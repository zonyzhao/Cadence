simulator( 'spectreVerilog )
design(	 "/net/kafka/nfs/rstdenis/Cadence/simulation/10T_TagMem_Test/spectreVerilog/config/netlist/analog/netlist")
resultsDir( "/net/kafka/nfs/rstdenis/Cadence/simulation/10T_TagMem_Test/spectreVerilog/config" )
modelFile(
    '("/software/cadence/ncsu-FreePDK15/hspice_16nm_hp.include" "")
)
analysis('tran ?stop "50n"  ?errpreset "conservative"
		?readic "/net/kafka/nfs/rstdenis/Cadence/simulation/10T_TagMem_Test/spectreVerilog/config/netlist/spectre.ic"
		?readns "/net/kafka/nfs/rstdenis/Cadence/simulation/10T_TagMem_Test/spectreVerilog/config/netlist/spectre.ic"
		)
desVar(	  "vdd" .500	)
desVar(	  "vcc" "vdd"	)
envOption(
	'mspSetupNetlistSimPrecisionUnit  "ps"
	'mspSetupNetlistSimTimeUnit  "ps"
	'mspSetupNetlistSwitchRC  t
	'analysisOrder  list("tran")
)
option(	'checklimitdest  ""
	'multithread  "on"
	'temp  "30.0"
)
saveOption( ?simOutputFormat "psfxl" )
save( 'i "/V1/MINUS" "/V0/MINUS" )
converge( 'ic "/ResetT" "0" )
converge( 'ic "/R_AddrT<0>" "0" )
converge( 'ic "/R_AddrT<1>" "0" )
converge( 'ic "/R_AddrT<2>" "0" )
converge( 'ic "/R_AddrT<3>" "0" )
converge( 'ic "/R_AddrT<4>" "0" )
converge( 'ic "/R_AddrT<5>" "0" )
converge( 'ic "/R_AddrT<6>" "0" )
converge( 'ic "/GoRT" "0" )
converge( 'ic "/W_AddrT<0>" "0" )
converge( 'ic "/W_AddrT<1>" "0" )
converge( 'ic "/W_AddrT<2>" "0" )
converge( 'ic "/W_AddrT<3>" "0" )
converge( 'ic "/W_AddrT<4>" "0" )
converge( 'ic "/W_AddrT<5>" "0" )
converge( 'ic "/W_AddrT<6>" "0" )
converge( 'ic "/GoWT" "0" )
converge( 'ic "/W1T<0>" "0" )
converge( 'ic "/W1T<1>" "0" )
converge( 'ic "/W1T<2>" "0" )
converge( 'ic "/W1T<3>" "0" )
converge( 'ic "/W1T<4>" "0" )
converge( 'ic "/W1T<5>" "0" )
converge( 'ic "/W1T<6>" "0" )
converge( 'ic "/W1T<7>" "0" )
converge( 'ic "/W1T<8>" "0" )
converge( 'ic "/W1T<9>" "0" )
converge( 'ic "/W1T<10>" "0" )
converge( 'ic "/W1T<11>" "0" )
converge( 'ic "/W1T<12>" "0" )
converge( 'ic "/W1T<13>" "0" )
converge( 'ic "/W1T<14>" "0" )
converge( 'ic "/W1T<15>" "0" )
converge( 'ic "/W1T<16>" "0" )
converge( 'ic "/W1T<17>" "0" )
converge( 'ic "/W1T<18>" "0" )
converge( 'ic "/W1T<19>" "0" )
converge( 'ic "/W1T<20>" "0" )
converge( 'ic "/W1T<21>" "0" )
converge( 'ic "/W1T<22>" "0" )
converge( 'ic "/W1T<23>" "0" )
converge( 'ic "/W1T<24>" "0" )
converge( 'ic "/W1T<25>" "0" )
converge( 'ic "/W1T<26>" "0" )
converge( 'ic "/W1T<27>" "0" )
converge( 'ic "/W1T<28>" "0" )
converge( 'ic "/W1T<29>" "0" )
converge( 'ic "/W1T<30>" "0" )
converge( 'ic "/W1T<31>" "0" )
converge( 'ic "/W0T<0>" "0" )
converge( 'ic "/W0T<1>" "0" )
converge( 'ic "/W0T<2>" "0" )
converge( 'ic "/W0T<3>" "0" )
converge( 'ic "/W0T<4>" "0" )
converge( 'ic "/W0T<5>" "0" )
converge( 'ic "/W0T<6>" "0" )
converge( 'ic "/W0T<7>" "0" )
converge( 'ic "/W0T<8>" "0" )
converge( 'ic "/W0T<9>" "0" )
converge( 'ic "/W0T<10>" "0" )
converge( 'ic "/W0T<11>" "0" )
converge( 'ic "/W0T<12>" "0" )
converge( 'ic "/W0T<13>" "0" )
converge( 'ic "/W0T<14>" "0" )
converge( 'ic "/W0T<15>" "0" )
converge( 'ic "/W0T<16>" "0" )
converge( 'ic "/W0T<17>" "0" )
converge( 'ic "/W0T<18>" "0" )
converge( 'ic "/W0T<19>" "0" )
converge( 'ic "/W0T<20>" "0" )
converge( 'ic "/W0T<21>" "0" )
converge( 'ic "/W0T<22>" "0" )
converge( 'ic "/W0T<23>" "0" )
converge( 'ic "/W0T<24>" "0" )
converge( 'ic "/W0T<25>" "0" )
converge( 'ic "/W0T<26>" "0" )
converge( 'ic "/W0T<27>" "0" )
converge( 'ic "/W0T<28>" "0" )
converge( 'ic "/W0T<29>" "0" )
converge( 'ic "/W0T<30>" "0" )
converge( 'ic "/W0T<31>" "0" )
converge( 'ic "/KWeT" "0" )
converge( 'ic "/KReT" "0" )
converge( 'ic "/R0T<0>" "0" )
converge( 'ic "/R0T<1>" "0" )
converge( 'ic "/R0T<2>" "0" )
converge( 'ic "/R0T<3>" "0" )
converge( 'ic "/R0T<4>" "0" )
converge( 'ic "/R0T<5>" "0" )
converge( 'ic "/R0T<6>" "0" )
converge( 'ic "/R0T<7>" "0" )
converge( 'ic "/R0T<8>" "0" )
converge( 'ic "/R0T<9>" "0" )
converge( 'ic "/R0T<10>" "0" )
converge( 'ic "/R0T<11>" "0" )
converge( 'ic "/R0T<12>" "0" )
converge( 'ic "/R0T<13>" "0" )
converge( 'ic "/R0T<14>" "0" )
converge( 'ic "/R0T<15>" "0" )
converge( 'ic "/R0T<16>" "0" )
converge( 'ic "/R0T<17>" "0" )
converge( 'ic "/R0T<18>" "0" )
converge( 'ic "/R0T<19>" "0" )
converge( 'ic "/R0T<20>" "0" )
converge( 'ic "/R0T<21>" "0" )
converge( 'ic "/R0T<22>" "0" )
converge( 'ic "/R0T<23>" "0" )
converge( 'ic "/R0T<24>" "0" )
converge( 'ic "/R0T<25>" "0" )
converge( 'ic "/R0T<26>" "0" )
converge( 'ic "/R0T<27>" "0" )
converge( 'ic "/R0T<28>" "0" )
converge( 'ic "/R0T<29>" "0" )
converge( 'ic "/R0T<30>" "0" )
converge( 'ic "/R0T<31>" "0" )
converge( 'ic "/R1T<0>" "0" )
converge( 'ic "/R1T<1>" "0" )
converge( 'ic "/R1T<2>" "0" )
converge( 'ic "/R1T<3>" "0" )
converge( 'ic "/R1T<4>" "0" )
converge( 'ic "/R1T<5>" "0" )
converge( 'ic "/R1T<6>" "0" )
converge( 'ic "/R1T<7>" "0" )
converge( 'ic "/R1T<8>" "0" )
converge( 'ic "/R1T<9>" "0" )
converge( 'ic "/R1T<10>" "0" )
converge( 'ic "/R1T<11>" "0" )
converge( 'ic "/R1T<12>" "0" )
converge( 'ic "/R1T<13>" "0" )
converge( 'ic "/R1T<14>" "0" )
converge( 'ic "/R1T<15>" "0" )
converge( 'ic "/R1T<16>" "0" )
converge( 'ic "/R1T<17>" "0" )
converge( 'ic "/R1T<18>" "0" )
converge( 'ic "/R1T<19>" "0" )
converge( 'ic "/R1T<20>" "0" )
converge( 'ic "/R1T<21>" "0" )
converge( 'ic "/R1T<22>" "0" )
converge( 'ic "/R1T<23>" "0" )
converge( 'ic "/R1T<24>" "0" )
converge( 'ic "/R1T<25>" "0" )
converge( 'ic "/R1T<26>" "0" )
converge( 'ic "/R1T<27>" "0" )
converge( 'ic "/R1T<28>" "0" )
converge( 'ic "/R1T<29>" "0" )
converge( 'ic "/R1T<30>" "0" )
converge( 'ic "/R1T<31>" "0" )
converge( 'ic "/I36/I0/I1/I7/I3/Qb" "0" )
converge( 'ic "/I36/I0/I1/I7/I3/Q" "vdd" )
temp( 30.0 )
run()
selectResult( 'tran )
plot(getData("/R_Addr<6:0>") getData("/GoR") getData("/R1<31:0>") getData("/R0<31:0>") getData("/R_Ack") getData("/W_Addr<6:0>") getData("/GoW") getData("/W1<31:0>") getData("/W0<31:0>") getData("/W_Ack") getData("/I36/I0/I1/I7/I3/Qb") getData("/I36/I0/I1/I7/I3/Q") getData("/I36/I0/~W0<0>") getData("/I36/I0/~R1<0>") getData("/I36/I0/~R0<0>") getData("/I36/I0/~W1<0>") getData("/V1/MINUS") getData("/V0/MINUS") getData("/vdd!") getData("/vcc!") )
