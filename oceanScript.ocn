;====================== Set to XL mode =========================================
ocnSetXLMode()
ocnxlProjectDir( "/net/kafka/nfs/rstdenis/Cadence/simulation" )
ocnxlTargetCellView( "16nm_Tests" "MCsetup_Test" "adexl" )
ocnxlResultsLocation( "" )
ocnxlSimResultsLocation( "" )

;====================== Tests setup ============================================

;---------- Test "16nm_Tests:MCsetup_Test:1" -------------
ocnxlBeginTest("16nm_Tests:MCsetup_Test:1")
simulator( 'spectre )
design( "16nm_Tests" "MCsetup_Test" "schematic")
modelFile(
    '("/root/Desktop/Cadence/ncsu-FreePDK15/hspice_16nm_hp.include" "")
    '("/root/Desktop/Cadence/ncsu-FreePDK15/PTM-MG/stats.scs" "")
)
analysis('tran ?stop "12n"  ?errpreset "conservative"  )
desVar(	  "time2" 5n	)
desVar(	  "vdd" .500	)
envOption(
	'cmd64bit  t
	'analysisOrder  list("tran" "pz" "dcmatch" "stb" "envlp" "ac" "dc" "lf" "noise" "xf" "sp" "pss" "pac" "pstb" "pnoise" "pxf" "psp" "qpss" "qpac" "qpnoise" "qpxf" "qpsp" "hb" "hbac" "hbnoise" "sens")
)
option(	'multithread  "on"
	'temp  "30.0"
)
save( 'v "/Y" )
save( 'i "/V0/MINUS" )
temp( 30.0 )
ocnxlOutputTerminal( "/V0/MINUS" ?plot t ?save t)
ocnxlOutputSignal( "/Y" ?plot t ?save t)
ocnxlOutputExpr( "pv(\"I0.M1.mpfet\" \"vth\" ?result \"tranOp\")" ?plot t ?save t)
ocnxlOutputExpr( "pv(\"I0.M0.mnfet\" \"vth\" ?result \"tranOp\")" ?plot t ?save t)
ocnxlEndTest() ; "16nm_Tests:MCsetup_Test:1"

;====================== Sweeps setup ===========================================
ocnxlSweepVar("time2" "5n")
ocnxlSweepVar("vdd" ".500")

;====================== Model Group setup ==========================================

;====================== Corners setup ==========================================

;====================== Job setup ==============================================
ocnxlJobSetup( '(
	"blockemail" "1"
	"configuretimeout" "300"
	"distributionmethod" "Local"
	"lingertimeout" "300"
	"maxjobs" "1"
	"name" "ADE XL Default"
	"preemptivestart" "1"
	"reconfigureimmediately" "1"
	"runtimeout" "-1"
	"showerrorwhenretrying" "1"
	"showoutputlogerror" "0"
	"startmaxjobsimmed" "1"
	"starttimeout" "300"
	"usesameprocess" "1"
) )

;====================== Disabled items =========================================

;====================== Run Mode Options ======================================
ocnxlMonteCarloOptions( ?dutSummary "16nm_Tests:MCsetup_Test:1%/I0/M0%nfet%Subcircuit#16nm_Tests:MCsetup_Test:1%/I0/M1%pfet%Subcircuit#" ?ignoreFlag "0" ?mcMethod "mismatch" ?mcNumPoints "200" ?mcNumBins "201" ?mcStopEarly "0" ?mcStopMethod "Significance Test" ?samplingMode "random" ?saveProcess "0" ?saveMismatch "1" ?useReference "0" ?donominal "1" ?saveAllPlots "1" ?monteCarloSeed "1" ?mcStartingRunNumber "1" ?dumpParamMode "yes" )

;====================== Starting Point Info ======================================

;====================== Run command ============================================
ocnxlRun( ?mode 'monteCarlo ?nominalCornerEnabled t ?allCornersEnabled t ?allSweepsEnabled t)
ocnxlOutputSummary(?yieldSummary t ?exprSummary nil ?specSummary nil ?detailed nil)
ocnxlOpenResults()

;====================== End XL Mode command ===================================
ocnxlEndXLMode()
