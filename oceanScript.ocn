simulator( 'spectreVerilog )
hostMode( 'distributed )
design(	 "/net/kafka/nfs/rstdenis/Cadence/simulation/6T_SDP_BANK_Test/spectreVerilog/config/netlist/analog/netlist")
resultsDir( "/net/kafka/nfs/rstdenis/Cadence/simulation/6T_SDP_BANK_Test/spectreVerilog/config" )
modelFile(
    '("/software/cadence/ncsu-FreePDK15/hspice_16nm_hp.include" "")
)
analysis('tran ?stop "50n"  ?errpreset "conservative"  )
desVar(	  "vdd" .650	)
desVar(	  "vcc" "vdd"	)
envOption(
	'mspSetupNetlistSimPrecisionUnit  "ps"
	'mspSetupNetlistSimTimeUnit  "ps"
	'mspSetupNetlistSwitchRC  t
	'analysisOrder  list("tran")
)
option(	'multithread  "on"
	'temp  "30.0"
)
saveOption( ?simOutputFormat "psfxl" )
save( 'v "/vdd!" )
save( 'i "/V1/MINUS" "/IBank/Write_Ack" "/IBank/Read_Ack" "/V0/MINUS" "/V0/PLUS" "/V1/PLUS" )
converge( 'ic "/IBank/I0/I0/I0/I0/I7/I3/Q0" "0" )
converge( 'ic "/IBank/I0/I0/I0/I0/I7/I3/Q1" "vdd" )
converge( 'ic "/WriteDataT<0>" "0" )
converge( 'ic "/WriteDataT<1>" "0" )
converge( 'ic "/WriteDataT<2>" "0" )
converge( 'ic "/WriteDataT<3>" "0" )
converge( 'ic "/WriteDataT<4>" "0" )
converge( 'ic "/WriteDataT<5>" "0" )
converge( 'ic "/WriteDataT<6>" "0" )
converge( 'ic "/WriteDataT<7>" "0" )
converge( 'ic "/WriteDataT<8>" "0" )
converge( 'ic "/WriteDataT<9>" "0" )
converge( 'ic "/WriteDataT<10>" "0" )
converge( 'ic "/WriteDataT<11>" "0" )
converge( 'ic "/WriteDataT<12>" "0" )
converge( 'ic "/WriteDataT<13>" "0" )
converge( 'ic "/WriteDataT<14>" "0" )
converge( 'ic "/WriteDataT<15>" "0" )
converge( 'ic "/WriteDataT<16>" "0" )
converge( 'ic "/WriteDataT<17>" "0" )
converge( 'ic "/WriteDataT<18>" "0" )
converge( 'ic "/WriteDataT<19>" "0" )
converge( 'ic "/WriteDataT<20>" "0" )
converge( 'ic "/WriteDataT<21>" "0" )
converge( 'ic "/WriteDataT<22>" "0" )
converge( 'ic "/WriteDataT<23>" "0" )
converge( 'ic "/WriteDataT<24>" "0" )
converge( 'ic "/WriteDataT<25>" "0" )
converge( 'ic "/WriteDataT<26>" "0" )
converge( 'ic "/WriteDataT<27>" "0" )
converge( 'ic "/WriteDataT<28>" "0" )
converge( 'ic "/WriteDataT<29>" "0" )
converge( 'ic "/WriteDataT<30>" "0" )
converge( 'ic "/WriteDataT<31>" "0" )
converge( 'ic "/W_AddressT<0>" "0" )
converge( 'ic "/W_AddressT<1>" "0" )
converge( 'ic "/W_AddressT<2>" "0" )
converge( 'ic "/W_AddressT<3>" "0" )
converge( 'ic "/W_AddressT<4>" "0" )
converge( 'ic "/W_AddressT<5>" "0" )
converge( 'ic "/W_AddressT<6>" "0" )
converge( 'ic "/W_AddressT<7>" "0" )
converge( 'ic "/W_AddressT<8>" "0" )
converge( 'ic "/W_AddressT<9>" "0" )
converge( 'ic "/W_AddressT<10>" "0" )
converge( 'ic "/W_AddressT<11>" "0" )
converge( 'ic "/W_AddressT<12>" "0" )
converge( 'ic "/W_AddressT<13>" "0" )
converge( 'ic "/W_AddressT<14>" "0" )
converge( 'ic "/W_AddressT<15>" "0" )
converge( 'ic "/W_AddressT<16>" "0" )
converge( 'ic "/W_AddressT<17>" "0" )
converge( 'ic "/W_AddressT<18>" "0" )
converge( 'ic "/W_AddressT<19>" "0" )
converge( 'ic "/WRWT<0>" "0" )
converge( 'ic "/WRWT<1>" "0" )
converge( 'ic "/RRWT<0>" "0" )
converge( 'ic "/RRWT<1>" "0" )
converge( 'ic "/R_AddressT<0>" "0" )
converge( 'ic "/R_AddressT<1>" "0" )
converge( 'ic "/R_AddressT<2>" "0" )
converge( 'ic "/R_AddressT<3>" "0" )
converge( 'ic "/R_AddressT<4>" "0" )
converge( 'ic "/R_AddressT<5>" "0" )
converge( 'ic "/R_AddressT<6>" "0" )
converge( 'ic "/R_AddressT<7>" "0" )
converge( 'ic "/R_AddressT<8>" "0" )
converge( 'ic "/R_AddressT<9>" "0" )
converge( 'ic "/R_AddressT<10>" "0" )
converge( 'ic "/R_AddressT<11>" "0" )
converge( 'ic "/R_AddressT<12>" "0" )
converge( 'ic "/R_AddressT<13>" "0" )
converge( 'ic "/R_AddressT<14>" "0" )
converge( 'ic "/R_AddressT<15>" "0" )
converge( 'ic "/R_AddressT<16>" "0" )
converge( 'ic "/R_AddressT<17>" "0" )
converge( 'ic "/R_AddressT<18>" "0" )
converge( 'ic "/R_AddressT<19>" "0" )
converge( 'ic "/RD_AckT<0>" "0" )
converge( 'ic "/RD_AckT<1>" "0" )
converge( 'ic "/RD_AckT<2>" "0" )
converge( 'ic "/RD_AckT<3>" "0" )
converge( 'ic "/RD_AckT<4>" "0" )
converge( 'ic "/RD_AckT<5>" "0" )
converge( 'ic "/RD_AckT<6>" "0" )
converge( 'ic "/RD_AckT<7>" "0" )
converge( 'ic "/~RD_Ack<7:0>" "vdd" )
converge( 'ic "/WD_AckT<0>" "0" )
converge( 'ic "/WD_AckT<1>" "0" )
converge( 'ic "/WD_AckT<2>" "0" )
converge( 'ic "/WD_AckT<3>" "0" )
converge( 'ic "/WD_AckT<4>" "0" )
converge( 'ic "/WD_AckT<5>" "0" )
converge( 'ic "/WD_AckT<6>" "0" )
converge( 'ic "/WD_AckT<7>" "0" )
converge( 'ic "/IBank/Ap<16>" "0" )
converge( 'ic "/IBank/Ap<17>" "0" )
converge( 'ic "/IBank/Ap<18>" "0" )
converge( 'ic "/IBank/Ap<19>" "0" )
converge( 'ic "/IBank/I1/I1/amid<0>" "0" )
converge( 'ic "/IBank/I1/I1/amid<1>" "0" )
converge( 'ic "/IBank/I1/I1/amid<2>" "0" )
converge( 'ic "/IBank/I1/I1/amid<3>" "0" )
converge( 'ic "/IBank/I1/I1/bmid<0>" "0" )
converge( 'ic "/IBank/I1/I1/bmid<1>" "0" )
converge( 'ic "/IBank/I1/I1/bmid<3>" "0" )
converge( 'ic "/IBank/I1/I1/bmid<2>" "0" )
converge( 'ic "/IBank/I1/I1/Vpass<3>" "0" )
converge( 'ic "/IBank/I1/I1/Vpass<2>" "0" )
converge( 'ic "/IBank/I1/I1/Vpass<1>" "0" )
converge( 'ic "/IBank/I1/I1/Vpass<0>" "0" )
converge( 'ic "/IBank/I1/I3/net26" "0" )
converge( 'ic "/IBank/I1/I3/net28" "0" )
converge( 'ic "/IBank/I1/I3/net29" "0" )
converge( 'ic "/IBank/I1/I3/net31" "0" )
converge( 'ic "/IBank/WRWp<0>" "0" )
converge( 'ic "/IBank/WRWp<1>" "0" )
converge( 'ic "/IBank/Ap<0>" "0" )
converge( 'ic "/IBank/Ap<1>" "0" )
converge( 'ic "/IBank/Ap<2>" "0" )
converge( 'ic "/IBank/Ap<3>" "0" )
converge( 'ic "/IBank/Ap<4>" "0" )
converge( 'ic "/IBank/Ap<5>" "0" )
converge( 'ic "/IBank/Ap<6>" "0" )
converge( 'ic "/IBank/Ap<7>" "0" )
converge( 'ic "/IBank/Ap<8>" "0" )
converge( 'ic "/IBank/Ap<9>" "0" )
converge( 'ic "/IBank/Ap<10>" "0" )
converge( 'ic "/IBank/Ap<11>" "0" )
converge( 'ic "/IBank/Ap<12>" "0" )
converge( 'ic "/IBank/Ap<13>" "0" )
converge( 'ic "/IBank/Ap<14>" "0" )
converge( 'ic "/IBank/Ap<15>" "0" )
temp( 30.0 )
run( ?jobName "job" ?queue "c2107" )
selectResult( 'tran )
plot(getData("/IBank/I0/I0/I0/B0P1") getData("/IBank/I0/I0/I0/B1P1") getData("/IBank/I0/I0/I0/I0/I7/I3/Q0") getData("/IBank/I0/I0/I0/I0/I7/I3/Q1") getData("/IBank/Ap<0>") getData("/IBank/Ap<10>") getData("/IBank/Ap<11>") getData("/IBank/Ap<12>") getData("/IBank/Ap<13>") getData("/IBank/Ap<14>") getData("/IBank/Ap<15>") getData("/IBank/Ap<16>") getData("/IBank/Ap<17>") getData("/IBank/Ap<18>") getData("/IBank/Ap<19>") getData("/IBank/Ap<1>") getData("/IBank/Ap<2>") getData("/IBank/Ap<3>") getData("/IBank/Ap<4>") getData("/IBank/Ap<5>") getData("/IBank/Ap<6>") getData("/IBank/Ap<7>") getData("/IBank/Ap<8>") getData("/IBank/Ap<9>") getData("/IBank/I1/I1/Vpass<0>") getData("/IBank/I1/I1/Vpass<1>") getData("/IBank/I1/I1/Vpass<2>") getData("/IBank/I1/I1/Vpass<3>") getData("/IBank/I1/I1/amid<0>") getData("/IBank/I1/I1/amid<1>") getData("/IBank/I1/I1/amid<2>") getData("/IBank/I1/I1/amid<3>") getData("/IBank/I1/I1/bmid<0>") getData("/IBank/I1/I1/bmid<1>") getData("/IBank/I1/I1/bmid<2>") getData("/IBank/I1/I1/bmid<3>") getData("/IBank/WAck") getData("/IBank/WAckp<0>") getData("/IBank/WAckp<1>") getData("/IBank/WAckp<2>") getData("/IBank/WAckp<3>") getData("/IBank/WAckp<4>") getData("/IBank/WRWp<0>") getData("/IBank/WRWp<1>") getData("/RA_Ack<4:0>") getData("/RA_AckT<0>") getData("/RA_AckT<1>") getData("/RA_AckT<2>") getData("/RA_AckT<3>") getData("/RA_AckT<4>") getData("/RD_Ack<7:0>") getData("/RD_AckT<0>") getData("/RD_AckT<1>") getData("/RD_AckT<2>") getData("/RD_AckT<3>") getData("/RD_AckT<4>") getData("/RD_AckT<5>") getData("/RD_AckT<6>") getData("/RD_AckT<7>") getData("/RRW<1:0>") getData("/RRWT<0>") getData("/RRWT<1>") getData("/R_Address<19:0>") getData("/R_AddressT<0>") getData("/R_AddressT<10>") getData("/R_AddressT<11>") getData("/R_AddressT<12>") getData("/R_AddressT<13>") getData("/R_AddressT<14>") getData("/R_AddressT<15>") getData("/R_AddressT<16>") getData("/R_AddressT<17>") getData("/R_AddressT<18>") getData("/R_AddressT<19>") getData("/R_AddressT<1>") getData("/R_AddressT<2>") getData("/R_AddressT<3>") getData("/R_AddressT<4>") getData("/R_AddressT<5>") getData("/R_AddressT<6>") getData("/R_AddressT<7>") getData("/R_AddressT<8>") getData("/R_AddressT<9>") getData("/ReadAck") getData("/ReadAckT") getData("/ReadData<31:0>") getData("/ReadDataT<0>") getData("/ReadDataT<10>") getData("/ReadDataT<11>") getData("/ReadDataT<12>") getData("/ReadDataT<13>") getData("/ReadDataT<14>") getData("/ReadDataT<15>") getData("/ReadDataT<16>") getData("/ReadDataT<17>") getData("/ReadDataT<18>") getData("/ReadDataT<19>") getData("/ReadDataT<1>") getData("/ReadDataT<20>") getData("/ReadDataT<21>") getData("/ReadDataT<22>") getData("/ReadDataT<23>") getData("/ReadDataT<24>") getData("/ReadDataT<25>") getData("/ReadDataT<26>") getData("/ReadDataT<27>") getData("/ReadDataT<28>") getData("/ReadDataT<29>") getData("/ReadDataT<2>") getData("/ReadDataT<30>") getData("/ReadDataT<31>") getData("/ReadDataT<3>") getData("/ReadDataT<4>") getData("/ReadDataT<5>") getData("/ReadDataT<6>") getData("/ReadDataT<7>") getData("/ReadDataT<8>") getData("/ReadDataT<9>") getData("/V1/MINUS") getData("/WA_Ack<4:0>") getData("/WA_AckT<0>") getData("/WA_AckT<1>") getData("/WA_AckT<2>") getData("/WA_AckT<3>") getData("/WA_AckT<4>") getData("/WD_Ack<7:0>") getData("/WD_AckT<0>") getData("/WD_AckT<1>") getData("/WD_AckT<2>") getData("/WD_AckT<3>") getData("/WD_AckT<4>") getData("/WD_AckT<5>") getData("/WD_AckT<6>") getData("/WD_AckT<7>") getData("/WRW<1:0>") getData("/WRWT<0>") getData("/WRWT<1>") getData("/W_Address<19:0>") getData("/W_AddressT<0>") getData("/W_AddressT<10>") getData("/W_AddressT<11>") getData("/W_AddressT<12>") getData("/W_AddressT<13>") getData("/W_AddressT<14>") getData("/W_AddressT<15>") getData("/W_AddressT<16>") getData("/W_AddressT<17>") getData("/W_AddressT<18>") getData("/W_AddressT<19>") getData("/W_AddressT<1>") getData("/W_AddressT<2>") getData("/W_AddressT<3>") getData("/W_AddressT<4>") getData("/W_AddressT<5>") getData("/W_AddressT<6>") getData("/W_AddressT<7>") getData("/W_AddressT<8>") getData("/W_AddressT<9>") getData("/WriteAck") getData("/WriteAckT") getData("/WriteData<31:0>") getData("/WriteDataT<0>") getData("/WriteDataT<10>") getData("/WriteDataT<11>") getData("/WriteDataT<12>") getData("/WriteDataT<13>") getData("/WriteDataT<14>") getData("/WriteDataT<15>") getData("/WriteDataT<16>") getData("/WriteDataT<17>") getData("/WriteDataT<18>") getData("/WriteDataT<19>") getData("/WriteDataT<1>") getData("/WriteDataT<20>") getData("/WriteDataT<21>") getData("/WriteDataT<22>") getData("/WriteDataT<23>") getData("/WriteDataT<24>") getData("/WriteDataT<25>") getData("/WriteDataT<26>") getData("/WriteDataT<27>") getData("/WriteDataT<28>") getData("/WriteDataT<29>") getData("/WriteDataT<2>") getData("/WriteDataT<30>") getData("/WriteDataT<31>") getData("/WriteDataT<3>") getData("/WriteDataT<4>") getData("/WriteDataT<5>") getData("/WriteDataT<6>") getData("/WriteDataT<7>") getData("/WriteDataT<8>") getData("/WriteDataT<9>") getData("/IBank/Write_Ack") getData("/IBank/Read_Ack") getData("/vdd!") getData("/V0/MINUS") getData("/V0/PLUS") getData("/V1/PLUS") )
