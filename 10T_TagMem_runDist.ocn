simulator( 'spectreVerilog )
design(	 "/net/kafka/nfs/rstdenis/Cadence/simulation/10T_TagMem_Test/spectreVerilog/config/netlist/analog/netlist")
resultsDir( "/net/kafka/nfs/rstdenis/Cadence/simulation/10T_TagMem_Test/spectreVerilog/config" )
modelFile(
    '("/software/cadence/ncsu-FreePDK15/hspice_16nm_hp.include" "")
)
analysis('tran ?stop "500n"  ?errpreset "conservative"
		)
desVar(	  "vdd" .500	)
desVar(	  "vcc" "vdd"	)
envOption(
	'mspSetupNetlistSimPrecisionUnit  "ps"
	'mspSetupNetlistSimTimeUnit  "ps"
	'mspSetupNetlistSwitchRC  t
	'analysisOrder  list("tran")
)
option(	'checklimitdest  ""
	'multithread  "on"
	'temp  "30.0"
)
saveOption( ?simOutputFormat "psfxl" )
save( 'i "/V1/MINUS" "/V0/MINUS" )
converge( 'ic "/ResetT" "0" )
converge( 'ic "/R_AddrT<0>" "0" )
converge( 'ic "/R_AddrT<1>" "0" )
converge( 'ic "/R_AddrT<2>" "0" )
converge( 'ic "/R_AddrT<3>" "0" )
converge( 'ic "/R_AddrT<4>" "0" )
converge( 'ic "/R_AddrT<5>" "0" )
converge( 'ic "/R_AddrT<6>" "0" )
converge( 'ic "/GoRT" "0" )
converge( 'ic "/W_AddrT<0>" "0" )
converge( 'ic "/W_AddrT<1>" "0" )
converge( 'ic "/W_AddrT<2>" "0" )
converge( 'ic "/W_AddrT<3>" "0" )
converge( 'ic "/W_AddrT<4>" "0" )
converge( 'ic "/W_AddrT<5>" "0" )
converge( 'ic "/W_AddrT<6>" "0" )
converge( 'ic "/GoWT" "0" )
converge( 'ic "/W1T<0>" "0" )
converge( 'ic "/W1T<1>" "0" )
converge( 'ic "/W1T<2>" "0" )
converge( 'ic "/W1T<3>" "0" )
converge( 'ic "/W1T<4>" "0" )
converge( 'ic "/W1T<5>" "0" )
converge( 'ic "/W1T<6>" "0" )
converge( 'ic "/W1T<7>" "0" )
converge( 'ic "/W1T<8>" "0" )
converge( 'ic "/W1T<9>" "0" )
converge( 'ic "/W1T<10>" "0" )
converge( 'ic "/W1T<11>" "0" )
converge( 'ic "/W1T<12>" "0" )
converge( 'ic "/W1T<13>" "0" )
converge( 'ic "/W1T<14>" "0" )
converge( 'ic "/W1T<15>" "0" )
converge( 'ic "/W1T<16>" "0" )
converge( 'ic "/W1T<17>" "0" )
converge( 'ic "/W1T<18>" "0" )
converge( 'ic "/W1T<19>" "0" )
converge( 'ic "/W1T<20>" "0" )
converge( 'ic "/W1T<21>" "0" )
converge( 'ic "/W1T<22>" "0" )
converge( 'ic "/W1T<23>" "0" )
converge( 'ic "/W1T<24>" "0" )
converge( 'ic "/W1T<25>" "0" )
converge( 'ic "/W1T<26>" "0" )
converge( 'ic "/W1T<27>" "0" )
converge( 'ic "/W1T<28>" "0" )
converge( 'ic "/W1T<29>" "0" )
converge( 'ic "/W1T<30>" "0" )
converge( 'ic "/W1T<31>" "0" )
converge( 'ic "/W0T<0>" "0" )
converge( 'ic "/W0T<1>" "0" )
converge( 'ic "/W0T<2>" "0" )
converge( 'ic "/W0T<3>" "0" )
converge( 'ic "/W0T<4>" "0" )
converge( 'ic "/W0T<5>" "0" )
converge( 'ic "/W0T<6>" "0" )
converge( 'ic "/W0T<7>" "0" )
converge( 'ic "/W0T<8>" "0" )
converge( 'ic "/W0T<9>" "0" )
converge( 'ic "/W0T<10>" "0" )
converge( 'ic "/W0T<11>" "0" )
converge( 'ic "/W0T<12>" "0" )
converge( 'ic "/W0T<13>" "0" )
converge( 'ic "/W0T<14>" "0" )
converge( 'ic "/W0T<15>" "0" )
converge( 'ic "/W0T<16>" "0" )
converge( 'ic "/W0T<17>" "0" )
converge( 'ic "/W0T<18>" "0" )
converge( 'ic "/W0T<19>" "0" )
converge( 'ic "/W0T<20>" "0" )
converge( 'ic "/W0T<21>" "0" )
converge( 'ic "/W0T<22>" "0" )
converge( 'ic "/W0T<23>" "0" )
converge( 'ic "/W0T<24>" "0" )
converge( 'ic "/W0T<25>" "0" )
converge( 'ic "/W0T<26>" "0" )
converge( 'ic "/W0T<27>" "0" )
converge( 'ic "/W0T<28>" "0" )
converge( 'ic "/W0T<29>" "0" )
converge( 'ic "/W0T<30>" "0" )
converge( 'ic "/W0T<31>" "0" )
converge( 'ic "/KWeT" "0" )
converge( 'ic "/KReT" "0" )
converge( 'ic "/R0T<0>" "0" )
converge( 'ic "/R0T<1>" "0" )
converge( 'ic "/R0T<2>" "0" )
converge( 'ic "/R0T<3>" "0" )
converge( 'ic "/R0T<4>" "0" )
converge( 'ic "/R0T<5>" "0" )
converge( 'ic "/R0T<6>" "0" )
converge( 'ic "/R0T<7>" "0" )
converge( 'ic "/R0T<8>" "0" )
converge( 'ic "/R0T<9>" "0" )
converge( 'ic "/R0T<10>" "0" )
converge( 'ic "/R0T<11>" "0" )
converge( 'ic "/R0T<12>" "0" )
converge( 'ic "/R0T<13>" "0" )
converge( 'ic "/R0T<14>" "0" )
converge( 'ic "/R0T<15>" "0" )
converge( 'ic "/R0T<16>" "0" )
converge( 'ic "/R0T<17>" "0" )
converge( 'ic "/R0T<18>" "0" )
converge( 'ic "/R0T<19>" "0" )
converge( 'ic "/R0T<20>" "0" )
converge( 'ic "/R0T<21>" "0" )
converge( 'ic "/R0T<22>" "0" )
converge( 'ic "/R0T<23>" "0" )
converge( 'ic "/R0T<24>" "0" )
converge( 'ic "/R0T<25>" "0" )
converge( 'ic "/R0T<26>" "0" )
converge( 'ic "/R0T<27>" "0" )
converge( 'ic "/R0T<28>" "0" )
converge( 'ic "/R0T<29>" "0" )
converge( 'ic "/R0T<30>" "0" )
converge( 'ic "/R0T<31>" "0" )
converge( 'ic "/R1T<0>" "0" )
converge( 'ic "/R1T<1>" "0" )
converge( 'ic "/R1T<2>" "0" )
converge( 'ic "/R1T<3>" "0" )
converge( 'ic "/R1T<4>" "0" )
converge( 'ic "/R1T<5>" "0" )
converge( 'ic "/R1T<6>" "0" )
converge( 'ic "/R1T<7>" "0" )
converge( 'ic "/R1T<8>" "0" )
converge( 'ic "/R1T<9>" "0" )
converge( 'ic "/R1T<10>" "0" )
converge( 'ic "/R1T<11>" "0" )
converge( 'ic "/R1T<12>" "0" )
converge( 'ic "/R1T<13>" "0" )
converge( 'ic "/R1T<14>" "0" )
converge( 'ic "/R1T<15>" "0" )
converge( 'ic "/R1T<16>" "0" )
converge( 'ic "/R1T<17>" "0" )
converge( 'ic "/R1T<18>" "0" )
converge( 'ic "/R1T<19>" "0" )
converge( 'ic "/R1T<20>" "0" )
converge( 'ic "/R1T<21>" "0" )
converge( 'ic "/R1T<22>" "0" )
converge( 'ic "/R1T<23>" "0" )
converge( 'ic "/R1T<24>" "0" )
converge( 'ic "/R1T<25>" "0" )
converge( 'ic "/R1T<26>" "0" )
converge( 'ic "/R1T<27>" "0" )
converge( 'ic "/R1T<28>" "0" )
converge( 'ic "/R1T<29>" "0" )
converge( 'ic "/R1T<30>" "0" )
converge( 'ic "/R1T<31>" "0" )
converge( 'ic "/I36/I0/I1/I7/I3/Qb" "0" )
converge( 'ic "/I36/I0/I1/I7/I3/Q" "vdd" )
temp( 30.0 )

;;;;;;;;;;;;;;;;;;;;;;;;;;;;;;;;;;;;;;;;;;;;;;;;;;;;;;;;;;
;hList = 	list( "adder" "asp" "blind" "boa" "boom" "brown" \
;		      "cobra"  "copper" "coral" "corn" "crowned" \
;		      "deathadder" "fierce" "garter" "gopher" 	 \
;		      "hognose" "indigo" "krait" "mamba" "milk"  \
;		      "python" "queen" "racer" "rainbow" "rat" 	 \
;		      "rattle" "redbelly" "ribbon" "scarlet" 	 \
;		      "swamp" "timber" "viper" )

hList = list( "asp" "boa" "boom" "brown" "cobra"  "copper" "coral" "corn" "crowned" "deathadder" "fierce" "garter" "gopher" "hognose" "indigo" "krait" "mamba" "milk" "python" "queen" "racer" "rainbow" "rat" "rattle" "redbelly" "ribbon" "scarlet" "swamp" "timber" "viper" )

;vLoad = list(  .250 .325 0.45 .475 .50 .525 .675 .85 1.0 1.125 )
;vLoad = list( .195 .480 .485 .490 .495 .50 .505 .510 1.3 )
vLoad = list(   .125 .150 .175 .200 .250 .275 .300 .325 .350 .400 .450 .475 .500 .525 .550 .650 .750 .850 .950 1.0 1.050 1.075 1.10 1.125 1.150 1.175 1.20 1.25 )
;tLoad = list( 30 60 90 )
tLoad = list( 90 )

jobList 	= nil
mVs   		= nil
temps   	= nil
j=1
foreach( degC  tLoad
    foreach( val  vLoad
	desVar( "vdd" val )
	temp(degC)

	volt    = round( evalstring( desVar( "vdd" )) * 1000 )
	mVs     = append1( mVs sprintf( nil "%d" volt ))
	temps   = append1( temps sprintf(nil "%d" degC ))

;;;;;;;;;;;;;;;;;;;;;;;;;;;;;;;;;;;;;;;;;;;;;;;;;;;;;;;;;;;;;;;;;;;;;;;;;;;;;;;;;;;;;;;;;;;;;;;;;;;;
	jobName = strcat("TagMem_"  sprintf( nil "%d" volt ) "mV_" sprintf( nil "%d" degC) "C" )
	jobList = append1( jobList run( ?jobName jobName ?queue "c2107" ?host nthelem(j hList) ) )
;;;;;;;;;;;;;;;;;;;;;;;;;;;;;;;;;;;;;;;;;;;;;;;;;;;;;;;;;;;;;;;;;;;;;;;;;;;;;;;;;;;;;;;;;;;;;;;;;;;;

	j = j + 1
    )
)

printf("Completed.")
