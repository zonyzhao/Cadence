simulator( 'spectre )
hostMode( 'distributed )
design(	 "/net/kafka/nfs/rstdenis/Cadence/simulation/Dual_Supply_Word_Test/spectre/schematic/netlist/netlist")
resultsDir( "/net/kafka/nfs/rstdenis/Cadence/simulation/Dual_Supply_Word_Test/spectre/schematic" )
modelFile(
    '("/software/cadence/ncsu-FreePDK15/hspice_20nm_hp.include" "")
)
analysis('tran ?stop "VAR(\"timeStop\")"  ?errpreset "conservative"  )
desVar(	  "nfin" 12	)
desVar(	  "VDDH" .600	)
desVar(	  "VDDL" .450	)
desVar(	  "period" 6n	)
desVar(	  "C" 26.374f	)
desVar(	  "pulseWidth" "period/2"	)
desVar(	  "startDelay" "period/2"	)
desVar(	  "timeStop" "3*period"	)
envOption(
	'cmd64bit  t
	'analysisOrder  list("tran")
)
option(	'multithread  "on"
)
save( 'v "/VH" "/VL" "/Vline" )
save( 'i "/ILine/src" "/IVDDH/src" "/IVDDL/dst" )
converge( 'ic "/net035" "0" )
converge( 'ic "/sH" "VDDH" )
converge( 'ic "/VH" "VDDH" )
converge( 'ic "/VL" "0" )
converge( 'ic "/I33/I7/I3/Q0" "0" )
converge( 'ic "/I33/I7/I3/Q1" "VDDL" )
temp( 27 )
;paramAnalysis("nfin" ?values '(1 2 3 4 5 6 7 8 9 10 11 12 13 14 15 16 17 18 19 20 21 22 23 24 25 26 27 28 29 30 ))
;paramRun( ?jobName "job" ?queue "c2107" )
selectResult( 'tran )

vDiff = (VAR("VDDH") - VAR("VDDL"))
cVH = clip(v("/VH" ?result "tran") clipStart (VAR("timeStop") - (0.75 * VAR("period"))))
cVL = clip(v("/VL" ?result "tran") clipStart (VAR("timeStop") - (0.75 * VAR("period"))))
cVline = clip(v("/Vline" ?result "tran") clipStart (VAR("timeStop") - (0.75 * VAR("period"))))
clipStart = ((0.75 * VAR("period")) + VAR("startDelay"))

iPwr=i("/IVDDL/dst" ?result "tran") * v("/Vline" ?result "tran")
iPwr2=i("/IVDDH/src" ?result "tran") * v("/Vline" ?result "tran")
tFallSettleEnd 		= cross(cVline 1.05*VAR("VDDL") 1 "falling")
tFallSettleStart 	= xmin(intersect(cVH cVL))
tFallEnd 			= cross(cVline (VAR("VDDH") - (0.9 * vDiff)) 1 "falling")
tFallStart 			= cross(cVline (VAR("VDDH") - (0.1 * vDiff)) 1 "falling")
tRiseEnd 			= cross(cVline (VAR("VDDL") + (0.9 * vDiff)) 1 "rising")
tRiseStart 			= cross(cVline (VAR("VDDL") + (0.1 * vDiff)) 1 "rising")

tRiseSettleEnd 		= cross(cVline (0.95 * VAR("VDDH")) 1 "rising")
tRiseSettleStart 	= xmax(intersect(cVH cVL))
tTPRiseEnd 			= cross(cVline (VAR("VDDL") + (0.5 * vDiff)) 1 "rising")
tTPFallEnd 			= cross(cVline (VAR("VDDH") - (0.5 * vDiff)) 1 "falling")
TSettleFall 		= (tFallSettleEnd - tFallSettleStart)
TSettleRise 		= (tRiseSettleEnd - tRiseSettleStart)

TFall 			= (tFallEnd - tFallStart)
TPFall 			= (tTPFallEnd - tFallSettleStart)
TPRise 			= (tTPRiseEnd - tRiseSettleStart)
TRise 			= (tRiseEnd - tRiseStart)
EFall 	= ymax( iinteg( clip( iPwr tFallSettleStart tFallSettleEnd )))
ERise 	= ymax( iinteg( clip( iPwr2 tRiseSettleStart tRiseSettleEnd )))

tLeakageStart 	= (clipStart + (0.40 * VAR("period")))
tLeakageEnd 	= (clipStart + (0.60 * VAR("period")))
LeakageIntoVDDL = average(clip(i("/IVDDL/dst" ?result "tran") tLeakageStart tLeakageEnd))
LeakageLine 	= average(clip(i("/ILine/src" ?result "tran") tLeakageStart tLeakageEnd))
LeakageVDDH 	= average(clip(i("/IVDDH/src" ?result "tran") tLeakageStart tLeakageEnd))

file  =  strcat(  "/root/Desktop/"  "DualSupplyResults.matlab"  )
out   = outfile(file, "w")
ocnPrint(?output out TSettleRise TSettleFall TRise TFall TPRise TPFall ERise EFall LeakageVDDH  LeakageLine  LeakageIntoVDDL ?precision 16  ?numSpaces 1 ?numberNotation 'scientific)
printf("Completed.")
