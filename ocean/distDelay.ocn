simulator( 'spectreVerilog )
hostMode( 'distributed )
design(	 "/net/bull/root/Desktop/Cadence/simulation/Martin32_Test/spectreVerilog/config/netlist/analog/netlist")
resultsDir( "/net/bull/root/Desktop/Cadence/simulation/Martin32_Test/spectreVerilog/config" )
modelFile(
    '("/project/ncsu-FreePDK15/hspice_16nm_lstp.include" "")
)
analysis('tran ?stop "1000n"  ?errpreset "conservative"  )
envOption(
	'mspSetupNetlistSimPrecisionUnit  "ps"
	'mspSetupNetlistSimTimeUnit  "ps"
	'mspSetupNetlistOverWriteSchTimeScale  t
	'mspSetupNetlistDeclareGlobalLocally  t
	'mspSetupNetlistSwitchRC  t
	'analysisOrder  list("tran")
)
saveOption( ?simOutputFormat "psfxl" )
;save( 'i "/V1/MINUS" )
converge( 'ic "/afT<0>" "0" )
converge( 'ic "/afT<1>" "0" )
converge( 'ic "/afT<2>" "0" )
converge( 'ic "/afT<3>" "0" )
converge( 'ic "/afT<4>" "0" )
converge( 'ic "/afT<5>" "0" )
converge( 'ic "/afT<6>" "0" )
converge( 'ic "/afT<7>" "0" )
converge( 'ic "/afT<8>" "0" )
converge( 'ic "/afT<9>" "0" )
converge( 'ic "/afT<10>" "0" )
converge( 'ic "/afT<11>" "0" )
converge( 'ic "/afT<12>" "0" )
converge( 'ic "/afT<13>" "0" )
converge( 'ic "/afT<14>" "0" )
converge( 'ic "/afT<15>" "0" )
converge( 'ic "/afT<16>" "0" )
converge( 'ic "/afT<17>" "0" )
converge( 'ic "/afT<18>" "0" )
converge( 'ic "/afT<19>" "0" )
converge( 'ic "/afT<20>" "0" )
converge( 'ic "/afT<21>" "0" )
converge( 'ic "/afT<22>" "0" )
converge( 'ic "/afT<23>" "0" )
converge( 'ic "/afT<24>" "0" )
converge( 'ic "/afT<25>" "0" )
converge( 'ic "/afT<26>" "0" )
converge( 'ic "/afT<27>" "0" )
converge( 'ic "/afT<28>" "0" )
converge( 'ic "/afT<29>" "0" )
converge( 'ic "/afT<30>" "0" )
converge( 'ic "/afT<31>" "0" )
converge( 'ic "/atT<0>" "0" )
converge( 'ic "/atT<1>" "0" )
converge( 'ic "/atT<2>" "0" )
converge( 'ic "/atT<3>" "0" )
converge( 'ic "/atT<4>" "0" )
converge( 'ic "/atT<5>" "0" )
converge( 'ic "/atT<6>" "0" )
converge( 'ic "/atT<7>" "0" )
converge( 'ic "/atT<8>" "0" )
converge( 'ic "/atT<9>" "0" )
converge( 'ic "/atT<10>" "0" )
converge( 'ic "/atT<11>" "0" )
converge( 'ic "/atT<12>" "0" )
converge( 'ic "/atT<13>" "0" )
converge( 'ic "/atT<14>" "0" )
converge( 'ic "/atT<15>" "0" )
converge( 'ic "/atT<16>" "0" )
converge( 'ic "/atT<17>" "0" )
converge( 'ic "/atT<18>" "0" )
converge( 'ic "/atT<19>" "0" )
converge( 'ic "/atT<20>" "0" )
converge( 'ic "/atT<21>" "0" )
converge( 'ic "/atT<22>" "0" )
converge( 'ic "/atT<23>" "0" )
converge( 'ic "/atT<24>" "0" )
converge( 'ic "/atT<25>" "0" )
converge( 'ic "/atT<26>" "0" )
converge( 'ic "/atT<27>" "0" )
converge( 'ic "/atT<28>" "0" )
converge( 'ic "/atT<29>" "0" )
converge( 'ic "/atT<30>" "0" )
converge( 'ic "/atT<31>" "0" )
converge( 'ic "/bfT<0>" "0" )
converge( 'ic "/bfT<1>" "0" )
converge( 'ic "/bfT<2>" "0" )
converge( 'ic "/bfT<3>" "0" )
converge( 'ic "/bfT<4>" "0" )
converge( 'ic "/bfT<5>" "0" )
converge( 'ic "/bfT<6>" "0" )
converge( 'ic "/bfT<7>" "0" )
converge( 'ic "/bfT<8>" "0" )
converge( 'ic "/bfT<9>" "0" )
converge( 'ic "/bfT<10>" "0" )
converge( 'ic "/bfT<11>" "0" )
converge( 'ic "/bfT<12>" "0" )
converge( 'ic "/bfT<13>" "0" )
converge( 'ic "/bfT<14>" "0" )
converge( 'ic "/bfT<15>" "0" )
converge( 'ic "/bfT<16>" "0" )
converge( 'ic "/bfT<17>" "0" )
converge( 'ic "/bfT<18>" "0" )
converge( 'ic "/bfT<19>" "0" )
converge( 'ic "/bfT<20>" "0" )
converge( 'ic "/bfT<21>" "0" )
converge( 'ic "/bfT<22>" "0" )
converge( 'ic "/bfT<23>" "0" )
converge( 'ic "/bfT<24>" "0" )
converge( 'ic "/bfT<25>" "0" )
converge( 'ic "/bfT<26>" "0" )
converge( 'ic "/bfT<27>" "0" )
converge( 'ic "/bfT<28>" "0" )
converge( 'ic "/bfT<29>" "0" )
converge( 'ic "/bfT<30>" "0" )
converge( 'ic "/bfT<31>" "0" )
converge( 'ic "/btT<0>" "0" )
converge( 'ic "/btT<1>" "0" )
converge( 'ic "/btT<2>" "0" )
converge( 'ic "/btT<3>" "0" )
converge( 'ic "/btT<4>" "0" )
converge( 'ic "/btT<5>" "0" )
converge( 'ic "/btT<6>" "0" )
converge( 'ic "/btT<7>" "0" )
converge( 'ic "/btT<8>" "0" )
converge( 'ic "/btT<9>" "0" )
converge( 'ic "/btT<10>" "0" )
converge( 'ic "/btT<11>" "0" )
converge( 'ic "/btT<12>" "0" )
converge( 'ic "/btT<13>" "0" )
converge( 'ic "/btT<14>" "0" )
converge( 'ic "/btT<15>" "0" )
converge( 'ic "/btT<16>" "0" )
converge( 'ic "/btT<17>" "0" )
converge( 'ic "/btT<18>" "0" )
converge( 'ic "/btT<19>" "0" )
converge( 'ic "/btT<20>" "0" )
converge( 'ic "/btT<21>" "0" )
converge( 'ic "/btT<22>" "0" )
converge( 'ic "/btT<23>" "0" )
converge( 'ic "/btT<24>" "0" )
converge( 'ic "/btT<25>" "0" )
converge( 'ic "/btT<26>" "0" )
converge( 'ic "/btT<27>" "0" )
converge( 'ic "/btT<28>" "0" )
converge( 'ic "/btT<29>" "0" )
converge( 'ic "/btT<30>" "0" )
converge( 'ic "/btT<31>" "0" )
converge( 'ic "/ctT" "0" )
converge( 'ic "/cfT" "0" )
converge( 'ic "/dtT" "0" )
converge( 'ic "/dfT" "0" )
converge( 'ic "/dt" "0" )
converge( 'ic "/df" "0" )
converge( 'ic "/sfT<0>" "0" )
converge( 'ic "/sfT<1>" "0" )
converge( 'ic "/sfT<2>" "0" )
converge( 'ic "/sfT<3>" "0" )
converge( 'ic "/sfT<4>" "0" )
converge( 'ic "/sfT<5>" "0" )
converge( 'ic "/sfT<6>" "0" )
converge( 'ic "/sfT<7>" "0" )
converge( 'ic "/sfT<8>" "0" )
converge( 'ic "/sfT<9>" "0" )
converge( 'ic "/sfT<10>" "0" )
converge( 'ic "/sfT<11>" "0" )
converge( 'ic "/sfT<12>" "0" )
converge( 'ic "/sfT<13>" "0" )
converge( 'ic "/sfT<14>" "0" )
converge( 'ic "/sfT<15>" "0" )
converge( 'ic "/sfT<16>" "0" )
converge( 'ic "/sfT<17>" "0" )
converge( 'ic "/sfT<18>" "0" )
converge( 'ic "/sfT<19>" "0" )
converge( 'ic "/sfT<20>" "0" )
converge( 'ic "/sfT<21>" "0" )
converge( 'ic "/sfT<22>" "0" )
converge( 'ic "/sfT<23>" "0" )
converge( 'ic "/sfT<24>" "0" )
converge( 'ic "/sfT<25>" "0" )
converge( 'ic "/sfT<26>" "0" )
converge( 'ic "/sfT<27>" "0" )
converge( 'ic "/sfT<28>" "0" )
converge( 'ic "/sfT<29>" "0" )
converge( 'ic "/sfT<30>" "0" )
converge( 'ic "/sfT<31>" "0" )
converge( 'ic "/stT<0>" "0" )
converge( 'ic "/stT<1>" "0" )
converge( 'ic "/stT<2>" "0" )
converge( 'ic "/stT<3>" "0" )
converge( 'ic "/stT<4>" "0" )
converge( 'ic "/stT<5>" "0" )
converge( 'ic "/stT<6>" "0" )
converge( 'ic "/stT<7>" "0" )
converge( 'ic "/stT<8>" "0" )
converge( 'ic "/stT<9>" "0" )
converge( 'ic "/stT<10>" "0" )
converge( 'ic "/stT<11>" "0" )
converge( 'ic "/stT<12>" "0" )
converge( 'ic "/stT<13>" "0" )
converge( 'ic "/stT<14>" "0" )
converge( 'ic "/stT<15>" "0" )
converge( 'ic "/stT<16>" "0" )
converge( 'ic "/stT<17>" "0" )
converge( 'ic "/stT<18>" "0" )
converge( 'ic "/stT<19>" "0" )
converge( 'ic "/stT<20>" "0" )
converge( 'ic "/stT<21>" "0" )
converge( 'ic "/stT<22>" "0" )
converge( 'ic "/stT<23>" "0" )
converge( 'ic "/stT<24>" "0" )
converge( 'ic "/stT<25>" "0" )
converge( 'ic "/stT<26>" "0" )
converge( 'ic "/stT<27>" "0" )
converge( 'ic "/stT<28>" "0" )
converge( 'ic "/stT<29>" "0" )
converge( 'ic "/stT<30>" "0" )
converge( 'ic "/stT<31>" "0" )
converge( 'ic "/ReqT" "0" )
converge( 'ic "/Req" "0" )
temp( 27 )

;;;;;;;;;;;;;;;;;;;;;;;;;;;;;;;;;;;;;;;;;;;;
;;;;;;;;;;;;;;;;;;;;;;;;;;;;;;;;;;;;;;;;;;;;

;Vload = list( .40 .41 .42 .43 .44 .45 .46 .47 .48 .49 \
	      .50 .51 .52 .53 .54 .55 .56 .57 .58 .59 \
	      .60 .61 .62 .63 .64 .65 .66 .67 .68 .69 \
	      .70 .71 .72 .73 .74 .75 .76 .77 .78 .79 \
	      .80 .81 .82 .83 .84 .85 .86 .87 .88 .89 \
	      .90 .91 .92 .93 .94 .95 .96 .97 .98 .99 1 )
Vload = list( .41 .43 .45 .47 .49 \
               .51 .53 .55 .57 .59 \
               .61 .63 .65 .67 .69 \
               .71 .73 .75 .77 .79 \
               .81 .83 .85 .87 .89 \
               .91 .93 .95 .97 .99 )

;Vload = list(  .40 .42 .44 .46 .48 \
               .50 .52 .54 .56 .58 \
               .60 .62 .64 .66 .68 \
               .70 .72 .74 .76 .78 \
               .80 .82 .84 .86 .88 \
	       .90 .92 .94 .96 .98 )
jobList = nil
volts   = nil

foreach( val  Vload
    	desVar( "vdd" val )
	desVar( "vcc" val )
        volt = round( evalstring( desVar( "vdd" )) * 1000 )
        volts = append1( volts sprintf( nil "%d" volt ))
	jobList = append1( jobList run( ?jobName "job" ?mail "rstdenis@ucdavis.edu" ))
)

wait( last( jobList ))

;i = 1
;foreach(job jobList
;	openResults( nthelem(i jobList))
;	selectResult( 'tran )
;        leakage = average( clip( i( "/V1/MINUS" ) 0 10n ) ) *1e9

;        p = outfile("/root/Desktop/leakage.log" "a")
;        fprintf( p "%s,%g\n" nthelem(i volts)  leakage )
;        close( p)
;	i = i + 1
;)
foreach( x jobList deleteJob( x ) )
