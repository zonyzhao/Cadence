simulator( 'spectre )
design(	 "/net/kafka/nfs/rstdenis/Cadence/simulation/Dual_Supply_Word_Test/spectre/schematic/netlist/netlist")
resultsDir( "/net/kafka/nfs/rstdenis/Cadence/simulation/Dual_Supply_Word_Test/spectre/schematic" )
modelFile(
    '("/software/cadence/ncsu-FreePDK15/hspice_20nm_hp.include" "")
)
analysis('tran ?stop "VAR(\"timeStop\")"  ?errpreset "conservative"  ?ic "all"
		?readic "/net/kafka/nfs/rstdenis/Cadence/simulation/Dual_Supply_Word_Test/spectre/schematic/netlist/spectre.ic"
		)
desVar(	  "nfin" 12	)
desVar(	  "VDDH" .600	)
desVar(	  "VDDL" .450	)
desVar(	  "period" 6n	)
desVar(	  "C" 26.374f	)
desVar(	  "pulseWidth" 3n	)
desVar(	  "startDelay" 3n	)
desVar(	  "timeStop" 18n	)
envOption(
	'cmd64bit  t
	'analysisOrder  list("tran")
)
option(	'multithread  "on"
)
save( 'v "/VH" "/VL" "/Vline" )
save( 'i "/ILine/src" "/IVDDH/src" "/IVDDL/dst" )
converge( 'ic "/net035" "0" )
converge( 'ic "/VL" "0" )
converge( 'ic "/VH" "VDDH" )
converge( 'ic "/sH" "VDDH" )
converge( 'ic "/vcc!" "VDDL" )
converge( 'ic "/I33/I7/I3/Q1" "VDDL" )
converge( 'ic "/I33/I7/I3/Q0" "0" )
converge( 'ic "/I33/I7/I2/Q0" "0" )
converge( 'ic "/I33/I7/I2/Q1" "VDDL" )
converge( 'ic "/gnd!" "0" )
converge( 'ic "/I33/I7/I1/Q0" "0" )
converge( 'ic "/I33/I7/I1/Q1" "VDDL" )
converge( 'ic "/I34/I7/I3/Q0" "0" )
converge( 'ic "/I34/I7/I3/Q1" "VDDL" )
temp( 27 )

selectResult( 'tran )

vDiff 				= (VAR("VDDH") - VAR("VDDL"))
clipStart 			= ((0.75 * VAR("period")) + VAR("startDelay"))
cVH 				= clip(v("/VH" ?result "tran") clipStart (VAR("timeStop") - (0.75 * VAR("period"))))
cVL 				= clip(v("/VL" ?result "tran") clipStart (VAR("timeStop") - (0.75 * VAR("period"))))
cVline 				= clip(v("/Vline" ?result "tran") clipStart (VAR("timeStop") - (0.75 * VAR("period"))))

iPwr 				= i("/IVDDL/dst" ?result "tran") * v("/Vline" ?result "tran")
iPwr2				= i("/IVDDH/src" ?result "tran") * v("/Vline" ?result "tran")
tFallStart 			= cross(cVline (VAR("VDDH") - (0.1 * vDiff)) 1 "falling")
tFallEnd 			= cross(cVline (VAR("VDDH") - (0.9 * vDiff)) 1 "falling")
tRiseStart 			= cross(cVline (VAR("VDDL") + (0.1 * vDiff)) 1 "rising")
tRiseEnd 			= cross(cVline (VAR("VDDL") + (0.9 * vDiff)) 1 "rising")
tTPFallEnd 			= cross(cVline (VAR("VDDH") - (0.5 * vDiff)) 1 "falling")
tTPRiseEnd 			= cross(cVline (VAR("VDDL") + (0.5 * vDiff)) 1 "rising")

tRiseSettleStart 	= xmax(intersect(cVH cVL))
tRiseSettleEnd 		= cross(cVline (0.95 * VAR("VDDH")) 1 "rising")
tFallSettleStart 	= xmin(intersect(cVH cVL))
tFallSettleEnd 		= cross(cVline (1.05 * VAR("VDDL")) 1 "falling")

TSettleFall 		= (tFallSettleEnd - tFallSettleStart)
TSettleRise 		= (tRiseSettleEnd - tRiseSettleStart)
TFall 				= (tFallEnd - tFallStart)
TPFall 				= (tTPFallEnd - tFallSettleStart)
TPRise 				= (tTPRiseEnd - tRiseSettleStart)
TRise 				= (tRiseEnd - tRiseStart)

tLeakageEnd 		= (clipStart + (0.58 * VAR("period")))
tLeakageStart 		= (clipStart + (0.42 * VAR("period")))
LeakageIntoVDDL 	= average(clip(i("/IVDDL/dst" ?result "tran") tLeakageStart tLeakageEnd))
LeakageLine 		= average(clip(i("/ILine/src" ?result "tran") tLeakageStart tLeakageEnd))
LeakageVDDH 		= average(clip(i("/IVDDH/src" ?result "tran") tLeakageStart tLeakageEnd))
EFall 				= ymax( iinteg( clip( iPwr tFallSettleStart tFallSettleEnd )))
ERise 				= ymax( iinteg( clip( iPwr2 tRiseSettleStart tRiseSettleEnd )))

file  =  strcat(  "/root/Desktop/"  "DualSupplyResults.matlab"  )
out   = outfile(file, "w")
ocnPrint(?output out TSettleRise TSettleFall TRise TFall TPRise TPFall ERise EFall LeakageVDDH  LeakageLine  LeakageIntoVDDL ?precision 16  ?numSpaces 1 ?numberNotation 'scientific)
printf("Completed.")

;plot(getData("/ILine/src") getData("/IVDDH/src") getData("/IVDDL/dst") getData("/VH") getData("/VL") getData("/Vline") getData("/I33/I7/I3/Q1") getData("/I33/I7/I3/Q0") )
;plot( TPRise ?expr '( "TPRise" ) )
;plot( TRise ?expr '( "TRise" ) )
;plot( TSettleFall ?expr '( "TSettleFall" ) )
;plot( TSettleRise ?expr '( "TSettleRise" ) )
;plot( tRiseSettleStart ?expr '( "tRiseSettleStart" ) )
;plot( tRiseStart ?expr '( "tRiseStart" ) )
;plot( tTPFallEnd ?expr '( "tTPFallEnd" ) )
;plot( tTPRiseEnd ?expr '( "tTPRiseEnd" ) )
;plot( EFall ?expr '( "EFall" ) )
;plot( ERise ?expr '( "ERise" ) )
;plot( LeakageIntoVDDL ?expr '( "LeakageIntoVDDL" ) )
;plot( LeakageLine ?expr '( "LeakageLine" ) )
;plot( TFall ?expr '( "TFall" ) )
;plot( LeakageVDDH ?expr '( "LeakageVDDH" ) )
;plot( TPFall ?expr '( "TPFall" ) )
;plot( cVH ?expr '( "cVH" ) )
;plot( tRiseEnd ?expr '( "tRiseEnd" ) )
;plot( tLeakageStart ?expr '( "tLeakageStart" ) )
;plot( tLeakageEnd ?expr '( "tLeakageEnd" ) )
;plot( tFallStart ?expr '( "tFallStart" ) )
;plot( tFallSettleStart ?expr '( "tFallSettleStart" ) )
;plot( tFallSettleEnd ?expr '( "tFallSettleEnd" ) )
;plot( tFallEnd ?expr '( "tFallEnd" ) )
;plot( cVline ?expr '( "cVline" ) )
;plot( clipStart ?expr '( "clipStart" ) )
;plot( iPwr ?expr '( "iPwr" ) )
;plot( tRiseSettleEnd ?expr '( "tRiseSettleEnd" ) )
;plot( cVL ?expr '( "cVL" ) )
