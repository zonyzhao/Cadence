simulator( 'spectreVerilog )
design(	 "/net/kafka/nfs/rstdenis/Cadence/simulation/6T_BANK_Test/spectreVerilog/config/netlist/analog/netlist")
resultsDir( "/net/kafka/nfs/rstdenis/Cadence/simulation/6T_BANK_Test/spectreVerilog/config" )
modelFile(
    '("/software/cadence/ncsu-FreePDK15/hspice_16nm_hp.include" "")
)
analysis('tran ?stop "500n "  ?errpreset "conservative"
		?readic "/net/kafka/nfs/rstdenis/Cadence/simulation/6T_BANK_Test/spectreVerilog/config/netlist/spectre.ic"
		?readns "/net/kafka/nfs/rstdenis/Cadence/simulation/6T_BANK_Test/spectreVerilog/config/netlist/spectre.dc"
		)
desVar(	  "vdd" .7	)
desVar(	  "vcc" "vdd"	)
envOption(
	'mspSetupNetlistSimPrecisionUnit  "ps"
	'mspSetupNetlistSimTimeUnit  "ps"
	'mspSetupNetlistSwitchRC  t
	'analysisOrder  list("tran")
)
option(	'narrate  "yes"
	'inventory  "detailed"
	'multithread  "on"
	'temp  "30.0"
)
saveOption( ?simOutputFormat "psfxl" )
save( 'v "/vdd!" "/vcc!" )
save( 'i "/V1/PLUS" "/V1/MINUS" "/V0/PLUS" "/V0/MINUS" )
temp( 30.0 )
;;;;;;;;;;;;;;;;;;;;;;;;;;;;;;;;;;;;;;;;;;;;;;;;;;;;;;;;;;;;;;;;;;;;;;;;;;;;;;;;;;;;;
;2107List = 	list( "adder" "asp" "blind" "boa" "boom" "brown" \
;		      "cobra"  "copper" "coral" "corn" "crowned" \
;		      "deathadder" "fierce" "garter" "gopher" 	 \
;		      "hognose" "indigo" "krait" "mamba" "milk"  \
;		      "python" "queen" "racer" "rainbow" "rat" 	 \
;		      "rattle" "redbelly" "ribbon" "scarlet" 	 \
;		      "swamp" "timber" "viper" )
;;;;;;;;;;;;;;;;;;;;;;;;;;;;;;;;;;;;;;;;;;;;;;;;;;;;;;;;;;;;;;;;;;;;;;;;;;;;;;;;;;;;;
;;;;;;;;;;;;;;;;;;;;;;;;;;;;;;;;;;;;;;;;;;;;;;;;;;;;;;;;;;;;;;;;;;;;;;;;;;;;;;;;;;;;;

hList = list( "asp" "boa" "boom" "brown" "cobra"  "copper" "coral" "corn" "crowned" "deathadder" "fierce" "garter" "gopher" "hognose" "indigo" "krait" "mamba" "milk" "python" "queen" "racer" "rainbow" "rat" "rattle" "redbelly" "ribbon" "scarlet" "swamp" "timber" "viper" )

vLoad = list(   .125 .150 .175 .200 .250 .275 .300 .325 .350 .400 .450 .475 .500 .525 .550 .650 .750 .850 .950 1.0 1.050 1.075 1.10 1.125 1.150 1.175 1.20 1.25 )
tLoad = list( 30 )

jobList 	= nil
mVs   		= nil
temps   	= nil
j=1
foreach( degC  tLoad
    foreach( val  vLoad
	desVar( "vdd" val )
	temp(degC)

	volt    = round( evalstring( desVar( "vdd" )) * 1000 )
	mVs     = append1( mVs sprintf( nil "%d" volt ))
	temps   = append1( temps sprintf(nil "%d" degC ))

	jobName = strcat("/net/kafka/nfs/rstdenis/Cadence/simulation/6T_BANK_Test/spectreVerilog/config/distributed/2KBank_" sprintf( nil "%d" volt ) "mV_" sprintf( nil "%d" degC) "C/psf" )
	jobList = append1( jobList jobName )

	j = j + 1
    )
)

;;;;;;;;;;;;;;;;;;;;;;;;;;;;;;;;;;;;;;;;;;;;;;;;;;;;;;;;;;;;;;;;;;;;;;;;;;;;;;;;;;;;;
;;;;;;;;;;;;;;;;;;;;;;;;;;;;;;;;;;;;;;;;;;;;;;;;;;;;;;;;;;;;;;;;;;;;;;;;;;;;;;;;;;;;;
file      =  strcat( "/root/Desktop/Cadence/simData/CacheData/2K_BankData.csv")
outF      =   outfile(file,    "w")
fprintf( outF,   "Vdd [mv],Temp [C],Leakage [mA],Leakage [mW],peak Current [mA],peakPwr [mW],rDelay [ps],rEnergy [pJ],rNull [ps],rnullEnergy [pJ],rCycle Total [ps],rCycleEgy Total [pJ],rCycle EDP [pJ*ps],wDelay [ps],Wenergy [pJ],Wnull [ps],WnullEnergy [pJ],WCycle Total [ps],WCycleEgy Total [pJ],wCycle EDP [pJ*ps]\n" )
close(outF)
;;;;;;;;;;;;;;;;;;;;;;;;;;;;;;;;;;;;;;;;;;;;;;;;;;;;;;;;;;;;;;;;;;;;;;;;;;;;;;;;;;;;;
;;;;;;;;;;;;;;;;;;;;;;;;;;;;;;;;;;;;;;;;;;;;;;;;;;;;;;;;;;;;;;;;;;;;;;;;;;;;;;;;;;;;;
;file8K    =  strcat( "/root/Desktop/Cadence/simData/CacheData/8K_BankData.csv"  )
;file16K   =  strcat( "/root/Desktop/Cadence/simData/CacheData/16K_BankData.csv" )
;file32K   =  strcat( "/root/Desktop/Cadence/simData/CacheData/32K_BankData.csv" )

;out8K     =   outfile(file8K,  "w")
;out16K    =   outfile(file16K, "w")
;out32K    =   outfile(file32K, "w")

;fprintf( out8K,  "Vdd [mv], Temp [C], Leakage [mA], LeakagePw [mW], RW_Energy [pJ], RW_Energy_Null [pJ], Cycle_Energy [pJ], ) \n"  )
;fprintf( out16K,  "Vdd [mv], Temp [C], Leakage [mA], LeakagePw [mW], RW_Energy [pJ], RW_Energy_Null [pJ], Cycle_Energy [pJ],  \n" )
;fprintf( out32K,  "Vdd [mv], Temp [C], Leakage [mA], LeakagePw [mW], RW_Energy [pJ], RW_Energy_Null [pJ], Cycle_Energy [pJ],  \n" )

;close(out8K)
;close(out16K)
;close(out32K)
;;;;;;;;;;;;;;;;;;;;;;;;;;;;;;;;;;;;;;;;;;;;;;;;;;;;;;;;;;;;;;;;;;;;;;;;;;;;;;;;;;;;;
;;;;;;;;;;;;;;;;;;;;;;;;;;;;;;;;;;;;;;;;;;;;;;;;;;;;;;;;;;;;;;;;;;;;;;;;;;;;;;;;;;;;;
j = 1
foreach(job jobList
    	printf("%s\n" job )
    	unless( openResults( job ) == nil 		;;|| (evalstring(nthelem(j mVs)) <175) ;|| (evalstring(nthelem(j mVs)) >1200)
    		selectResult( 'tran )
    		unless( i("/V1/MINUS")  == nil
				Volts       = evalstring( nthelem(j mVs) )*0.001;
				peakCurrent = ymax( i( "/V1/MINUS" ))*1e3
				peakPwr     = peakCurrent*Volts

				cHost       = sprintf(nil "%s" nthelem(j hList))
        		nameR       = strcat( "/root/Desktop/Cadence/simData/CacheData/2Kbank_logs/2KBankRLog_" nthelem(j mVs) "mV_" nthelem(j temps) "C.log" )
        		nameW       = strcat( "/root/Desktop/Cadence/simData/CacheData/2Kbank_logs/2KBankWLog_" nthelem(j mVs) "mV_" nthelem(j temps) "C.log" )
				shellCmd1   = strcat("scp " cHost ":/tmp2/bankRLog.csv " nameR  )
				shellCmd2   = strcat("scp " cHost ":/tmp2/bankWLog.csv " nameW  )
				shell( shellCmd1 )
				shell( shellCmd2 )

        		printf("Reading %s from host: %s\n" nameR, cHost)
        		fidR   = infile( nameR )
				gets( s fidR )
        		fscanf( fidR "%s %s %s %s" rAddr  rData rEnd     rDelay )
       		    fscanf( fidR "%s %s %s %s" rAddr  rData rEndNull rNull )
        		close( fidR )

        		printf("Reading %s from host: %s\n\n" nameW, cHost)
        		fidW   = infile( nameW )
				gets( s fidW )
       			fscanf( fidW "%s %s %s %s" wAddr  wData wEnd     wDelay )
        		fscanf( fidW "%s %s %s %s" wAddr  wData wEndNull wNull  )
        		close(fidW)

				unless( (rEnd == nil) || (rEndNull == nil) || (wEnd == nil) || (wEndNull == nil)
	    			rStart       = evalstring( strcat(rEnd "p")) - evalstring( strcat(rDelay "p"))
            		rEnd         = evalstring( strcat(rEnd "p"))
            		rEndNull     = evalstring( strcat(rEndNull "p"))
 	    			rEnergy      = integ( i("/V1/MINUS")  rStart rEnd    )*1e12*Volts
	    			rnullEnergy  = integ( i("/V1/MINUS")  rEnd   rEndNull)*1e12*Volts

	    			rCycle       = evalstring( rDelay ) + evalstring( rNull )
	    			rCycleEnergy = rEnergy +  rnullEnergy
	    			rEDP	 = rCycle*rCycleEnergy

            		wStart      = evalstring( strcat(wEnd "p") ) - evalstring( strcat(wDelay "p"))
            		wEnd        = evalstring( strcat(wEnd "p") )
            		wEndNull    = evalstring( strcat(wEndNull "p") )
	    			wEnergy     = integ( i("/V1/MINUS") wStart wEnd    )*1e12*Volts
	    			wnullEnergy = integ( i("/V1/MINUS") wEnd   wEndNull)*1e12*Volts

	    			wCycle       = evalstring( wDelay) + evalstring( wNull )
	    			wCycleEnergy = wEnergy +  wnullEnergy
	    			wEDP	 = wCycle*wCycleEnergy

					leakage     = average( clip( i( "/V1/MINUS" ) (wEndNull+500p) (wEndNull+1000p) ) ) *1e3
        			leakagePwr  = leakage*Volts

	   				outF       =  outfile(file, "a")
            		fprintf( outF "%s,%s,%g,%g,%g,%g,%s,%g,%s,%g,%d,%g,%g,%s,%g,%s,%g,%d,%g,%g\n" nthelem(j mVs) nthelem(j temps) leakage leakagePwr peakCurrent peakPwr rDelay rEnergy rNull rnullEnergy rCycle rCycleEnergy rEDP wDelay wEnergy wNull wnullEnergy wCycle wCycleEnergy wEDP)
            		close( outF )

;;;;;;;;;;;;;;;;;;;;;;;;;;;;;;;;;;;;;;;;;;;;;;;;;;;;;;;;;;;;;;;;;;;;;;;;;;;;;;;;;;;;;;;;;;;;;;;;;;;;;;;;;;;;;;
;;;;;;;;;;;;;;;;;;;;;;;;;;;;;;;;;;;;;;;;;;;;;;;;;;;;;;;;;;;;;;;;;;;;;;;;;;;;;;;;;;;;;;;;;;;;;;;;;;;;;;;;;;;;;;

;            	leak8K    = leakage*4   ;;mA
;            	leak16K   = leak8K*2    ;;mA
;            	leak32K   = leak16K*2   ;;mA

;            	leak8KPwr  = leak8K*Volts  ;;mW
;            	leak16KPwr = leak16K*Volts ;;mW
;            	leak32KPwr = leak32K*Volts ;;mW

;            	leakageEnergy     = 1e-3*leakagePwr*2*(rEnd-rStart)*1e12         ;; read is longer than write
;            	leakageEnergyNull = 1e-3*leakagePwr*2*(rEndNull-rEnd)*1e12       ;; read is longer than write

;            	rwEnergy8K   = rEnergy+wEnergy+leakageEnergy
;            	rwEnergy16K  = 2*rwEnergy8K
;            	rwEnergy32K  = 4*rwEnergy8K

;            	rwEnergyNull8K  = rnullEnergy+wnullEnergy+leakageEnergyNull
;            	rwEnergyNull16K = 2*rwEnergyNull8K
;            	rwEnergyNull32K = 4*rwEnergyNull8K

;            	rwCycleEnergy8K  =  rwEnergy8K +   rwEnergyNull8K
;            	rwCycleEnergy16K =  rwEnergy16K +  rwEnergyNull16K
;            	rwCycleEnergy32K =  rwEnergy32K +  rwEnergyNull32K

;;;;;;;;;;;;;;;;;;;;;;;;;;;;;;;;;;;;;;;;;;;;;;;;;;;;;;;;;;;;;;;;;;;;;;;;;;;;;;;;;;;;;;;;;;;;;;;;;;;;;;;;;;;;;;

 ;           	out8K     =   outfile(file8K,  "a")
 ;           	out16K    =   outfile(file16K, "a")
 ;           	out32K    =   outfile(file32K, "a")
 ;           	fprintf( out8K  "%s,\t %s,\t %g,\t %g,\t %g,\t %g,\t %g\n" nthelem(j mVs) nthelem(j temps) leak8K leak8KPwr rwEnergy8K rwEnergyNull8K rwCycleEnergy8K)
 ;           	fprintf( out16K "%s,\t %s,\t %g,\t %g,\t %g,\t %g,\t %g\n" nthelem(j mVs) nthelem(j temps) leak16K leak16KPwr rwEnergy16K rwEnergyNull16K rwCycleEnergy16K)
 ;           	fprintf( out32K "%s,\t %s,\t %g,\t %g,\t %g,\t %g,\t %g\n" nthelem(j mVs) nthelem(j temps) leak32K leak32KPwr rwEnergy32K rwEnergyNull32K rwCycleEnergy32K)
 ;           	close( out8K)
 ;           	close( out16K)
 ;           	close( out32K)
;;;;;;;;;;;;;;;;;;;;;;;;;;;;;;;;;;;;;;;;;;;;;;;;;;;;;;;;;;;;;;;;;;;;;;;;;;;;;;;;;;;;;;;;;;;;;;;;;;;;;;;;;;;;;;
        	)
      	)
    )
    j     = j + 1
)
printf("\nCompleted.\n")
;;;;;;;;;;;;;;;;;;;;;;;;;;;;;;;;;;;;;;;;;;;;;;;;;;;;;;;;;;;;;;;;;;;;;;;;;;;;;;;;;;;;;;;;;;;;;;;;;;;;;;;;;;;;;;
