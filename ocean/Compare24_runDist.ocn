simulator( 'spectreVerilog )
design(	 "/net/kafka/nfs/rstdenis/Cadence/simulation/Compare24_Test/spectreVerilog/config/netlist/analog/netlist")
resultsDir( "/net/kafka/nfs/rstdenis/Cadence/simulation/Compare24_Test/spectreVerilog/config" )
modelFile(
    '("/software/cadence/ncsu-FreePDK15/hspice_16nm_hp.include" "")
)
analysis('tran ?stop "500n"  ?errpreset "conservative"  )
desVar(	  "vdd" .500	)
envOption(
	'analysisOrder  list("tran")
)
option(	'multithread  "on"
	'temp  "30.0"
)
saveOption( ?simOutputFormat "psfxl" )
save( 'v "/vcc!" "/vdd!" )
save( 'i "/V0/MINUS" "/V1/MINUS" "/V1/PLUS" "/V0/PLUS" )
converge( 'ic "/b1T<0>" "0" )
converge( 'ic "/b1T<1>" "0" )
converge( 'ic "/b1T<2>" "0" )
converge( 'ic "/b1T<3>" "0" )
converge( 'ic "/b1T<4>" "0" )
converge( 'ic "/b1T<5>" "0" )
converge( 'ic "/b1T<6>" "0" )
converge( 'ic "/b1T<7>" "0" )
converge( 'ic "/b1T<8>" "0" )
converge( 'ic "/b1T<9>" "0" )
converge( 'ic "/b1T<10>" "0" )
converge( 'ic "/b1T<11>" "0" )
converge( 'ic "/b1T<12>" "0" )
converge( 'ic "/b1T<13>" "0" )
converge( 'ic "/b1T<14>" "0" )
converge( 'ic "/b1T<15>" "0" )
converge( 'ic "/b1T<16>" "0" )
converge( 'ic "/b1T<17>" "0" )
converge( 'ic "/b1T<18>" "0" )
converge( 'ic "/b1T<19>" "0" )
converge( 'ic "/b1T<20>" "0" )
converge( 'ic "/b1T<21>" "0" )
converge( 'ic "/b1T<22>" "0" )
converge( 'ic "/b1T<23>" "0" )
converge( 'ic "/b0T<0>" "0" )
converge( 'ic "/b0T<1>" "0" )
converge( 'ic "/b0T<2>" "0" )
converge( 'ic "/b0T<3>" "0" )
converge( 'ic "/b0T<4>" "0" )
converge( 'ic "/b0T<5>" "0" )
converge( 'ic "/b0T<6>" "0" )
converge( 'ic "/b0T<7>" "0" )
converge( 'ic "/b0T<8>" "0" )
converge( 'ic "/b0T<9>" "0" )
converge( 'ic "/b0T<10>" "0" )
converge( 'ic "/b0T<11>" "0" )
converge( 'ic "/b0T<12>" "0" )
converge( 'ic "/b0T<13>" "0" )
converge( 'ic "/b0T<14>" "0" )
converge( 'ic "/b0T<15>" "0" )
converge( 'ic "/b0T<16>" "0" )
converge( 'ic "/b0T<17>" "0" )
converge( 'ic "/b0T<18>" "0" )
converge( 'ic "/b0T<19>" "0" )
converge( 'ic "/b0T<20>" "0" )
converge( 'ic "/b0T<21>" "0" )
converge( 'ic "/b0T<22>" "0" )
converge( 'ic "/b0T<23>" "0" )
converge( 'ic "/a0T<0>" "0" )
converge( 'ic "/a0T<1>" "0" )
converge( 'ic "/a0T<2>" "0" )
converge( 'ic "/a0T<3>" "0" )
converge( 'ic "/a0T<4>" "0" )
converge( 'ic "/a0T<5>" "0" )
converge( 'ic "/a0T<6>" "0" )
converge( 'ic "/a0T<7>" "0" )
converge( 'ic "/a0T<8>" "0" )
converge( 'ic "/a0T<9>" "0" )
converge( 'ic "/a0T<10>" "0" )
converge( 'ic "/a0T<11>" "0" )
converge( 'ic "/a0T<12>" "0" )
converge( 'ic "/a0T<13>" "0" )
converge( 'ic "/a0T<14>" "0" )
converge( 'ic "/a0T<15>" "0" )
converge( 'ic "/a0T<16>" "0" )
converge( 'ic "/a0T<17>" "0" )
converge( 'ic "/a0T<18>" "0" )
converge( 'ic "/a0T<19>" "0" )
converge( 'ic "/a0T<20>" "0" )
converge( 'ic "/a0T<21>" "0" )
converge( 'ic "/a0T<22>" "0" )
converge( 'ic "/a0T<23>" "0" )
converge( 'ic "/a1T<0>" "0" )
converge( 'ic "/a1T<1>" "0" )
converge( 'ic "/a1T<2>" "0" )
converge( 'ic "/a1T<3>" "0" )
converge( 'ic "/a1T<4>" "0" )
converge( 'ic "/a1T<5>" "0" )
converge( 'ic "/a1T<6>" "0" )
converge( 'ic "/a1T<7>" "0" )
converge( 'ic "/a1T<8>" "0" )
converge( 'ic "/a1T<9>" "0" )
converge( 'ic "/a1T<10>" "0" )
converge( 'ic "/a1T<11>" "0" )
converge( 'ic "/a1T<12>" "0" )
converge( 'ic "/a1T<13>" "0" )
converge( 'ic "/a1T<14>" "0" )
converge( 'ic "/a1T<15>" "0" )
converge( 'ic "/a1T<16>" "0" )
converge( 'ic "/a1T<17>" "0" )
converge( 'ic "/a1T<18>" "0" )
converge( 'ic "/a1T<19>" "0" )
converge( 'ic "/a1T<20>" "0" )
converge( 'ic "/a1T<21>" "0" )
converge( 'ic "/a1T<22>" "0" )
converge( 'ic "/a1T<23>" "0" )
temp( 30.0 )

;;;;;;;;;;;;;;;;;;;;;;;;;;;;;;;;;;;;;;;;;;;;;;;;;;;;;;;;;;
;hList = 	list( "adder" "asp" "blind" "boa" "boom" "brown" \
;		      "cobra"  "copper" "coral" "corn" "crowned" \
;		      "deathadder" "fierce" "garter" "gopher" 	 \
;		      "hognose" "indigo" "krait" "mamba" "milk"  \
;		      "python" "queen" "racer" "rainbow" "rat" 	 \
;		      "rattle" "redbelly" "ribbon" "scarlet" 	 \
;		      "swamp" "timber" "viper" )

hList = list( "asp" "boa" "boom" "brown" "cobra"  "copper" "coral" "corn" "crowned" "deathadder" "fierce" "garter" "gopher" "hognose" "indigo" "krait" "mamba" "milk" "python" "queen" "racer" "rainbow" "rat" "rattle" "redbelly" "ribbon" "scarlet" "swamp" "timber" "viper" )

;vLoad = list(  .250 .325 0.45 .475 .50 .525 .675 .85 1.0 1.125 )
;vLoad = list( .195 .480 .485 .490 .495 .50 .505 .510 1.3 )
vLoad = list( .125 .150 .175 .200 .250 .275 .300 .325 .350 .400 .450 .475 .500 .525 .550 .650 .750 .850 .950 1.0 1.050 1.075 1.10 1.125 1.150 1.175 1.20 1.25 )

;tLoad = list( 30 60 90 )
tLoad = list( 60 )

jobList 	= nil
mVs   		= nil
temps   	= nil
j=1
foreach( degC  tLoad
    foreach( val  vLoad
	desVar( "vdd" val )
	temp(degC)

	volt    = round( evalstring( desVar( "vdd" )) * 1000 )
	mVs     = append1( mVs sprintf( nil "%d" volt ))
	temps   = append1( temps sprintf(nil "%d" degC ))

;;;;;;;;;;;;;;;;;;;;;;;;;;;;;;;;;;;;;;;;;;;;;;;;;;;;;;;;;;;;;;;;;;;;;;;;;;;;;;;;;;;;;;;;;;;;;;;;;;;;
	jobName = strcat("Compare24_"  sprintf( nil "%d" volt ) "mV_" sprintf( nil "%d" degC) "C" )
	jobList = append1( jobList run( ?jobName jobName ?queue "c2107" ?host nthelem(j hList) ) )
;;;;;;;;;;;;;;;;;;;;;;;;;;;;;;;;;;;;;;;;;;;;;;;;;;;;;;;;;;;;;;;;;;;;;;;;;;;;;;;;;;;;;;;;;;;;;;;;;;;;

	j = j + 1
    )
)

printf("Completed.")
