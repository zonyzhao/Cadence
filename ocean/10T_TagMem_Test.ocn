simulator( 'spectreVerilog )
hostMode( 'distributed )
design(	 "/net/kafka/nfs/rstdenis/Cadence/simulation/10T_TagMem_Test/spectreVerilog/config/netlist/analog/netlist")
resultsDir( "/net/kafka/nfs/rstdenis/Cadence/simulation/10T_TagMem_Test/spectreVerilog/config" )
modelFile(
    '("/software/cadence/ncsu-FreePDK15/hspice_16nm_hp.include" "")
)
analysis('tran ?stop "5n"  ?errpreset "conservative"  )
desVar(	  "vdd" .850	)
desVar(	  "vcc" "vdd"	)
envOption(
	'mspSetupNetlistSimPrecisionUnit  "ps"
	'mspSetupNetlistSimTimeUnit  "ps"
	'mspSetupNetlistSwitchRC  t
	'userCmdLineOption  "+multithread"
	'analysisOrder  list("tran")
)
option(	'temp  "85.0"
)
saveOption( ?simOutputFormat "psfxl" )
save( 'i "/V0/MINUS" "/V1/MINUS" )
converge( 'ic "/R_AddrT<0>" "0" )
converge( 'ic "/R_AddrT<1>" "0" )
converge( 'ic "/R_AddrT<2>" "0" )
converge( 'ic "/R_AddrT<3>" "0" )
converge( 'ic "/R_AddrT<4>" "0" )
converge( 'ic "/R_AddrT<5>" "0" )
converge( 'ic "/R_AddrT<6>" "0" )
converge( 'ic "/GoRT" "0" )
converge( 'ic "/W_AddrT<0>" "0" )
converge( 'ic "/W_AddrT<1>" "0" )
converge( 'ic "/W_AddrT<2>" "0" )
converge( 'ic "/W_AddrT<3>" "0" )
converge( 'ic "/W_AddrT<4>" "0" )
converge( 'ic "/W_AddrT<5>" "0" )
converge( 'ic "/W_AddrT<6>" "0" )
converge( 'ic "/GoWT" "0" )
converge( 'ic "/W0T<0>" "0" )
converge( 'ic "/W0T<1>" "0" )
converge( 'ic "/W0T<2>" "0" )
converge( 'ic "/W0T<3>" "0" )
converge( 'ic "/W0T<4>" "0" )
converge( 'ic "/W0T<5>" "0" )
converge( 'ic "/W0T<6>" "0" )
converge( 'ic "/W0T<7>" "0" )
converge( 'ic "/W0T<8>" "0" )
converge( 'ic "/W0T<9>" "0" )
converge( 'ic "/W0T<10>" "0" )
converge( 'ic "/W0T<11>" "0" )
converge( 'ic "/W0T<12>" "0" )
converge( 'ic "/W0T<13>" "0" )
converge( 'ic "/W0T<14>" "0" )
converge( 'ic "/W0T<15>" "0" )
converge( 'ic "/W0T<16>" "0" )
converge( 'ic "/W0T<17>" "0" )
converge( 'ic "/W0T<18>" "0" )
converge( 'ic "/W0T<19>" "0" )
converge( 'ic "/W0T<20>" "0" )
converge( 'ic "/W0T<21>" "0" )
converge( 'ic "/W0T<22>" "0" )
converge( 'ic "/W0T<23>" "0" )
converge( 'ic "/W0T<24>" "0" )
converge( 'ic "/W0T<25>" "0" )
converge( 'ic "/W0T<26>" "0" )
converge( 'ic "/W0T<27>" "0" )
converge( 'ic "/W0T<28>" "0" )
converge( 'ic "/W0T<29>" "0" )
converge( 'ic "/W0T<30>" "0" )
converge( 'ic "/W0T<31>" "0" )
converge( 'ic "/W1T<0>" "0" )
converge( 'ic "/W1T<1>" "0" )
converge( 'ic "/W1T<2>" "0" )
converge( 'ic "/W1T<3>" "0" )
converge( 'ic "/W1T<4>" "0" )
converge( 'ic "/W1T<5>" "0" )
converge( 'ic "/W1T<6>" "0" )
converge( 'ic "/W1T<7>" "0" )
converge( 'ic "/W1T<8>" "0" )
converge( 'ic "/W1T<9>" "0" )
converge( 'ic "/W1T<10>" "0" )
converge( 'ic "/W1T<11>" "0" )
converge( 'ic "/W1T<12>" "0" )
converge( 'ic "/W1T<13>" "0" )
converge( 'ic "/W1T<14>" "0" )
converge( 'ic "/W1T<15>" "0" )
converge( 'ic "/W1T<16>" "0" )
converge( 'ic "/W1T<17>" "0" )
converge( 'ic "/W1T<18>" "0" )
converge( 'ic "/W1T<19>" "0" )
converge( 'ic "/W1T<20>" "0" )
converge( 'ic "/W1T<21>" "0" )
converge( 'ic "/W1T<22>" "0" )
converge( 'ic "/W1T<23>" "0" )
converge( 'ic "/W1T<24>" "0" )
converge( 'ic "/W1T<25>" "0" )
converge( 'ic "/W1T<26>" "0" )
converge( 'ic "/W1T<27>" "0" )
converge( 'ic "/W1T<28>" "0" )
converge( 'ic "/W1T<29>" "0" )
converge( 'ic "/W1T<30>" "0" )
converge( 'ic "/W1T<31>" "0" )
converge( 'ic "/ResetT" "0" )
converge( 'ic "/I36/I0/I1/I7/I3/Qb" "0" )
converge( 'ic "/I36/I2/I1/I7/I3/Qb" "0" )
converge( 'ic "/I36/I6/I1/I7/I3/Qb" "0" )
converge( 'ic "/I36/I6/I1/I7/I3/Q" "vdd" )
converge( 'ic "/I36/I2/I1/I7/I3/Q" "vdd" )
converge( 'ic "/I36/I0/I1/I7/I3/Q" "vdd" )
temp( 85.0 )
run( ?jobName "job" ?queue "c2107" )
