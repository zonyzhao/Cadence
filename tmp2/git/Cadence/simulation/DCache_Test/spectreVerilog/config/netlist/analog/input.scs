// Design: 16nm_Tests/DCache_Test
simulator lang=spectre
global 0 vdd! vcc!
parameters vcc=0.85 vdd=0.85
include "/software/cadence/ncsu-FreePDK15/hspice_16nm_hp.include"
include "/cerl/kstraube/Cadence/ATSim/Tag_write_ctrl_rev3/spectreText/spectre.scs"
include "/cerl/kstraube/Cadence/ATSim/L1_write_ctrl_rev3/spectreText/spectre.scs"
include "/cerl/kstraube/Cadence/ATSim/L1_read_ctrl_rev3/spectreText/spectre.scs"

// 16nm/inv_1xt/schematic
//system verilogNetlist schematic cmos.sch cmos_sch veriloga ahdl
subckt inv_1xt A Y
    M0 (Y A 0 0) nfet w=288n l=20n ld=105n ls=105n m=1 degradation=no
    M1 (Y A vcc! vcc!) pfet w=90n l=20n ld=105n ls=105n m=1 degradation=no
ends inv_1xt

// 16nm/inv_1x/schematic
//system verilogNetlist schematic cmos.sch cmos_sch veriloga ahdl
subckt inv_1x A Y
    M0 (Y A 0 0) nfet w=288n l=20n ld=105n ls=105n m=1 degradation=no
    M1 (Y A vdd! vdd!) pfet w=90n l=20n ld=105n ls=105n m=1 degradation=no
ends inv_1x

// 16nm/nand_1x/schematic
//system verilogNetlist schematic cmos.sch cmos_sch veriloga ahdl
subckt nand_1x A B Y
    M1 (Y B vdd! vdd!) pfet w=90n l=20n ld=105n ls=105n m=1 region=off degradation=no
    M0 (Y A vdd! vdd!) pfet w=90n l=20n ld=105n ls=105n m=1 region=off degradation=no
    M3 (net22 B 0 0) nfet w=288n l=20n ld=105n ls=105n m=1 degradation=no
    M2 (Y A net22 0) nfet w=288n l=20n ld=105n ls=105n m=1 degradation=no
ends nand_1x

// 16nm/TH44/schematic
//system verilogNetlist schematic cmos.sch cmos_sch veriloga ahdl
subckt TH44 A B C D Y
    M19 (net13 A 0 0) nfet w=80n l=16n m=1
    M18 (net13 B 0 0) nfet w=80n l=16n m=1
    M17 (net13 C 0 0) nfet w=80n l=16n m=1
    M16 (net13 D 0 0) nfet w=80n l=16n m=1
    M15 (Y net19 0 0) nfet w=40n l=16n m=1
    M14 (net42 A 0 0) nfet w=160n l=16n m=1
    M13 (net43 B net42 0) nfet w=160n l=16n m=1
    M12 (net44 C net43 0) nfet w=160n l=16n m=1
    M11 (net19 D net44 0) nfet w=160n l=16n m=1
    M10 (net19 Y net13 0) nfet w=80n l=16n m=1
    M9 (Y net19 vdd! vdd!) pfet w=80n l=16n m=1
    M8 (net19 Y net15 vdd!) pfet w=160n l=16n m=1
    M7 (net15 D vdd! vdd!) pfet w=160n l=16n m=1
    M6 (net15 C vdd! vdd!) pfet w=160n l=16n m=1
    M5 (net15 B vdd! vdd!) pfet w=160n l=16n m=1
    M4 (net15 A vdd! vdd!) pfet w=160n l=16n m=1
    M3 (net19 D net45 vdd!) pfet w=320n l=16n m=1
    M2 (net45 C net46 vdd!) pfet w=320n l=16n m=1
    M1 (net46 B net47 vdd!) pfet w=320n l=16n m=1
    M0 (net47 A vdd! vdd!) pfet w=320n l=16n m=1
ends TH44

// 16nm/TH22/schematic
//system verilogNetlist schematic cmos.sch cmos_sch veriloga ahdl
subckt TH22 A B Y
    M5 (Y net5 0 0) nfet w=48n l=16n m=1
    M4 (net5 Y net9 0) nfet w=48n l=16n m=1
    M3 (net9 B 0 0) nfet w=48n l=16n m=1
    M2 (net9 A 0 0) nfet w=48n l=16n m=1
    M1 (net5 B net17 0) nfet w=80n l=16n m=1
    M0 (net17 A 0 0) nfet w=80n l=16n m=1
    M11 (Y net5 vdd! vdd!) pfet w=80n l=16n m=1
    M10 (net5 B net032 vdd!) pfet w=160n l=16n m=1
    M9 (net032 A vdd! vdd!) pfet w=160n l=16n m=1
    M8 (net037 B vdd! vdd!) pfet w=80n l=16n m=1
    M7 (net037 A vdd! vdd!) pfet w=80n l=16n m=1
    M6 (net5 Y net037 vdd!) pfet w=80n l=16n m=1
ends TH22

// 16nm/TH22~/schematic
//system verilogNetlist schematic cmos.sch cmos_sch veriloga ahdl
subckt _sub160 A B Y
    I6 (net010 Y) inv_1x
    M5 (net010 net5 0 0) nfet w=48n l=16n m=1
    M4 (net5 net010 net9 0) nfet w=48n l=16n m=1
    M3 (net9 B 0 0) nfet w=48n l=16n m=1
    M2 (net9 A 0 0) nfet w=48n l=16n m=1
    M1 (net5 B net17 0) nfet w=80n l=16n m=1
    M0 (net17 A 0 0) nfet w=80n l=16n m=1
    M11 (net010 net5 vdd! vdd!) pfet w=80n l=16n m=1
    M10 (net5 B net032 vdd!) pfet w=160n l=16n m=1
    M9 (net032 A vdd! vdd!) pfet w=160n l=16n m=1
    M8 (net037 B vdd! vdd!) pfet w=80n l=16n m=1
    M7 (net037 A vdd! vdd!) pfet w=80n l=16n m=1
    M6 (net5 net010 net037 vdd!) pfet w=80n l=16n m=1
ends _sub160

// 16nm/10T_DUAL_SRAM_CompDetect/schematic
//system verilogNetlist schematic cmos.sch cmos_sch veriloga ahdl
subckt _sub161 KRe KRv KWe KWv R0_31 R0_30 R0_29 R0_28 R0_27 R0_26 R0_25 R0_24 R0_23 R0_22 R0_21 R0_20 R0_19 R0_18 R0_17 R0_16 R0_15 R0_14 R0_13 R0_12 R0_11 R0_10 R0_9 R0_8 R0_7 R0_6 R0_5 R0_4 R0_3 R0_2 R0_1 R0_0 R1_31 R1_30 R1_29 R1_28 R1_27 R1_26 R1_25 R1_24 R1_23 R1_22 R1_21 R1_20 R1_19 R1_18 R1_17 R1_16 R1_15 R1_14 R1_13 R1_12 R1_11 R1_10 R1_9 R1_8 R1_7 R1_6 R1_5 R1_4 R1_3 R1_2 R1_1 R1_0 Re2_7 Re2_6 Re2_5 Re2_4 Re2_3 Re2_2 Re2_1 Re2_0 W0_31 W0_30 W0_29 W0_28 W0_27 W0_26 W0_25 W0_24 W0_23 W0_22 W0_21 W0_20 W0_19 W0_18 W0_17 W0_16 W0_15 W0_14 W0_13 W0_12 W0_11 W0_10 W0_9 W0_8 W0_7 W0_6 W0_5 W0_4 W0_3 W0_2 W0_1 W0_0 W1_31 W1_30 W1_29 W1_28 W1_27 W1_26 W1_25 W1_24 W1_23 W1_22 W1_21 W1_20 W1_19 W1_18 W1_17 W1_16 W1_15 W1_14 W1_13 W1_12 W1_11 W1_10 W1_9 W1_8 W1_7 W1_6 W1_5 W1_4 W1_3 W1_2 W1_1 W1_0 We_7 We_6 We_5 We_4 We_3 We_2 We_1 We_0 \~R0_31 \~R0_30 \~R0_29 \~R0_28 \~R0_27 \~R0_26 \~R0_25 \~R0_24 \~R0_23 \~R0_22 \~R0_21 \~R0_20 \~R0_19 \~R0_18 \~R0_17 \~R0_16 \~R0_15 \~R0_14 \~R0_13 \~R0_12 \~R0_11 \~R0_10 \~R0_9 \~R0_8 \~R0_7 \~R0_6 \~R0_5 \~R0_4 \~R0_3 \~R0_2 \~R0_1 \~R0_0 \~R1_31 \~R1_30 \~R1_29 \~R1_28 \~R1_27 \~R1_26 \~R1_25 \~R1_24 \~R1_23 \~R1_22 \~R1_21 \~R1_20 \~R1_19 \~R1_18 \~R1_17 \~R1_16 \~R1_15 \~R1_14 \~R1_13 \~R1_12 \~R1_11 \~R1_10 \~R1_9 \~R1_8 \~R1_7 \~R1_6 \~R1_5 \~R1_4 \~R1_3 \~R1_2 \~R1_1 \~R1_0 \~W0_31 \~W0_30 \~W0_29 \~W0_28 \~W0_27 \~W0_26 \~W0_25 \~W0_24 \~W0_23 \~W0_22 \~W0_21 \~W0_20 \~W0_19 \~W0_18 \~W0_17 \~W0_16 \~W0_15 \~W0_14 \~W0_13 \~W0_12 \~W0_11 \~W0_10 \~W0_9 \~W0_8 \~W0_7 \~W0_6 \~W0_5 \~W0_4 \~W0_3 \~W0_2 \~W0_1 \~W0_0 \~W1_31 \~W1_30 \~W1_29 \~W1_28 \~W1_27 \~W1_26 \~W1_25 \~W1_24 \~W1_23 \~W1_22 \~W1_21 \~W1_20 \~W1_19 \~W1_18 \~W1_17 \~W1_16 \~W1_15 \~W1_14 \~W1_13 \~W1_12 \~W1_11 \~W1_10 \~W1_9 \~W1_8 \~W1_7 \~W1_6 \~W1_5 \~W1_4 \~W1_3 \~W1_2 \~W1_1 \~W1_0
    I77_3 (net0117_0 We_7) inv_1x
    I77_2 (net0117_1 We_6) inv_1x
    I77_1 (net0117_2 We_5) inv_1x
    I77_0 (net0117_3 We_4) inv_1x
    I76_3 (net0118_0 We_3) inv_1x
    I76_2 (net0118_1 We_2) inv_1x
    I76_1 (net0118_2 We_1) inv_1x
    I76_0 (net0118_3 We_0) inv_1x
    I75_3 (net0115_0 Re2_7) inv_1x
    I75_2 (net0115_1 Re2_6) inv_1x
    I75_1 (net0115_2 Re2_5) inv_1x
    I75_0 (net0115_3 Re2_4) inv_1x
    I73_3 (\~KRe_7 net0115_0) inv_1x
    I73_2 (\~KRe_6 net0115_1) inv_1x
    I73_1 (\~KRe_5 net0115_2) inv_1x
    I73_0 (\~KRe_4 net0115_3) inv_1x
    I72_3 (\~KRe_3 net0116_0) inv_1x
    I72_2 (\~KRe_2 net0116_1) inv_1x
    I72_1 (\~KRe_1 net0116_2) inv_1x
    I72_0 (\~KRe_0 net0116_3) inv_1x
    I71_3 (\~KWe_7 net0117_0) inv_1x
    I71_2 (\~KWe_6 net0117_1) inv_1x
    I71_1 (\~KWe_5 net0117_2) inv_1x
    I71_0 (\~KWe_4 net0117_3) inv_1x
    I70_3 (\~KWe_3 net0118_0) inv_1x
    I70_2 (\~KWe_2 net0118_1) inv_1x
    I70_1 (\~KWe_1 net0118_2) inv_1x
    I70_0 (\~KWe_0 net0118_3) inv_1x
    I66 (KRve_0 \~KRe_0) inv_1x
    I63 (KRve_1 \~KRe_1) inv_1x
    I59 (KRve_2 \~KRe_2) inv_1x
    I56 (KRve_3 \~KRe_3) inv_1x
    I52 (KRve_4 \~KRe_4) inv_1x
    I49 (KRve_5 \~KRe_5) inv_1x
    I45 (KRve_6 \~KRe_6) inv_1x
    I42 (KRve_7 \~KRe_7) inv_1x
    I37 (KWve_7 \~KWe_7) inv_1x
    I36 (KWve_6 \~KWe_6) inv_1x
    I35 (KWve_5 \~KWe_5) inv_1x
    I34 (KWve_4 \~KWe_4) inv_1x
    I33 (KWve_3 \~KWe_3) inv_1x
    I32 (KWve_2 \~KWe_2) inv_1x
    I31 (KWve_1 \~KWe_1) inv_1x
    I30 (KWve_0 \~KWe_0) inv_1x
    I74_3 (net0116_0 Re2_3) inv_1x
    I74_2 (net0116_1 Re2_2) inv_1x
    I74_1 (net0116_2 Re2_1) inv_1x
    I74_0 (net0116_3 Re2_0) inv_1x
    I3_31 (\~R1_31 R1_31) inv_1x
    I3_30 (\~R1_30 R1_30) inv_1x
    I3_29 (\~R1_29 R1_29) inv_1x
    I3_28 (\~R1_28 R1_28) inv_1x
    I3_27 (\~R1_27 R1_27) inv_1x
    I3_26 (\~R1_26 R1_26) inv_1x
    I3_25 (\~R1_25 R1_25) inv_1x
    I3_24 (\~R1_24 R1_24) inv_1x
    I3_23 (\~R1_23 R1_23) inv_1x
    I3_22 (\~R1_22 R1_22) inv_1x
    I3_21 (\~R1_21 R1_21) inv_1x
    I3_20 (\~R1_20 R1_20) inv_1x
    I3_19 (\~R1_19 R1_19) inv_1x
    I3_18 (\~R1_18 R1_18) inv_1x
    I3_17 (\~R1_17 R1_17) inv_1x
    I3_16 (\~R1_16 R1_16) inv_1x
    I3_15 (\~R1_15 R1_15) inv_1x
    I3_14 (\~R1_14 R1_14) inv_1x
    I3_13 (\~R1_13 R1_13) inv_1x
    I3_12 (\~R1_12 R1_12) inv_1x
    I3_11 (\~R1_11 R1_11) inv_1x
    I3_10 (\~R1_10 R1_10) inv_1x
    I3_9 (\~R1_9 R1_9) inv_1x
    I3_8 (\~R1_8 R1_8) inv_1x
    I3_7 (\~R1_7 R1_7) inv_1x
    I3_6 (\~R1_6 R1_6) inv_1x
    I3_5 (\~R1_5 R1_5) inv_1x
    I3_4 (\~R1_4 R1_4) inv_1x
    I3_3 (\~R1_3 R1_3) inv_1x
    I3_2 (\~R1_2 R1_2) inv_1x
    I3_1 (\~R1_1 R1_1) inv_1x
    I3_0 (\~R1_0 R1_0) inv_1x
    I2_31 (\~R0_31 R0_31) inv_1x
    I2_30 (\~R0_30 R0_30) inv_1x
    I2_29 (\~R0_29 R0_29) inv_1x
    I2_28 (\~R0_28 R0_28) inv_1x
    I2_27 (\~R0_27 R0_27) inv_1x
    I2_26 (\~R0_26 R0_26) inv_1x
    I2_25 (\~R0_25 R0_25) inv_1x
    I2_24 (\~R0_24 R0_24) inv_1x
    I2_23 (\~R0_23 R0_23) inv_1x
    I2_22 (\~R0_22 R0_22) inv_1x
    I2_21 (\~R0_21 R0_21) inv_1x
    I2_20 (\~R0_20 R0_20) inv_1x
    I2_19 (\~R0_19 R0_19) inv_1x
    I2_18 (\~R0_18 R0_18) inv_1x
    I2_17 (\~R0_17 R0_17) inv_1x
    I2_16 (\~R0_16 R0_16) inv_1x
    I2_15 (\~R0_15 R0_15) inv_1x
    I2_14 (\~R0_14 R0_14) inv_1x
    I2_13 (\~R0_13 R0_13) inv_1x
    I2_12 (\~R0_12 R0_12) inv_1x
    I2_11 (\~R0_11 R0_11) inv_1x
    I2_10 (\~R0_10 R0_10) inv_1x
    I2_9 (\~R0_9 R0_9) inv_1x
    I2_8 (\~R0_8 R0_8) inv_1x
    I2_7 (\~R0_7 R0_7) inv_1x
    I2_6 (\~R0_6 R0_6) inv_1x
    I2_5 (\~R0_5 R0_5) inv_1x
    I2_4 (\~R0_4 R0_4) inv_1x
    I2_3 (\~R0_3 R0_3) inv_1x
    I2_2 (\~R0_2 R0_2) inv_1x
    I2_1 (\~R0_1 R0_1) inv_1x
    I2_0 (\~R0_0 R0_0) inv_1x
    I1_31 (W1_31 \~W1_31) inv_1x
    I1_30 (W1_30 \~W1_30) inv_1x
    I1_29 (W1_29 \~W1_29) inv_1x
    I1_28 (W1_28 \~W1_28) inv_1x
    I1_27 (W1_27 \~W1_27) inv_1x
    I1_26 (W1_26 \~W1_26) inv_1x
    I1_25 (W1_25 \~W1_25) inv_1x
    I1_24 (W1_24 \~W1_24) inv_1x
    I1_23 (W1_23 \~W1_23) inv_1x
    I1_22 (W1_22 \~W1_22) inv_1x
    I1_21 (W1_21 \~W1_21) inv_1x
    I1_20 (W1_20 \~W1_20) inv_1x
    I1_19 (W1_19 \~W1_19) inv_1x
    I1_18 (W1_18 \~W1_18) inv_1x
    I1_17 (W1_17 \~W1_17) inv_1x
    I1_16 (W1_16 \~W1_16) inv_1x
    I1_15 (W1_15 \~W1_15) inv_1x
    I1_14 (W1_14 \~W1_14) inv_1x
    I1_13 (W1_13 \~W1_13) inv_1x
    I1_12 (W1_12 \~W1_12) inv_1x
    I1_11 (W1_11 \~W1_11) inv_1x
    I1_10 (W1_10 \~W1_10) inv_1x
    I1_9 (W1_9 \~W1_9) inv_1x
    I1_8 (W1_8 \~W1_8) inv_1x
    I1_7 (W1_7 \~W1_7) inv_1x
    I1_6 (W1_6 \~W1_6) inv_1x
    I1_5 (W1_5 \~W1_5) inv_1x
    I1_4 (W1_4 \~W1_4) inv_1x
    I1_3 (W1_3 \~W1_3) inv_1x
    I1_2 (W1_2 \~W1_2) inv_1x
    I1_1 (W1_1 \~W1_1) inv_1x
    I1_0 (W1_0 \~W1_0) inv_1x
    I0_31 (W0_31 \~W0_31) inv_1x
    I0_30 (W0_30 \~W0_30) inv_1x
    I0_29 (W0_29 \~W0_29) inv_1x
    I0_28 (W0_28 \~W0_28) inv_1x
    I0_27 (W0_27 \~W0_27) inv_1x
    I0_26 (W0_26 \~W0_26) inv_1x
    I0_25 (W0_25 \~W0_25) inv_1x
    I0_24 (W0_24 \~W0_24) inv_1x
    I0_23 (W0_23 \~W0_23) inv_1x
    I0_22 (W0_22 \~W0_22) inv_1x
    I0_21 (W0_21 \~W0_21) inv_1x
    I0_20 (W0_20 \~W0_20) inv_1x
    I0_19 (W0_19 \~W0_19) inv_1x
    I0_18 (W0_18 \~W0_18) inv_1x
    I0_17 (W0_17 \~W0_17) inv_1x
    I0_16 (W0_16 \~W0_16) inv_1x
    I0_15 (W0_15 \~W0_15) inv_1x
    I0_14 (W0_14 \~W0_14) inv_1x
    I0_13 (W0_13 \~W0_13) inv_1x
    I0_12 (W0_12 \~W0_12) inv_1x
    I0_11 (W0_11 \~W0_11) inv_1x
    I0_10 (W0_10 \~W0_10) inv_1x
    I0_9 (W0_9 \~W0_9) inv_1x
    I0_8 (W0_8 \~W0_8) inv_1x
    I0_7 (W0_7 \~W0_7) inv_1x
    I0_6 (W0_6 \~W0_6) inv_1x
    I0_5 (W0_5 \~W0_5) inv_1x
    I0_4 (W0_4 \~W0_4) inv_1x
    I0_3 (W0_3 \~W0_3) inv_1x
    I0_2 (W0_2 \~W0_2) inv_1x
    I0_1 (W0_1 \~W0_1) inv_1x
    I0_0 (W0_0 \~W0_0) inv_1x
    I5_31 (\~R0_31 \~R1_31 Rnand_31) nand_1x
    I5_30 (\~R0_30 \~R1_30 Rnand_30) nand_1x
    I5_29 (\~R0_29 \~R1_29 Rnand_29) nand_1x
    I5_28 (\~R0_28 \~R1_28 Rnand_28) nand_1x
    I5_27 (\~R0_27 \~R1_27 Rnand_27) nand_1x
    I5_26 (\~R0_26 \~R1_26 Rnand_26) nand_1x
    I5_25 (\~R0_25 \~R1_25 Rnand_25) nand_1x
    I5_24 (\~R0_24 \~R1_24 Rnand_24) nand_1x
    I5_23 (\~R0_23 \~R1_23 Rnand_23) nand_1x
    I5_22 (\~R0_22 \~R1_22 Rnand_22) nand_1x
    I5_21 (\~R0_21 \~R1_21 Rnand_21) nand_1x
    I5_20 (\~R0_20 \~R1_20 Rnand_20) nand_1x
    I5_19 (\~R0_19 \~R1_19 Rnand_19) nand_1x
    I5_18 (\~R0_18 \~R1_18 Rnand_18) nand_1x
    I5_17 (\~R0_17 \~R1_17 Rnand_17) nand_1x
    I5_16 (\~R0_16 \~R1_16 Rnand_16) nand_1x
    I5_15 (\~R0_15 \~R1_15 Rnand_15) nand_1x
    I5_14 (\~R0_14 \~R1_14 Rnand_14) nand_1x
    I5_13 (\~R0_13 \~R1_13 Rnand_13) nand_1x
    I5_12 (\~R0_12 \~R1_12 Rnand_12) nand_1x
    I5_11 (\~R0_11 \~R1_11 Rnand_11) nand_1x
    I5_10 (\~R0_10 \~R1_10 Rnand_10) nand_1x
    I5_9 (\~R0_9 \~R1_9 Rnand_9) nand_1x
    I5_8 (\~R0_8 \~R1_8 Rnand_8) nand_1x
    I5_7 (\~R0_7 \~R1_7 Rnand_7) nand_1x
    I5_6 (\~R0_6 \~R1_6 Rnand_6) nand_1x
    I5_5 (\~R0_5 \~R1_5 Rnand_5) nand_1x
    I5_4 (\~R0_4 \~R1_4 Rnand_4) nand_1x
    I5_3 (\~R0_3 \~R1_3 Rnand_3) nand_1x
    I5_2 (\~R0_2 \~R1_2 Rnand_2) nand_1x
    I5_1 (\~R0_1 \~R1_1 Rnand_1) nand_1x
    I5_0 (\~R0_0 \~R1_0 Rnand_0) nand_1x
    I4_31 (\~W0_31 \~W1_31 Wnand_31) nand_1x
    I4_30 (\~W0_30 \~W1_30 Wnand_30) nand_1x
    I4_29 (\~W0_29 \~W1_29 Wnand_29) nand_1x
    I4_28 (\~W0_28 \~W1_28 Wnand_28) nand_1x
    I4_27 (\~W0_27 \~W1_27 Wnand_27) nand_1x
    I4_26 (\~W0_26 \~W1_26 Wnand_26) nand_1x
    I4_25 (\~W0_25 \~W1_25 Wnand_25) nand_1x
    I4_24 (\~W0_24 \~W1_24 Wnand_24) nand_1x
    I4_23 (\~W0_23 \~W1_23 Wnand_23) nand_1x
    I4_22 (\~W0_22 \~W1_22 Wnand_22) nand_1x
    I4_21 (\~W0_21 \~W1_21 Wnand_21) nand_1x
    I4_20 (\~W0_20 \~W1_20 Wnand_20) nand_1x
    I4_19 (\~W0_19 \~W1_19 Wnand_19) nand_1x
    I4_18 (\~W0_18 \~W1_18 Wnand_18) nand_1x
    I4_17 (\~W0_17 \~W1_17 Wnand_17) nand_1x
    I4_16 (\~W0_16 \~W1_16 Wnand_16) nand_1x
    I4_15 (\~W0_15 \~W1_15 Wnand_15) nand_1x
    I4_14 (\~W0_14 \~W1_14 Wnand_14) nand_1x
    I4_13 (\~W0_13 \~W1_13 Wnand_13) nand_1x
    I4_12 (\~W0_12 \~W1_12 Wnand_12) nand_1x
    I4_11 (\~W0_11 \~W1_11 Wnand_11) nand_1x
    I4_10 (\~W0_10 \~W1_10 Wnand_10) nand_1x
    I4_9 (\~W0_9 \~W1_9 Wnand_9) nand_1x
    I4_8 (\~W0_8 \~W1_8 Wnand_8) nand_1x
    I4_7 (\~W0_7 \~W1_7 Wnand_7) nand_1x
    I4_6 (\~W0_6 \~W1_6 Wnand_6) nand_1x
    I4_5 (\~W0_5 \~W1_5 Wnand_5) nand_1x
    I4_4 (\~W0_4 \~W1_4 Wnand_4) nand_1x
    I4_3 (\~W0_3 \~W1_3 Wnand_3) nand_1x
    I4_2 (\~W0_2 \~W1_2 Wnand_2) nand_1x
    I4_1 (\~W0_1 \~W1_1 Wnand_1) nand_1x
    I4_0 (\~W0_0 \~W1_0 Wnand_0) nand_1x
    I68 (Rnand_0 Rnand_1 Rnand_2 Rnand_3 Rv_0) TH44
    I65 (Rnand_4 Rnand_5 Rnand_6 Rnand_7 Rv_1) TH44
    I62 (\~KRe_0 \~KRe_1 \~KRe_2 \~KRe_3 net088) TH44
    I61 (Rnand_8 Rnand_9 Rnand_10 Rnand_11 Rv_2) TH44
    I58 (Rnand_12 Rnand_13 Rnand_14 Rnand_15 Rv_3) TH44
    I54 (Rnand_16 Rnand_17 Rnand_18 Rnand_19 Rv_4) TH44
    I51 (Rnand_20 Rnand_21 Rnand_22 Rnand_23 Rv_5) TH44
    I48 (\~KRe_4 \~KRe_5 \~KRe_6 \~KRe_7 net087) TH44
    I47 (Rnand_24 Rnand_25 Rnand_26 Rnand_27 Rv_6) TH44
    I44 (Rnand_28 Rnand_29 Rnand_30 Rnand_31 Rv_7) TH44
    I39 (\~KWe_4 \~KWe_5 \~KWe_6 \~KWe_7 net089) TH44
    I38 (\~KWe_0 \~KWe_1 \~KWe_2 \~KWe_3 net090) TH44
    I13 (Wnand_28 Wnand_29 Wnand_30 Wnand_31 Wv_7) TH44
    I12 (Wnand_24 Wnand_25 Wnand_26 Wnand_27 Wv_6) TH44
    I11 (Wnand_20 Wnand_21 Wnand_22 Wnand_23 Wv_5) TH44
    I10 (Wnand_16 Wnand_17 Wnand_18 Wnand_19 Wv_4) TH44
    I9 (Wnand_12 Wnand_13 Wnand_14 Wnand_15 Wv_3) TH44
    I8 (Wnand_8 Wnand_9 Wnand_10 Wnand_11 Wv_2) TH44
    I7 (Wnand_4 Wnand_5 Wnand_6 Wnand_7 Wv_1) TH44
    I6 (Wnand_0 Wnand_1 Wnand_2 Wnand_3 Wv_0) TH44
    I67 (KRv Rv_0 KRve_0) TH22
    I64 (KRv Rv_1 KRve_1) TH22
    I60 (KRv Rv_2 KRve_2) TH22
    I57 (KRv Rv_3 KRve_3) TH22
    I53 (KRv Rv_4 KRve_4) TH22
    I50 (KRv Rv_5 KRve_5) TH22
    I46 (KRv Rv_6 KRve_6) TH22
    I43 (KRv Rv_7 KRve_7) TH22
    I23 (Wv_1 KWv KWve_1) TH22
    I24 (Wv_2 KWv KWve_2) TH22
    I25 (Wv_3 KWv KWve_3) TH22
    I26 (Wv_4 KWv KWve_4) TH22
    I22 (Wv_0 KWv KWve_0) TH22
    I27 (Wv_5 KWv KWve_5) TH22
    I28 (Wv_6 KWv KWve_6) TH22
    I29 (Wv_7 KWv KWve_7) TH22
    I55 (net088 net087 KRe) _sub160
    I41 (net090 net089 KWe) _sub160
ends _sub161

// 16nm/10T/schematic
//system verilogNetlist schematic cmos.sch cmos_sch veriloga ahdl
subckt _sub162 JRi JWi \~R0 \~R1 \~W0 \~W1
    I3 (Q Qb) inv_1x
    I1 (Qb Q) inv_1x
    M1 (\~R1 JRi net023 0) nfet w=40n l=16n m=1
    M0 (Qb JWi \~W0 0) nfet w=40n l=16n m=1
    M2 (net023 Qb 0 0) nfet w=40n l=16n m=1
    M5 (\~R0 JRi net020 0) nfet w=40n l=16n m=1
    M3 (net020 Q 0 0) nfet w=40n l=16n m=1
    M4 (Q JWi \~W1 0) nfet w=40n l=16n m=1
ends _sub162

// 16nm/10T_4x/schematic
//system verilogNetlist schematic cmos.sch cmos_sch veriloga ahdl
subckt _sub163 JRi JWi \~R0_3 \~R0_2 \~R0_1 \~R0_0 \~R1_3 \~R1_2 \~R1_1 \~R1_0 \~W0_3 \~W0_2 \~W0_1 \~W0_0 \~W1_3 \~W1_2 \~W1_1 \~W1_0
    I3 (JRi JWi \~R0_0 \~R1_0 \~W0_0 \~W1_0) _sub162
    I2 (JRi JWi \~R0_1 \~R1_1 \~W0_1 \~W1_1) _sub162
    I1 (JRi JWi \~R0_2 \~R1_2 \~W0_2 \~W1_2) _sub162
    I0 (JRi JWi \~R0_3 \~R1_3 \~W0_3 \~W1_3) _sub162
ends _sub163

// 16nm/10T_32x32/schematic
//system verilogNetlist schematic cmos.sch cmos_sch veriloga ahdl
subckt _sub164 JR_31 JR_30 JR_29 JR_28 JR_27 JR_26 JR_25 JR_24 JR_23 JR_22 JR_21 JR_20 JR_19 JR_18 JR_17 JR_16 JR_15 JR_14 JR_13 JR_12 JR_11 JR_10 JR_9 JR_8 JR_7 JR_6 JR_5 JR_4 JR_3 JR_2 JR_1 JR_0 JW_31 JW_30 JW_29 JW_28 JW_27 JW_26 JW_25 JW_24 JW_23 JW_22 JW_21 JW_20 JW_19 JW_18 JW_17 JW_16 JW_15 JW_14 JW_13 JW_12 JW_11 JW_10 JW_9 JW_8 JW_7 JW_6 JW_5 JW_4 JW_3 JW_2 JW_1 JW_0 \~R0_31 \~R0_30 \~R0_29 \~R0_28 \~R0_27 \~R0_26 \~R0_25 \~R0_24 \~R0_23 \~R0_22 \~R0_21 \~R0_20 \~R0_19 \~R0_18 \~R0_17 \~R0_16 \~R0_15 \~R0_14 \~R0_13 \~R0_12 \~R0_11 \~R0_10 \~R0_9 \~R0_8 \~R0_7 \~R0_6 \~R0_5 \~R0_4 \~R0_3 \~R0_2 \~R0_1 \~R0_0 \~R1_31 \~R1_30 \~R1_29 \~R1_28 \~R1_27 \~R1_26 \~R1_25 \~R1_24 \~R1_23 \~R1_22 \~R1_21 \~R1_20 \~R1_19 \~R1_18 \~R1_17 \~R1_16 \~R1_15 \~R1_14 \~R1_13 \~R1_12 \~R1_11 \~R1_10 \~R1_9 \~R1_8 \~R1_7 \~R1_6 \~R1_5 \~R1_4 \~R1_3 \~R1_2 \~R1_1 \~R1_0 \~W0_31 \~W0_30 \~W0_29 \~W0_28 \~W0_27 \~W0_26 \~W0_25 \~W0_24 \~W0_23 \~W0_22 \~W0_21 \~W0_20 \~W0_19 \~W0_18 \~W0_17 \~W0_16 \~W0_15 \~W0_14 \~W0_13 \~W0_12 \~W0_11 \~W0_10 \~W0_9 \~W0_8 \~W0_7 \~W0_6 \~W0_5 \~W0_4 \~W0_3 \~W0_2 \~W0_1 \~W0_0 \~W1_31 \~W1_30 \~W1_29 \~W1_28 \~W1_27 \~W1_26 \~W1_25 \~W1_24 \~W1_23 \~W1_22 \~W1_21 \~W1_20 \~W1_19 \~W1_18 \~W1_17 \~W1_16 \~W1_15 \~W1_14 \~W1_13 \~W1_12 \~W1_11 \~W1_10 \~W1_9 \~W1_8 \~W1_7 \~W1_6 \~W1_5 \~W1_4 \~W1_3 \~W1_2 \~W1_1 \~W1_0
    I255 (JR_31 JW_31 \~R0_3 \~R0_2 \~R0_1 \~R0_0 \~R1_3 \~R1_2 \~R1_1 \~R1_0 \~W0_3 \~W0_2 \~W0_1 \~W0_0 \~W1_3 \~W1_2 \~W1_1 \~W1_0) _sub163
    I247 (JR_30 JW_30 \~R0_3 \~R0_2 \~R0_1 \~R0_0 \~R1_3 \~R1_2 \~R1_1 \~R1_0 \~W0_3 \~W0_2 \~W0_1 \~W0_0 \~W1_3 \~W1_2 \~W1_1 \~W1_0) _sub163
    I239 (JR_29 JW_29 \~R0_3 \~R0_2 \~R0_1 \~R0_0 \~R1_3 \~R1_2 \~R1_1 \~R1_0 \~W0_3 \~W0_2 \~W0_1 \~W0_0 \~W1_3 \~W1_2 \~W1_1 \~W1_0) _sub163
    I231 (JR_28 JW_28 \~R0_3 \~R0_2 \~R0_1 \~R0_0 \~R1_3 \~R1_2 \~R1_1 \~R1_0 \~W0_3 \~W0_2 \~W0_1 \~W0_0 \~W1_3 \~W1_2 \~W1_1 \~W1_0) _sub163
    I223 (JR_27 JW_27 \~R0_3 \~R0_2 \~R0_1 \~R0_0 \~R1_3 \~R1_2 \~R1_1 \~R1_0 \~W0_3 \~W0_2 \~W0_1 \~W0_0 \~W1_3 \~W1_2 \~W1_1 \~W1_0) _sub163
    I215 (JR_26 JW_26 \~R0_3 \~R0_2 \~R0_1 \~R0_0 \~R1_3 \~R1_2 \~R1_1 \~R1_0 \~W0_3 \~W0_2 \~W0_1 \~W0_0 \~W1_3 \~W1_2 \~W1_1 \~W1_0) _sub163
    I207 (JR_25 JW_25 \~R0_3 \~R0_2 \~R0_1 \~R0_0 \~R1_3 \~R1_2 \~R1_1 \~R1_0 \~W0_3 \~W0_2 \~W0_1 \~W0_0 \~W1_3 \~W1_2 \~W1_1 \~W1_0) _sub163
    I199 (JR_24 JW_24 \~R0_3 \~R0_2 \~R0_1 \~R0_0 \~R1_3 \~R1_2 \~R1_1 \~R1_0 \~W0_3 \~W0_2 \~W0_1 \~W0_0 \~W1_3 \~W1_2 \~W1_1 \~W1_0) _sub163
    I191 (JR_23 JW_23 \~R0_3 \~R0_2 \~R0_1 \~R0_0 \~R1_3 \~R1_2 \~R1_1 \~R1_0 \~W0_3 \~W0_2 \~W0_1 \~W0_0 \~W1_3 \~W1_2 \~W1_1 \~W1_0) _sub163
    I183 (JR_22 JW_22 \~R0_3 \~R0_2 \~R0_1 \~R0_0 \~R1_3 \~R1_2 \~R1_1 \~R1_0 \~W0_3 \~W0_2 \~W0_1 \~W0_0 \~W1_3 \~W1_2 \~W1_1 \~W1_0) _sub163
    I175 (JR_21 JW_21 \~R0_3 \~R0_2 \~R0_1 \~R0_0 \~R1_3 \~R1_2 \~R1_1 \~R1_0 \~W0_3 \~W0_2 \~W0_1 \~W0_0 \~W1_3 \~W1_2 \~W1_1 \~W1_0) _sub163
    I167 (JR_20 JW_20 \~R0_3 \~R0_2 \~R0_1 \~R0_0 \~R1_3 \~R1_2 \~R1_1 \~R1_0 \~W0_3 \~W0_2 \~W0_1 \~W0_0 \~W1_3 \~W1_2 \~W1_1 \~W1_0) _sub163
    I159 (JR_19 JW_19 \~R0_3 \~R0_2 \~R0_1 \~R0_0 \~R1_3 \~R1_2 \~R1_1 \~R1_0 \~W0_3 \~W0_2 \~W0_1 \~W0_0 \~W1_3 \~W1_2 \~W1_1 \~W1_0) _sub163
    I151 (JR_18 JW_18 \~R0_3 \~R0_2 \~R0_1 \~R0_0 \~R1_3 \~R1_2 \~R1_1 \~R1_0 \~W0_3 \~W0_2 \~W0_1 \~W0_0 \~W1_3 \~W1_2 \~W1_1 \~W1_0) _sub163
    I143 (JR_17 JW_17 \~R0_3 \~R0_2 \~R0_1 \~R0_0 \~R1_3 \~R1_2 \~R1_1 \~R1_0 \~W0_3 \~W0_2 \~W0_1 \~W0_0 \~W1_3 \~W1_2 \~W1_1 \~W1_0) _sub163
    I135 (JR_16 JW_16 \~R0_3 \~R0_2 \~R0_1 \~R0_0 \~R1_3 \~R1_2 \~R1_1 \~R1_0 \~W0_3 \~W0_2 \~W0_1 \~W0_0 \~W1_3 \~W1_2 \~W1_1 \~W1_0) _sub163
    I127 (JR_15 JW_15 \~R0_3 \~R0_2 \~R0_1 \~R0_0 \~R1_3 \~R1_2 \~R1_1 \~R1_0 \~W0_3 \~W0_2 \~W0_1 \~W0_0 \~W1_3 \~W1_2 \~W1_1 \~W1_0) _sub163
    I119 (JR_14 JW_14 \~R0_3 \~R0_2 \~R0_1 \~R0_0 \~R1_3 \~R1_2 \~R1_1 \~R1_0 \~W0_3 \~W0_2 \~W0_1 \~W0_0 \~W1_3 \~W1_2 \~W1_1 \~W1_0) _sub163
    I111 (JR_13 JW_13 \~R0_3 \~R0_2 \~R0_1 \~R0_0 \~R1_3 \~R1_2 \~R1_1 \~R1_0 \~W0_3 \~W0_2 \~W0_1 \~W0_0 \~W1_3 \~W1_2 \~W1_1 \~W1_0) _sub163
    I103 (JR_12 JW_12 \~R0_3 \~R0_2 \~R0_1 \~R0_0 \~R1_3 \~R1_2 \~R1_1 \~R1_0 \~W0_3 \~W0_2 \~W0_1 \~W0_0 \~W1_3 \~W1_2 \~W1_1 \~W1_0) _sub163
    I95 (JR_11 JW_11 \~R0_3 \~R0_2 \~R0_1 \~R0_0 \~R1_3 \~R1_2 \~R1_1 \~R1_0 \~W0_3 \~W0_2 \~W0_1 \~W0_0 \~W1_3 \~W1_2 \~W1_1 \~W1_0) _sub163
    I87 (JR_10 JW_10 \~R0_3 \~R0_2 \~R0_1 \~R0_0 \~R1_3 \~R1_2 \~R1_1 \~R1_0 \~W0_3 \~W0_2 \~W0_1 \~W0_0 \~W1_3 \~W1_2 \~W1_1 \~W1_0) _sub163
    I79 (JR_9 JW_9 \~R0_3 \~R0_2 \~R0_1 \~R0_0 \~R1_3 \~R1_2 \~R1_1 \~R1_0 \~W0_3 \~W0_2 \~W0_1 \~W0_0 \~W1_3 \~W1_2 \~W1_1 \~W1_0) _sub163
    I71 (JR_8 JW_8 \~R0_3 \~R0_2 \~R0_1 \~R0_0 \~R1_3 \~R1_2 \~R1_1 \~R1_0 \~W0_3 \~W0_2 \~W0_1 \~W0_0 \~W1_3 \~W1_2 \~W1_1 \~W1_0) _sub163
    I63 (JR_7 JW_7 \~R0_3 \~R0_2 \~R0_1 \~R0_0 \~R1_3 \~R1_2 \~R1_1 \~R1_0 \~W0_3 \~W0_2 \~W0_1 \~W0_0 \~W1_3 \~W1_2 \~W1_1 \~W1_0) _sub163
    I55 (JR_6 JW_6 \~R0_3 \~R0_2 \~R0_1 \~R0_0 \~R1_3 \~R1_2 \~R1_1 \~R1_0 \~W0_3 \~W0_2 \~W0_1 \~W0_0 \~W1_3 \~W1_2 \~W1_1 \~W1_0) _sub163
    I47 (JR_5 JW_5 \~R0_3 \~R0_2 \~R0_1 \~R0_0 \~R1_3 \~R1_2 \~R1_1 \~R1_0 \~W0_3 \~W0_2 \~W0_1 \~W0_0 \~W1_3 \~W1_2 \~W1_1 \~W1_0) _sub163
    I39 (JR_4 JW_4 \~R0_3 \~R0_2 \~R0_1 \~R0_0 \~R1_3 \~R1_2 \~R1_1 \~R1_0 \~W0_3 \~W0_2 \~W0_1 \~W0_0 \~W1_3 \~W1_2 \~W1_1 \~W1_0) _sub163
    I31 (JR_3 JW_3 \~R0_3 \~R0_2 \~R0_1 \~R0_0 \~R1_3 \~R1_2 \~R1_1 \~R1_0 \~W0_3 \~W0_2 \~W0_1 \~W0_0 \~W1_3 \~W1_2 \~W1_1 \~W1_0) _sub163
    I23 (JR_2 JW_2 \~R0_3 \~R0_2 \~R0_1 \~R0_0 \~R1_3 \~R1_2 \~R1_1 \~R1_0 \~W0_3 \~W0_2 \~W0_1 \~W0_0 \~W1_3 \~W1_2 \~W1_1 \~W1_0) _sub163
    I15 (JR_1 JW_1 \~R0_3 \~R0_2 \~R0_1 \~R0_0 \~R1_3 \~R1_2 \~R1_1 \~R1_0 \~W0_3 \~W0_2 \~W0_1 \~W0_0 \~W1_3 \~W1_2 \~W1_1 \~W1_0) _sub163
    I254 (JR_31 JW_31 \~R0_7 \~R0_6 \~R0_5 \~R0_4 \~R1_7 \~R1_6 \~R1_5 \~R1_4 \~W0_7 \~W0_6 \~W0_5 \~W0_4 \~W1_7 \~W1_6 \~W1_5 \~W1_4) _sub163
    I246 (JR_30 JW_30 \~R0_7 \~R0_6 \~R0_5 \~R0_4 \~R1_7 \~R1_6 \~R1_5 \~R1_4 \~W0_7 \~W0_6 \~W0_5 \~W0_4 \~W1_7 \~W1_6 \~W1_5 \~W1_4) _sub163
    I238 (JR_29 JW_29 \~R0_7 \~R0_6 \~R0_5 \~R0_4 \~R1_7 \~R1_6 \~R1_5 \~R1_4 \~W0_7 \~W0_6 \~W0_5 \~W0_4 \~W1_7 \~W1_6 \~W1_5 \~W1_4) _sub163
    I230 (JR_28 JW_28 \~R0_7 \~R0_6 \~R0_5 \~R0_4 \~R1_7 \~R1_6 \~R1_5 \~R1_4 \~W0_7 \~W0_6 \~W0_5 \~W0_4 \~W1_7 \~W1_6 \~W1_5 \~W1_4) _sub163
    I222 (JR_27 JW_27 \~R0_7 \~R0_6 \~R0_5 \~R0_4 \~R1_7 \~R1_6 \~R1_5 \~R1_4 \~W0_7 \~W0_6 \~W0_5 \~W0_4 \~W1_7 \~W1_6 \~W1_5 \~W1_4) _sub163
    I214 (JR_26 JW_26 \~R0_7 \~R0_6 \~R0_5 \~R0_4 \~R1_7 \~R1_6 \~R1_5 \~R1_4 \~W0_7 \~W0_6 \~W0_5 \~W0_4 \~W1_7 \~W1_6 \~W1_5 \~W1_4) _sub163
    I206 (JR_25 JW_25 \~R0_7 \~R0_6 \~R0_5 \~R0_4 \~R1_7 \~R1_6 \~R1_5 \~R1_4 \~W0_7 \~W0_6 \~W0_5 \~W0_4 \~W1_7 \~W1_6 \~W1_5 \~W1_4) _sub163
    I198 (JR_24 JW_24 \~R0_7 \~R0_6 \~R0_5 \~R0_4 \~R1_7 \~R1_6 \~R1_5 \~R1_4 \~W0_7 \~W0_6 \~W0_5 \~W0_4 \~W1_7 \~W1_6 \~W1_5 \~W1_4) _sub163
    I190 (JR_23 JW_23 \~R0_7 \~R0_6 \~R0_5 \~R0_4 \~R1_7 \~R1_6 \~R1_5 \~R1_4 \~W0_7 \~W0_6 \~W0_5 \~W0_4 \~W1_7 \~W1_6 \~W1_5 \~W1_4) _sub163
    I182 (JR_22 JW_22 \~R0_7 \~R0_6 \~R0_5 \~R0_4 \~R1_7 \~R1_6 \~R1_5 \~R1_4 \~W0_7 \~W0_6 \~W0_5 \~W0_4 \~W1_7 \~W1_6 \~W1_5 \~W1_4) _sub163
    I174 (JR_21 JW_21 \~R0_7 \~R0_6 \~R0_5 \~R0_4 \~R1_7 \~R1_6 \~R1_5 \~R1_4 \~W0_7 \~W0_6 \~W0_5 \~W0_4 \~W1_7 \~W1_6 \~W1_5 \~W1_4) _sub163
    I166 (JR_20 JW_20 \~R0_7 \~R0_6 \~R0_5 \~R0_4 \~R1_7 \~R1_6 \~R1_5 \~R1_4 \~W0_7 \~W0_6 \~W0_5 \~W0_4 \~W1_7 \~W1_6 \~W1_5 \~W1_4) _sub163
    I158 (JR_19 JW_19 \~R0_7 \~R0_6 \~R0_5 \~R0_4 \~R1_7 \~R1_6 \~R1_5 \~R1_4 \~W0_7 \~W0_6 \~W0_5 \~W0_4 \~W1_7 \~W1_6 \~W1_5 \~W1_4) _sub163
    I150 (JR_18 JW_18 \~R0_7 \~R0_6 \~R0_5 \~R0_4 \~R1_7 \~R1_6 \~R1_5 \~R1_4 \~W0_7 \~W0_6 \~W0_5 \~W0_4 \~W1_7 \~W1_6 \~W1_5 \~W1_4) _sub163
    I142 (JR_17 JW_17 \~R0_7 \~R0_6 \~R0_5 \~R0_4 \~R1_7 \~R1_6 \~R1_5 \~R1_4 \~W0_7 \~W0_6 \~W0_5 \~W0_4 \~W1_7 \~W1_6 \~W1_5 \~W1_4) _sub163
    I134 (JR_16 JW_16 \~R0_7 \~R0_6 \~R0_5 \~R0_4 \~R1_7 \~R1_6 \~R1_5 \~R1_4 \~W0_7 \~W0_6 \~W0_5 \~W0_4 \~W1_7 \~W1_6 \~W1_5 \~W1_4) _sub163
    I126 (JR_15 JW_15 \~R0_7 \~R0_6 \~R0_5 \~R0_4 \~R1_7 \~R1_6 \~R1_5 \~R1_4 \~W0_7 \~W0_6 \~W0_5 \~W0_4 \~W1_7 \~W1_6 \~W1_5 \~W1_4) _sub163
    I118 (JR_14 JW_14 \~R0_7 \~R0_6 \~R0_5 \~R0_4 \~R1_7 \~R1_6 \~R1_5 \~R1_4 \~W0_7 \~W0_6 \~W0_5 \~W0_4 \~W1_7 \~W1_6 \~W1_5 \~W1_4) _sub163
    I110 (JR_13 JW_13 \~R0_7 \~R0_6 \~R0_5 \~R0_4 \~R1_7 \~R1_6 \~R1_5 \~R1_4 \~W0_7 \~W0_6 \~W0_5 \~W0_4 \~W1_7 \~W1_6 \~W1_5 \~W1_4) _sub163
    I102 (JR_12 JW_12 \~R0_7 \~R0_6 \~R0_5 \~R0_4 \~R1_7 \~R1_6 \~R1_5 \~R1_4 \~W0_7 \~W0_6 \~W0_5 \~W0_4 \~W1_7 \~W1_6 \~W1_5 \~W1_4) _sub163
    I94 (JR_11 JW_11 \~R0_7 \~R0_6 \~R0_5 \~R0_4 \~R1_7 \~R1_6 \~R1_5 \~R1_4 \~W0_7 \~W0_6 \~W0_5 \~W0_4 \~W1_7 \~W1_6 \~W1_5 \~W1_4) _sub163
    I86 (JR_10 JW_10 \~R0_7 \~R0_6 \~R0_5 \~R0_4 \~R1_7 \~R1_6 \~R1_5 \~R1_4 \~W0_7 \~W0_6 \~W0_5 \~W0_4 \~W1_7 \~W1_6 \~W1_5 \~W1_4) _sub163
    I78 (JR_9 JW_9 \~R0_7 \~R0_6 \~R0_5 \~R0_4 \~R1_7 \~R1_6 \~R1_5 \~R1_4 \~W0_7 \~W0_6 \~W0_5 \~W0_4 \~W1_7 \~W1_6 \~W1_5 \~W1_4) _sub163
    I70 (JR_8 JW_8 \~R0_7 \~R0_6 \~R0_5 \~R0_4 \~R1_7 \~R1_6 \~R1_5 \~R1_4 \~W0_7 \~W0_6 \~W0_5 \~W0_4 \~W1_7 \~W1_6 \~W1_5 \~W1_4) _sub163
    I62 (JR_7 JW_7 \~R0_7 \~R0_6 \~R0_5 \~R0_4 \~R1_7 \~R1_6 \~R1_5 \~R1_4 \~W0_7 \~W0_6 \~W0_5 \~W0_4 \~W1_7 \~W1_6 \~W1_5 \~W1_4) _sub163
    I54 (JR_6 JW_6 \~R0_7 \~R0_6 \~R0_5 \~R0_4 \~R1_7 \~R1_6 \~R1_5 \~R1_4 \~W0_7 \~W0_6 \~W0_5 \~W0_4 \~W1_7 \~W1_6 \~W1_5 \~W1_4) _sub163
    I46 (JR_5 JW_5 \~R0_7 \~R0_6 \~R0_5 \~R0_4 \~R1_7 \~R1_6 \~R1_5 \~R1_4 \~W0_7 \~W0_6 \~W0_5 \~W0_4 \~W1_7 \~W1_6 \~W1_5 \~W1_4) _sub163
    I38 (JR_4 JW_4 \~R0_7 \~R0_6 \~R0_5 \~R0_4 \~R1_7 \~R1_6 \~R1_5 \~R1_4 \~W0_7 \~W0_6 \~W0_5 \~W0_4 \~W1_7 \~W1_6 \~W1_5 \~W1_4) _sub163
    I30 (JR_3 JW_3 \~R0_7 \~R0_6 \~R0_5 \~R0_4 \~R1_7 \~R1_6 \~R1_5 \~R1_4 \~W0_7 \~W0_6 \~W0_5 \~W0_4 \~W1_7 \~W1_6 \~W1_5 \~W1_4) _sub163
    I22 (JR_2 JW_2 \~R0_7 \~R0_6 \~R0_5 \~R0_4 \~R1_7 \~R1_6 \~R1_5 \~R1_4 \~W0_7 \~W0_6 \~W0_5 \~W0_4 \~W1_7 \~W1_6 \~W1_5 \~W1_4) _sub163
    I14 (JR_1 JW_1 \~R0_7 \~R0_6 \~R0_5 \~R0_4 \~R1_7 \~R1_6 \~R1_5 \~R1_4 \~W0_7 \~W0_6 \~W0_5 \~W0_4 \~W1_7 \~W1_6 \~W1_5 \~W1_4) _sub163
    I253 (JR_31 JW_31 \~R0_11 \~R0_10 \~R0_9 \~R0_8 \~R1_11 \~R1_10 \~R1_9 \~R1_8 \~W0_11 \~W0_10 \~W0_9 \~W0_8 \~W1_11 \~W1_10 \~W1_9 \~W1_8) _sub163
    I245 (JR_30 JW_30 \~R0_11 \~R0_10 \~R0_9 \~R0_8 \~R1_11 \~R1_10 \~R1_9 \~R1_8 \~W0_11 \~W0_10 \~W0_9 \~W0_8 \~W1_11 \~W1_10 \~W1_9 \~W1_8) _sub163
    I237 (JR_29 JW_29 \~R0_11 \~R0_10 \~R0_9 \~R0_8 \~R1_11 \~R1_10 \~R1_9 \~R1_8 \~W0_11 \~W0_10 \~W0_9 \~W0_8 \~W1_11 \~W1_10 \~W1_9 \~W1_8) _sub163
    I229 (JR_28 JW_28 \~R0_11 \~R0_10 \~R0_9 \~R0_8 \~R1_11 \~R1_10 \~R1_9 \~R1_8 \~W0_11 \~W0_10 \~W0_9 \~W0_8 \~W1_11 \~W1_10 \~W1_9 \~W1_8) _sub163
    I221 (JR_27 JW_27 \~R0_11 \~R0_10 \~R0_9 \~R0_8 \~R1_11 \~R1_10 \~R1_9 \~R1_8 \~W0_11 \~W0_10 \~W0_9 \~W0_8 \~W1_11 \~W1_10 \~W1_9 \~W1_8) _sub163
    I213 (JR_26 JW_26 \~R0_11 \~R0_10 \~R0_9 \~R0_8 \~R1_11 \~R1_10 \~R1_9 \~R1_8 \~W0_11 \~W0_10 \~W0_9 \~W0_8 \~W1_11 \~W1_10 \~W1_9 \~W1_8) _sub163
    I205 (JR_25 JW_25 \~R0_11 \~R0_10 \~R0_9 \~R0_8 \~R1_11 \~R1_10 \~R1_9 \~R1_8 \~W0_11 \~W0_10 \~W0_9 \~W0_8 \~W1_11 \~W1_10 \~W1_9 \~W1_8) _sub163
    I197 (JR_24 JW_24 \~R0_11 \~R0_10 \~R0_9 \~R0_8 \~R1_11 \~R1_10 \~R1_9 \~R1_8 \~W0_11 \~W0_10 \~W0_9 \~W0_8 \~W1_11 \~W1_10 \~W1_9 \~W1_8) _sub163
    I189 (JR_23 JW_23 \~R0_11 \~R0_10 \~R0_9 \~R0_8 \~R1_11 \~R1_10 \~R1_9 \~R1_8 \~W0_11 \~W0_10 \~W0_9 \~W0_8 \~W1_11 \~W1_10 \~W1_9 \~W1_8) _sub163
    I181 (JR_22 JW_22 \~R0_11 \~R0_10 \~R0_9 \~R0_8 \~R1_11 \~R1_10 \~R1_9 \~R1_8 \~W0_11 \~W0_10 \~W0_9 \~W0_8 \~W1_11 \~W1_10 \~W1_9 \~W1_8) _sub163
    I173 (JR_21 JW_21 \~R0_11 \~R0_10 \~R0_9 \~R0_8 \~R1_11 \~R1_10 \~R1_9 \~R1_8 \~W0_11 \~W0_10 \~W0_9 \~W0_8 \~W1_11 \~W1_10 \~W1_9 \~W1_8) _sub163
    I165 (JR_20 JW_20 \~R0_11 \~R0_10 \~R0_9 \~R0_8 \~R1_11 \~R1_10 \~R1_9 \~R1_8 \~W0_11 \~W0_10 \~W0_9 \~W0_8 \~W1_11 \~W1_10 \~W1_9 \~W1_8) _sub163
    I157 (JR_19 JW_19 \~R0_11 \~R0_10 \~R0_9 \~R0_8 \~R1_11 \~R1_10 \~R1_9 \~R1_8 \~W0_11 \~W0_10 \~W0_9 \~W0_8 \~W1_11 \~W1_10 \~W1_9 \~W1_8) _sub163
    I149 (JR_18 JW_18 \~R0_11 \~R0_10 \~R0_9 \~R0_8 \~R1_11 \~R1_10 \~R1_9 \~R1_8 \~W0_11 \~W0_10 \~W0_9 \~W0_8 \~W1_11 \~W1_10 \~W1_9 \~W1_8) _sub163
    I141 (JR_17 JW_17 \~R0_11 \~R0_10 \~R0_9 \~R0_8 \~R1_11 \~R1_10 \~R1_9 \~R1_8 \~W0_11 \~W0_10 \~W0_9 \~W0_8 \~W1_11 \~W1_10 \~W1_9 \~W1_8) _sub163
    I133 (JR_16 JW_16 \~R0_11 \~R0_10 \~R0_9 \~R0_8 \~R1_11 \~R1_10 \~R1_9 \~R1_8 \~W0_11 \~W0_10 \~W0_9 \~W0_8 \~W1_11 \~W1_10 \~W1_9 \~W1_8) _sub163
    I125 (JR_15 JW_15 \~R0_11 \~R0_10 \~R0_9 \~R0_8 \~R1_11 \~R1_10 \~R1_9 \~R1_8 \~W0_11 \~W0_10 \~W0_9 \~W0_8 \~W1_11 \~W1_10 \~W1_9 \~W1_8) _sub163
    I117 (JR_14 JW_14 \~R0_11 \~R0_10 \~R0_9 \~R0_8 \~R1_11 \~R1_10 \~R1_9 \~R1_8 \~W0_11 \~W0_10 \~W0_9 \~W0_8 \~W1_11 \~W1_10 \~W1_9 \~W1_8) _sub163
    I109 (JR_13 JW_13 \~R0_11 \~R0_10 \~R0_9 \~R0_8 \~R1_11 \~R1_10 \~R1_9 \~R1_8 \~W0_11 \~W0_10 \~W0_9 \~W0_8 \~W1_11 \~W1_10 \~W1_9 \~W1_8) _sub163
    I101 (JR_12 JW_12 \~R0_11 \~R0_10 \~R0_9 \~R0_8 \~R1_11 \~R1_10 \~R1_9 \~R1_8 \~W0_11 \~W0_10 \~W0_9 \~W0_8 \~W1_11 \~W1_10 \~W1_9 \~W1_8) _sub163
    I93 (JR_11 JW_11 \~R0_11 \~R0_10 \~R0_9 \~R0_8 \~R1_11 \~R1_10 \~R1_9 \~R1_8 \~W0_11 \~W0_10 \~W0_9 \~W0_8 \~W1_11 \~W1_10 \~W1_9 \~W1_8) _sub163
    I85 (JR_10 JW_10 \~R0_11 \~R0_10 \~R0_9 \~R0_8 \~R1_11 \~R1_10 \~R1_9 \~R1_8 \~W0_11 \~W0_10 \~W0_9 \~W0_8 \~W1_11 \~W1_10 \~W1_9 \~W1_8) _sub163
    I77 (JR_9 JW_9 \~R0_11 \~R0_10 \~R0_9 \~R0_8 \~R1_11 \~R1_10 \~R1_9 \~R1_8 \~W0_11 \~W0_10 \~W0_9 \~W0_8 \~W1_11 \~W1_10 \~W1_9 \~W1_8) _sub163
    I69 (JR_8 JW_8 \~R0_11 \~R0_10 \~R0_9 \~R0_8 \~R1_11 \~R1_10 \~R1_9 \~R1_8 \~W0_11 \~W0_10 \~W0_9 \~W0_8 \~W1_11 \~W1_10 \~W1_9 \~W1_8) _sub163
    I61 (JR_7 JW_7 \~R0_11 \~R0_10 \~R0_9 \~R0_8 \~R1_11 \~R1_10 \~R1_9 \~R1_8 \~W0_11 \~W0_10 \~W0_9 \~W0_8 \~W1_11 \~W1_10 \~W1_9 \~W1_8) _sub163
    I53 (JR_6 JW_6 \~R0_11 \~R0_10 \~R0_9 \~R0_8 \~R1_11 \~R1_10 \~R1_9 \~R1_8 \~W0_11 \~W0_10 \~W0_9 \~W0_8 \~W1_11 \~W1_10 \~W1_9 \~W1_8) _sub163
    I45 (JR_5 JW_5 \~R0_11 \~R0_10 \~R0_9 \~R0_8 \~R1_11 \~R1_10 \~R1_9 \~R1_8 \~W0_11 \~W0_10 \~W0_9 \~W0_8 \~W1_11 \~W1_10 \~W1_9 \~W1_8) _sub163
    I37 (JR_4 JW_4 \~R0_11 \~R0_10 \~R0_9 \~R0_8 \~R1_11 \~R1_10 \~R1_9 \~R1_8 \~W0_11 \~W0_10 \~W0_9 \~W0_8 \~W1_11 \~W1_10 \~W1_9 \~W1_8) _sub163
    I29 (JR_3 JW_3 \~R0_11 \~R0_10 \~R0_9 \~R0_8 \~R1_11 \~R1_10 \~R1_9 \~R1_8 \~W0_11 \~W0_10 \~W0_9 \~W0_8 \~W1_11 \~W1_10 \~W1_9 \~W1_8) _sub163
    I21 (JR_2 JW_2 \~R0_11 \~R0_10 \~R0_9 \~R0_8 \~R1_11 \~R1_10 \~R1_9 \~R1_8 \~W0_11 \~W0_10 \~W0_9 \~W0_8 \~W1_11 \~W1_10 \~W1_9 \~W1_8) _sub163
    I13 (JR_1 JW_1 \~R0_11 \~R0_10 \~R0_9 \~R0_8 \~R1_11 \~R1_10 \~R1_9 \~R1_8 \~W0_11 \~W0_10 \~W0_9 \~W0_8 \~W1_11 \~W1_10 \~W1_9 \~W1_8) _sub163
    I252 (JR_31 JW_31 \~R0_15 \~R0_14 \~R0_13 \~R0_12 \~R1_15 \~R1_14 \~R1_13 \~R1_12 \~W0_15 \~W0_14 \~W0_13 \~W0_12 \~W1_15 \~W1_14 \~W1_13 \~W1_12) _sub163
    I244 (JR_30 JW_30 \~R0_15 \~R0_14 \~R0_13 \~R0_12 \~R1_15 \~R1_14 \~R1_13 \~R1_12 \~W0_15 \~W0_14 \~W0_13 \~W0_12 \~W1_15 \~W1_14 \~W1_13 \~W1_12) _sub163
    I236 (JR_29 JW_29 \~R0_15 \~R0_14 \~R0_13 \~R0_12 \~R1_15 \~R1_14 \~R1_13 \~R1_12 \~W0_15 \~W0_14 \~W0_13 \~W0_12 \~W1_15 \~W1_14 \~W1_13 \~W1_12) _sub163
    I228 (JR_28 JW_28 \~R0_15 \~R0_14 \~R0_13 \~R0_12 \~R1_15 \~R1_14 \~R1_13 \~R1_12 \~W0_15 \~W0_14 \~W0_13 \~W0_12 \~W1_15 \~W1_14 \~W1_13 \~W1_12) _sub163
    I220 (JR_27 JW_27 \~R0_15 \~R0_14 \~R0_13 \~R0_12 \~R1_15 \~R1_14 \~R1_13 \~R1_12 \~W0_15 \~W0_14 \~W0_13 \~W0_12 \~W1_15 \~W1_14 \~W1_13 \~W1_12) _sub163
    I212 (JR_26 JW_26 \~R0_15 \~R0_14 \~R0_13 \~R0_12 \~R1_15 \~R1_14 \~R1_13 \~R1_12 \~W0_15 \~W0_14 \~W0_13 \~W0_12 \~W1_15 \~W1_14 \~W1_13 \~W1_12) _sub163
    I204 (JR_25 JW_25 \~R0_15 \~R0_14 \~R0_13 \~R0_12 \~R1_15 \~R1_14 \~R1_13 \~R1_12 \~W0_15 \~W0_14 \~W0_13 \~W0_12 \~W1_15 \~W1_14 \~W1_13 \~W1_12) _sub163
    I196 (JR_24 JW_24 \~R0_15 \~R0_14 \~R0_13 \~R0_12 \~R1_15 \~R1_14 \~R1_13 \~R1_12 \~W0_15 \~W0_14 \~W0_13 \~W0_12 \~W1_15 \~W1_14 \~W1_13 \~W1_12) _sub163
    I188 (JR_23 JW_23 \~R0_15 \~R0_14 \~R0_13 \~R0_12 \~R1_15 \~R1_14 \~R1_13 \~R1_12 \~W0_15 \~W0_14 \~W0_13 \~W0_12 \~W1_15 \~W1_14 \~W1_13 \~W1_12) _sub163
    I180 (JR_22 JW_22 \~R0_15 \~R0_14 \~R0_13 \~R0_12 \~R1_15 \~R1_14 \~R1_13 \~R1_12 \~W0_15 \~W0_14 \~W0_13 \~W0_12 \~W1_15 \~W1_14 \~W1_13 \~W1_12) _sub163
    I172 (JR_21 JW_21 \~R0_15 \~R0_14 \~R0_13 \~R0_12 \~R1_15 \~R1_14 \~R1_13 \~R1_12 \~W0_15 \~W0_14 \~W0_13 \~W0_12 \~W1_15 \~W1_14 \~W1_13 \~W1_12) _sub163
    I164 (JR_20 JW_20 \~R0_15 \~R0_14 \~R0_13 \~R0_12 \~R1_15 \~R1_14 \~R1_13 \~R1_12 \~W0_15 \~W0_14 \~W0_13 \~W0_12 \~W1_15 \~W1_14 \~W1_13 \~W1_12) _sub163
    I156 (JR_19 JW_19 \~R0_15 \~R0_14 \~R0_13 \~R0_12 \~R1_15 \~R1_14 \~R1_13 \~R1_12 \~W0_15 \~W0_14 \~W0_13 \~W0_12 \~W1_15 \~W1_14 \~W1_13 \~W1_12) _sub163
    I148 (JR_18 JW_18 \~R0_15 \~R0_14 \~R0_13 \~R0_12 \~R1_15 \~R1_14 \~R1_13 \~R1_12 \~W0_15 \~W0_14 \~W0_13 \~W0_12 \~W1_15 \~W1_14 \~W1_13 \~W1_12) _sub163
    I140 (JR_17 JW_17 \~R0_15 \~R0_14 \~R0_13 \~R0_12 \~R1_15 \~R1_14 \~R1_13 \~R1_12 \~W0_15 \~W0_14 \~W0_13 \~W0_12 \~W1_15 \~W1_14 \~W1_13 \~W1_12) _sub163
    I132 (JR_16 JW_16 \~R0_15 \~R0_14 \~R0_13 \~R0_12 \~R1_15 \~R1_14 \~R1_13 \~R1_12 \~W0_15 \~W0_14 \~W0_13 \~W0_12 \~W1_15 \~W1_14 \~W1_13 \~W1_12) _sub163
    I124 (JR_15 JW_15 \~R0_15 \~R0_14 \~R0_13 \~R0_12 \~R1_15 \~R1_14 \~R1_13 \~R1_12 \~W0_15 \~W0_14 \~W0_13 \~W0_12 \~W1_15 \~W1_14 \~W1_13 \~W1_12) _sub163
    I116 (JR_14 JW_14 \~R0_15 \~R0_14 \~R0_13 \~R0_12 \~R1_15 \~R1_14 \~R1_13 \~R1_12 \~W0_15 \~W0_14 \~W0_13 \~W0_12 \~W1_15 \~W1_14 \~W1_13 \~W1_12) _sub163
    I108 (JR_13 JW_13 \~R0_15 \~R0_14 \~R0_13 \~R0_12 \~R1_15 \~R1_14 \~R1_13 \~R1_12 \~W0_15 \~W0_14 \~W0_13 \~W0_12 \~W1_15 \~W1_14 \~W1_13 \~W1_12) _sub163
    I100 (JR_12 JW_12 \~R0_15 \~R0_14 \~R0_13 \~R0_12 \~R1_15 \~R1_14 \~R1_13 \~R1_12 \~W0_15 \~W0_14 \~W0_13 \~W0_12 \~W1_15 \~W1_14 \~W1_13 \~W1_12) _sub163
    I92 (JR_11 JW_11 \~R0_15 \~R0_14 \~R0_13 \~R0_12 \~R1_15 \~R1_14 \~R1_13 \~R1_12 \~W0_15 \~W0_14 \~W0_13 \~W0_12 \~W1_15 \~W1_14 \~W1_13 \~W1_12) _sub163
    I84 (JR_10 JW_10 \~R0_15 \~R0_14 \~R0_13 \~R0_12 \~R1_15 \~R1_14 \~R1_13 \~R1_12 \~W0_15 \~W0_14 \~W0_13 \~W0_12 \~W1_15 \~W1_14 \~W1_13 \~W1_12) _sub163
    I76 (JR_9 JW_9 \~R0_15 \~R0_14 \~R0_13 \~R0_12 \~R1_15 \~R1_14 \~R1_13 \~R1_12 \~W0_15 \~W0_14 \~W0_13 \~W0_12 \~W1_15 \~W1_14 \~W1_13 \~W1_12) _sub163
    I68 (JR_8 JW_8 \~R0_15 \~R0_14 \~R0_13 \~R0_12 \~R1_15 \~R1_14 \~R1_13 \~R1_12 \~W0_15 \~W0_14 \~W0_13 \~W0_12 \~W1_15 \~W1_14 \~W1_13 \~W1_12) _sub163
    I60 (JR_7 JW_7 \~R0_15 \~R0_14 \~R0_13 \~R0_12 \~R1_15 \~R1_14 \~R1_13 \~R1_12 \~W0_15 \~W0_14 \~W0_13 \~W0_12 \~W1_15 \~W1_14 \~W1_13 \~W1_12) _sub163
    I52 (JR_6 JW_6 \~R0_15 \~R0_14 \~R0_13 \~R0_12 \~R1_15 \~R1_14 \~R1_13 \~R1_12 \~W0_15 \~W0_14 \~W0_13 \~W0_12 \~W1_15 \~W1_14 \~W1_13 \~W1_12) _sub163
    I44 (JR_5 JW_5 \~R0_15 \~R0_14 \~R0_13 \~R0_12 \~R1_15 \~R1_14 \~R1_13 \~R1_12 \~W0_15 \~W0_14 \~W0_13 \~W0_12 \~W1_15 \~W1_14 \~W1_13 \~W1_12) _sub163
    I36 (JR_4 JW_4 \~R0_15 \~R0_14 \~R0_13 \~R0_12 \~R1_15 \~R1_14 \~R1_13 \~R1_12 \~W0_15 \~W0_14 \~W0_13 \~W0_12 \~W1_15 \~W1_14 \~W1_13 \~W1_12) _sub163
    I28 (JR_3 JW_3 \~R0_15 \~R0_14 \~R0_13 \~R0_12 \~R1_15 \~R1_14 \~R1_13 \~R1_12 \~W0_15 \~W0_14 \~W0_13 \~W0_12 \~W1_15 \~W1_14 \~W1_13 \~W1_12) _sub163
    I20 (JR_2 JW_2 \~R0_15 \~R0_14 \~R0_13 \~R0_12 \~R1_15 \~R1_14 \~R1_13 \~R1_12 \~W0_15 \~W0_14 \~W0_13 \~W0_12 \~W1_15 \~W1_14 \~W1_13 \~W1_12) _sub163
    I12 (JR_1 JW_1 \~R0_15 \~R0_14 \~R0_13 \~R0_12 \~R1_15 \~R1_14 \~R1_13 \~R1_12 \~W0_15 \~W0_14 \~W0_13 \~W0_12 \~W1_15 \~W1_14 \~W1_13 \~W1_12) _sub163
    I251 (JR_31 JW_31 \~R0_19 \~R0_18 \~R0_17 \~R0_16 \~R1_19 \~R1_18 \~R1_17 \~R1_16 \~W0_19 \~W0_18 \~W0_17 \~W0_16 \~W1_19 \~W1_18 \~W1_17 \~W1_16) _sub163
    I243 (JR_30 JW_30 \~R0_19 \~R0_18 \~R0_17 \~R0_16 \~R1_19 \~R1_18 \~R1_17 \~R1_16 \~W0_19 \~W0_18 \~W0_17 \~W0_16 \~W1_19 \~W1_18 \~W1_17 \~W1_16) _sub163
    I235 (JR_29 JW_29 \~R0_19 \~R0_18 \~R0_17 \~R0_16 \~R1_19 \~R1_18 \~R1_17 \~R1_16 \~W0_19 \~W0_18 \~W0_17 \~W0_16 \~W1_19 \~W1_18 \~W1_17 \~W1_16) _sub163
    I227 (JR_28 JW_28 \~R0_19 \~R0_18 \~R0_17 \~R0_16 \~R1_19 \~R1_18 \~R1_17 \~R1_16 \~W0_19 \~W0_18 \~W0_17 \~W0_16 \~W1_19 \~W1_18 \~W1_17 \~W1_16) _sub163
    I219 (JR_27 JW_27 \~R0_19 \~R0_18 \~R0_17 \~R0_16 \~R1_19 \~R1_18 \~R1_17 \~R1_16 \~W0_19 \~W0_18 \~W0_17 \~W0_16 \~W1_19 \~W1_18 \~W1_17 \~W1_16) _sub163
    I211 (JR_26 JW_26 \~R0_19 \~R0_18 \~R0_17 \~R0_16 \~R1_19 \~R1_18 \~R1_17 \~R1_16 \~W0_19 \~W0_18 \~W0_17 \~W0_16 \~W1_19 \~W1_18 \~W1_17 \~W1_16) _sub163
    I203 (JR_25 JW_25 \~R0_19 \~R0_18 \~R0_17 \~R0_16 \~R1_19 \~R1_18 \~R1_17 \~R1_16 \~W0_19 \~W0_18 \~W0_17 \~W0_16 \~W1_19 \~W1_18 \~W1_17 \~W1_16) _sub163
    I195 (JR_24 JW_24 \~R0_19 \~R0_18 \~R0_17 \~R0_16 \~R1_19 \~R1_18 \~R1_17 \~R1_16 \~W0_19 \~W0_18 \~W0_17 \~W0_16 \~W1_19 \~W1_18 \~W1_17 \~W1_16) _sub163
    I187 (JR_23 JW_23 \~R0_19 \~R0_18 \~R0_17 \~R0_16 \~R1_19 \~R1_18 \~R1_17 \~R1_16 \~W0_19 \~W0_18 \~W0_17 \~W0_16 \~W1_19 \~W1_18 \~W1_17 \~W1_16) _sub163
    I179 (JR_22 JW_22 \~R0_19 \~R0_18 \~R0_17 \~R0_16 \~R1_19 \~R1_18 \~R1_17 \~R1_16 \~W0_19 \~W0_18 \~W0_17 \~W0_16 \~W1_19 \~W1_18 \~W1_17 \~W1_16) _sub163
    I171 (JR_21 JW_21 \~R0_19 \~R0_18 \~R0_17 \~R0_16 \~R1_19 \~R1_18 \~R1_17 \~R1_16 \~W0_19 \~W0_18 \~W0_17 \~W0_16 \~W1_19 \~W1_18 \~W1_17 \~W1_16) _sub163
    I163 (JR_20 JW_20 \~R0_19 \~R0_18 \~R0_17 \~R0_16 \~R1_19 \~R1_18 \~R1_17 \~R1_16 \~W0_19 \~W0_18 \~W0_17 \~W0_16 \~W1_19 \~W1_18 \~W1_17 \~W1_16) _sub163
    I155 (JR_19 JW_19 \~R0_19 \~R0_18 \~R0_17 \~R0_16 \~R1_19 \~R1_18 \~R1_17 \~R1_16 \~W0_19 \~W0_18 \~W0_17 \~W0_16 \~W1_19 \~W1_18 \~W1_17 \~W1_16) _sub163
    I147 (JR_18 JW_18 \~R0_19 \~R0_18 \~R0_17 \~R0_16 \~R1_19 \~R1_18 \~R1_17 \~R1_16 \~W0_19 \~W0_18 \~W0_17 \~W0_16 \~W1_19 \~W1_18 \~W1_17 \~W1_16) _sub163
    I139 (JR_17 JW_17 \~R0_19 \~R0_18 \~R0_17 \~R0_16 \~R1_19 \~R1_18 \~R1_17 \~R1_16 \~W0_19 \~W0_18 \~W0_17 \~W0_16 \~W1_19 \~W1_18 \~W1_17 \~W1_16) _sub163
    I131 (JR_16 JW_16 \~R0_19 \~R0_18 \~R0_17 \~R0_16 \~R1_19 \~R1_18 \~R1_17 \~R1_16 \~W0_19 \~W0_18 \~W0_17 \~W0_16 \~W1_19 \~W1_18 \~W1_17 \~W1_16) _sub163
    I123 (JR_15 JW_15 \~R0_19 \~R0_18 \~R0_17 \~R0_16 \~R1_19 \~R1_18 \~R1_17 \~R1_16 \~W0_19 \~W0_18 \~W0_17 \~W0_16 \~W1_19 \~W1_18 \~W1_17 \~W1_16) _sub163
    I115 (JR_14 JW_14 \~R0_19 \~R0_18 \~R0_17 \~R0_16 \~R1_19 \~R1_18 \~R1_17 \~R1_16 \~W0_19 \~W0_18 \~W0_17 \~W0_16 \~W1_19 \~W1_18 \~W1_17 \~W1_16) _sub163
    I107 (JR_13 JW_13 \~R0_19 \~R0_18 \~R0_17 \~R0_16 \~R1_19 \~R1_18 \~R1_17 \~R1_16 \~W0_19 \~W0_18 \~W0_17 \~W0_16 \~W1_19 \~W1_18 \~W1_17 \~W1_16) _sub163
    I99 (JR_12 JW_12 \~R0_19 \~R0_18 \~R0_17 \~R0_16 \~R1_19 \~R1_18 \~R1_17 \~R1_16 \~W0_19 \~W0_18 \~W0_17 \~W0_16 \~W1_19 \~W1_18 \~W1_17 \~W1_16) _sub163
    I91 (JR_11 JW_11 \~R0_19 \~R0_18 \~R0_17 \~R0_16 \~R1_19 \~R1_18 \~R1_17 \~R1_16 \~W0_19 \~W0_18 \~W0_17 \~W0_16 \~W1_19 \~W1_18 \~W1_17 \~W1_16) _sub163
    I83 (JR_10 JW_10 \~R0_19 \~R0_18 \~R0_17 \~R0_16 \~R1_19 \~R1_18 \~R1_17 \~R1_16 \~W0_19 \~W0_18 \~W0_17 \~W0_16 \~W1_19 \~W1_18 \~W1_17 \~W1_16) _sub163
    I75 (JR_9 JW_9 \~R0_19 \~R0_18 \~R0_17 \~R0_16 \~R1_19 \~R1_18 \~R1_17 \~R1_16 \~W0_19 \~W0_18 \~W0_17 \~W0_16 \~W1_19 \~W1_18 \~W1_17 \~W1_16) _sub163
    I67 (JR_8 JW_8 \~R0_19 \~R0_18 \~R0_17 \~R0_16 \~R1_19 \~R1_18 \~R1_17 \~R1_16 \~W0_19 \~W0_18 \~W0_17 \~W0_16 \~W1_19 \~W1_18 \~W1_17 \~W1_16) _sub163
    I59 (JR_7 JW_7 \~R0_19 \~R0_18 \~R0_17 \~R0_16 \~R1_19 \~R1_18 \~R1_17 \~R1_16 \~W0_19 \~W0_18 \~W0_17 \~W0_16 \~W1_19 \~W1_18 \~W1_17 \~W1_16) _sub163
    I51 (JR_6 JW_6 \~R0_19 \~R0_18 \~R0_17 \~R0_16 \~R1_19 \~R1_18 \~R1_17 \~R1_16 \~W0_19 \~W0_18 \~W0_17 \~W0_16 \~W1_19 \~W1_18 \~W1_17 \~W1_16) _sub163
    I43 (JR_5 JW_5 \~R0_19 \~R0_18 \~R0_17 \~R0_16 \~R1_19 \~R1_18 \~R1_17 \~R1_16 \~W0_19 \~W0_18 \~W0_17 \~W0_16 \~W1_19 \~W1_18 \~W1_17 \~W1_16) _sub163
    I35 (JR_4 JW_4 \~R0_19 \~R0_18 \~R0_17 \~R0_16 \~R1_19 \~R1_18 \~R1_17 \~R1_16 \~W0_19 \~W0_18 \~W0_17 \~W0_16 \~W1_19 \~W1_18 \~W1_17 \~W1_16) _sub163
    I27 (JR_3 JW_3 \~R0_19 \~R0_18 \~R0_17 \~R0_16 \~R1_19 \~R1_18 \~R1_17 \~R1_16 \~W0_19 \~W0_18 \~W0_17 \~W0_16 \~W1_19 \~W1_18 \~W1_17 \~W1_16) _sub163
    I19 (JR_2 JW_2 \~R0_19 \~R0_18 \~R0_17 \~R0_16 \~R1_19 \~R1_18 \~R1_17 \~R1_16 \~W0_19 \~W0_18 \~W0_17 \~W0_16 \~W1_19 \~W1_18 \~W1_17 \~W1_16) _sub163
    I11 (JR_1 JW_1 \~R0_19 \~R0_18 \~R0_17 \~R0_16 \~R1_19 \~R1_18 \~R1_17 \~R1_16 \~W0_19 \~W0_18 \~W0_17 \~W0_16 \~W1_19 \~W1_18 \~W1_17 \~W1_16) _sub163
    I250 (JR_31 JW_31 \~R0_23 \~R0_22 \~R0_21 \~R0_20 \~R1_23 \~R1_22 \~R1_21 \~R1_20 \~W0_23 \~W0_22 \~W0_21 \~W0_20 \~W1_23 \~W1_22 \~W1_21 \~W1_20) _sub163
    I242 (JR_30 JW_30 \~R0_23 \~R0_22 \~R0_21 \~R0_20 \~R1_23 \~R1_22 \~R1_21 \~R1_20 \~W0_23 \~W0_22 \~W0_21 \~W0_20 \~W1_23 \~W1_22 \~W1_21 \~W1_20) _sub163
    I234 (JR_29 JW_29 \~R0_23 \~R0_22 \~R0_21 \~R0_20 \~R1_23 \~R1_22 \~R1_21 \~R1_20 \~W0_23 \~W0_22 \~W0_21 \~W0_20 \~W1_23 \~W1_22 \~W1_21 \~W1_20) _sub163
    I226 (JR_28 JW_28 \~R0_23 \~R0_22 \~R0_21 \~R0_20 \~R1_23 \~R1_22 \~R1_21 \~R1_20 \~W0_23 \~W0_22 \~W0_21 \~W0_20 \~W1_23 \~W1_22 \~W1_21 \~W1_20) _sub163
    I218 (JR_27 JW_27 \~R0_23 \~R0_22 \~R0_21 \~R0_20 \~R1_23 \~R1_22 \~R1_21 \~R1_20 \~W0_23 \~W0_22 \~W0_21 \~W0_20 \~W1_23 \~W1_22 \~W1_21 \~W1_20) _sub163
    I210 (JR_26 JW_26 \~R0_23 \~R0_22 \~R0_21 \~R0_20 \~R1_23 \~R1_22 \~R1_21 \~R1_20 \~W0_23 \~W0_22 \~W0_21 \~W0_20 \~W1_23 \~W1_22 \~W1_21 \~W1_20) _sub163
    I202 (JR_25 JW_25 \~R0_23 \~R0_22 \~R0_21 \~R0_20 \~R1_23 \~R1_22 \~R1_21 \~R1_20 \~W0_23 \~W0_22 \~W0_21 \~W0_20 \~W1_23 \~W1_22 \~W1_21 \~W1_20) _sub163
    I194 (JR_24 JW_24 \~R0_23 \~R0_22 \~R0_21 \~R0_20 \~R1_23 \~R1_22 \~R1_21 \~R1_20 \~W0_23 \~W0_22 \~W0_21 \~W0_20 \~W1_23 \~W1_22 \~W1_21 \~W1_20) _sub163
    I186 (JR_23 JW_23 \~R0_23 \~R0_22 \~R0_21 \~R0_20 \~R1_23 \~R1_22 \~R1_21 \~R1_20 \~W0_23 \~W0_22 \~W0_21 \~W0_20 \~W1_23 \~W1_22 \~W1_21 \~W1_20) _sub163
    I178 (JR_22 JW_22 \~R0_23 \~R0_22 \~R0_21 \~R0_20 \~R1_23 \~R1_22 \~R1_21 \~R1_20 \~W0_23 \~W0_22 \~W0_21 \~W0_20 \~W1_23 \~W1_22 \~W1_21 \~W1_20) _sub163
    I170 (JR_21 JW_21 \~R0_23 \~R0_22 \~R0_21 \~R0_20 \~R1_23 \~R1_22 \~R1_21 \~R1_20 \~W0_23 \~W0_22 \~W0_21 \~W0_20 \~W1_23 \~W1_22 \~W1_21 \~W1_20) _sub163
    I162 (JR_20 JW_20 \~R0_23 \~R0_22 \~R0_21 \~R0_20 \~R1_23 \~R1_22 \~R1_21 \~R1_20 \~W0_23 \~W0_22 \~W0_21 \~W0_20 \~W1_23 \~W1_22 \~W1_21 \~W1_20) _sub163
    I154 (JR_19 JW_19 \~R0_23 \~R0_22 \~R0_21 \~R0_20 \~R1_23 \~R1_22 \~R1_21 \~R1_20 \~W0_23 \~W0_22 \~W0_21 \~W0_20 \~W1_23 \~W1_22 \~W1_21 \~W1_20) _sub163
    I146 (JR_18 JW_18 \~R0_23 \~R0_22 \~R0_21 \~R0_20 \~R1_23 \~R1_22 \~R1_21 \~R1_20 \~W0_23 \~W0_22 \~W0_21 \~W0_20 \~W1_23 \~W1_22 \~W1_21 \~W1_20) _sub163
    I138 (JR_17 JW_17 \~R0_23 \~R0_22 \~R0_21 \~R0_20 \~R1_23 \~R1_22 \~R1_21 \~R1_20 \~W0_23 \~W0_22 \~W0_21 \~W0_20 \~W1_23 \~W1_22 \~W1_21 \~W1_20) _sub163
    I130 (JR_16 JW_16 \~R0_23 \~R0_22 \~R0_21 \~R0_20 \~R1_23 \~R1_22 \~R1_21 \~R1_20 \~W0_23 \~W0_22 \~W0_21 \~W0_20 \~W1_23 \~W1_22 \~W1_21 \~W1_20) _sub163
    I122 (JR_15 JW_15 \~R0_23 \~R0_22 \~R0_21 \~R0_20 \~R1_23 \~R1_22 \~R1_21 \~R1_20 \~W0_23 \~W0_22 \~W0_21 \~W0_20 \~W1_23 \~W1_22 \~W1_21 \~W1_20) _sub163
    I114 (JR_14 JW_14 \~R0_23 \~R0_22 \~R0_21 \~R0_20 \~R1_23 \~R1_22 \~R1_21 \~R1_20 \~W0_23 \~W0_22 \~W0_21 \~W0_20 \~W1_23 \~W1_22 \~W1_21 \~W1_20) _sub163
    I106 (JR_13 JW_13 \~R0_23 \~R0_22 \~R0_21 \~R0_20 \~R1_23 \~R1_22 \~R1_21 \~R1_20 \~W0_23 \~W0_22 \~W0_21 \~W0_20 \~W1_23 \~W1_22 \~W1_21 \~W1_20) _sub163
    I98 (JR_12 JW_12 \~R0_23 \~R0_22 \~R0_21 \~R0_20 \~R1_23 \~R1_22 \~R1_21 \~R1_20 \~W0_23 \~W0_22 \~W0_21 \~W0_20 \~W1_23 \~W1_22 \~W1_21 \~W1_20) _sub163
    I90 (JR_11 JW_11 \~R0_23 \~R0_22 \~R0_21 \~R0_20 \~R1_23 \~R1_22 \~R1_21 \~R1_20 \~W0_23 \~W0_22 \~W0_21 \~W0_20 \~W1_23 \~W1_22 \~W1_21 \~W1_20) _sub163
    I82 (JR_10 JW_10 \~R0_23 \~R0_22 \~R0_21 \~R0_20 \~R1_23 \~R1_22 \~R1_21 \~R1_20 \~W0_23 \~W0_22 \~W0_21 \~W0_20 \~W1_23 \~W1_22 \~W1_21 \~W1_20) _sub163
    I74 (JR_9 JW_9 \~R0_23 \~R0_22 \~R0_21 \~R0_20 \~R1_23 \~R1_22 \~R1_21 \~R1_20 \~W0_23 \~W0_22 \~W0_21 \~W0_20 \~W1_23 \~W1_22 \~W1_21 \~W1_20) _sub163
    I66 (JR_8 JW_8 \~R0_23 \~R0_22 \~R0_21 \~R0_20 \~R1_23 \~R1_22 \~R1_21 \~R1_20 \~W0_23 \~W0_22 \~W0_21 \~W0_20 \~W1_23 \~W1_22 \~W1_21 \~W1_20) _sub163
    I58 (JR_7 JW_7 \~R0_23 \~R0_22 \~R0_21 \~R0_20 \~R1_23 \~R1_22 \~R1_21 \~R1_20 \~W0_23 \~W0_22 \~W0_21 \~W0_20 \~W1_23 \~W1_22 \~W1_21 \~W1_20) _sub163
    I50 (JR_6 JW_6 \~R0_23 \~R0_22 \~R0_21 \~R0_20 \~R1_23 \~R1_22 \~R1_21 \~R1_20 \~W0_23 \~W0_22 \~W0_21 \~W0_20 \~W1_23 \~W1_22 \~W1_21 \~W1_20) _sub163
    I42 (JR_5 JW_5 \~R0_23 \~R0_22 \~R0_21 \~R0_20 \~R1_23 \~R1_22 \~R1_21 \~R1_20 \~W0_23 \~W0_22 \~W0_21 \~W0_20 \~W1_23 \~W1_22 \~W1_21 \~W1_20) _sub163
    I34 (JR_4 JW_4 \~R0_23 \~R0_22 \~R0_21 \~R0_20 \~R1_23 \~R1_22 \~R1_21 \~R1_20 \~W0_23 \~W0_22 \~W0_21 \~W0_20 \~W1_23 \~W1_22 \~W1_21 \~W1_20) _sub163
    I26 (JR_3 JW_3 \~R0_23 \~R0_22 \~R0_21 \~R0_20 \~R1_23 \~R1_22 \~R1_21 \~R1_20 \~W0_23 \~W0_22 \~W0_21 \~W0_20 \~W1_23 \~W1_22 \~W1_21 \~W1_20) _sub163
    I18 (JR_2 JW_2 \~R0_23 \~R0_22 \~R0_21 \~R0_20 \~R1_23 \~R1_22 \~R1_21 \~R1_20 \~W0_23 \~W0_22 \~W0_21 \~W0_20 \~W1_23 \~W1_22 \~W1_21 \~W1_20) _sub163
    I10 (JR_1 JW_1 \~R0_23 \~R0_22 \~R0_21 \~R0_20 \~R1_23 \~R1_22 \~R1_21 \~R1_20 \~W0_23 \~W0_22 \~W0_21 \~W0_20 \~W1_23 \~W1_22 \~W1_21 \~W1_20) _sub163
    I249 (JR_31 JW_31 \~R0_27 \~R0_26 \~R0_25 \~R0_24 \~R1_27 \~R1_26 \~R1_25 \~R1_24 \~W0_27 \~W0_26 \~W0_25 \~W0_24 \~W1_27 \~W1_26 \~W1_25 \~W1_24) _sub163
    I241 (JR_30 JW_30 \~R0_27 \~R0_26 \~R0_25 \~R0_24 \~R1_27 \~R1_26 \~R1_25 \~R1_24 \~W0_27 \~W0_26 \~W0_25 \~W0_24 \~W1_27 \~W1_26 \~W1_25 \~W1_24) _sub163
    I233 (JR_29 JW_29 \~R0_27 \~R0_26 \~R0_25 \~R0_24 \~R1_27 \~R1_26 \~R1_25 \~R1_24 \~W0_27 \~W0_26 \~W0_25 \~W0_24 \~W1_27 \~W1_26 \~W1_25 \~W1_24) _sub163
    I225 (JR_28 JW_28 \~R0_27 \~R0_26 \~R0_25 \~R0_24 \~R1_27 \~R1_26 \~R1_25 \~R1_24 \~W0_27 \~W0_26 \~W0_25 \~W0_24 \~W1_27 \~W1_26 \~W1_25 \~W1_24) _sub163
    I217 (JR_27 JW_27 \~R0_27 \~R0_26 \~R0_25 \~R0_24 \~R1_27 \~R1_26 \~R1_25 \~R1_24 \~W0_27 \~W0_26 \~W0_25 \~W0_24 \~W1_27 \~W1_26 \~W1_25 \~W1_24) _sub163
    I209 (JR_26 JW_26 \~R0_27 \~R0_26 \~R0_25 \~R0_24 \~R1_27 \~R1_26 \~R1_25 \~R1_24 \~W0_27 \~W0_26 \~W0_25 \~W0_24 \~W1_27 \~W1_26 \~W1_25 \~W1_24) _sub163
    I201 (JR_25 JW_25 \~R0_27 \~R0_26 \~R0_25 \~R0_24 \~R1_27 \~R1_26 \~R1_25 \~R1_24 \~W0_27 \~W0_26 \~W0_25 \~W0_24 \~W1_27 \~W1_26 \~W1_25 \~W1_24) _sub163
    I193 (JR_24 JW_24 \~R0_27 \~R0_26 \~R0_25 \~R0_24 \~R1_27 \~R1_26 \~R1_25 \~R1_24 \~W0_27 \~W0_26 \~W0_25 \~W0_24 \~W1_27 \~W1_26 \~W1_25 \~W1_24) _sub163
    I185 (JR_23 JW_23 \~R0_27 \~R0_26 \~R0_25 \~R0_24 \~R1_27 \~R1_26 \~R1_25 \~R1_24 \~W0_27 \~W0_26 \~W0_25 \~W0_24 \~W1_27 \~W1_26 \~W1_25 \~W1_24) _sub163
    I177 (JR_22 JW_22 \~R0_27 \~R0_26 \~R0_25 \~R0_24 \~R1_27 \~R1_26 \~R1_25 \~R1_24 \~W0_27 \~W0_26 \~W0_25 \~W0_24 \~W1_27 \~W1_26 \~W1_25 \~W1_24) _sub163
    I169 (JR_21 JW_21 \~R0_27 \~R0_26 \~R0_25 \~R0_24 \~R1_27 \~R1_26 \~R1_25 \~R1_24 \~W0_27 \~W0_26 \~W0_25 \~W0_24 \~W1_27 \~W1_26 \~W1_25 \~W1_24) _sub163
    I161 (JR_20 JW_20 \~R0_27 \~R0_26 \~R0_25 \~R0_24 \~R1_27 \~R1_26 \~R1_25 \~R1_24 \~W0_27 \~W0_26 \~W0_25 \~W0_24 \~W1_27 \~W1_26 \~W1_25 \~W1_24) _sub163
    I153 (JR_19 JW_19 \~R0_27 \~R0_26 \~R0_25 \~R0_24 \~R1_27 \~R1_26 \~R1_25 \~R1_24 \~W0_27 \~W0_26 \~W0_25 \~W0_24 \~W1_27 \~W1_26 \~W1_25 \~W1_24) _sub163
    I145 (JR_18 JW_18 \~R0_27 \~R0_26 \~R0_25 \~R0_24 \~R1_27 \~R1_26 \~R1_25 \~R1_24 \~W0_27 \~W0_26 \~W0_25 \~W0_24 \~W1_27 \~W1_26 \~W1_25 \~W1_24) _sub163
    I137 (JR_17 JW_17 \~R0_27 \~R0_26 \~R0_25 \~R0_24 \~R1_27 \~R1_26 \~R1_25 \~R1_24 \~W0_27 \~W0_26 \~W0_25 \~W0_24 \~W1_27 \~W1_26 \~W1_25 \~W1_24) _sub163
    I129 (JR_16 JW_16 \~R0_27 \~R0_26 \~R0_25 \~R0_24 \~R1_27 \~R1_26 \~R1_25 \~R1_24 \~W0_27 \~W0_26 \~W0_25 \~W0_24 \~W1_27 \~W1_26 \~W1_25 \~W1_24) _sub163
    I121 (JR_15 JW_15 \~R0_27 \~R0_26 \~R0_25 \~R0_24 \~R1_27 \~R1_26 \~R1_25 \~R1_24 \~W0_27 \~W0_26 \~W0_25 \~W0_24 \~W1_27 \~W1_26 \~W1_25 \~W1_24) _sub163
    I113 (JR_14 JW_14 \~R0_27 \~R0_26 \~R0_25 \~R0_24 \~R1_27 \~R1_26 \~R1_25 \~R1_24 \~W0_27 \~W0_26 \~W0_25 \~W0_24 \~W1_27 \~W1_26 \~W1_25 \~W1_24) _sub163
    I105 (JR_13 JW_13 \~R0_27 \~R0_26 \~R0_25 \~R0_24 \~R1_27 \~R1_26 \~R1_25 \~R1_24 \~W0_27 \~W0_26 \~W0_25 \~W0_24 \~W1_27 \~W1_26 \~W1_25 \~W1_24) _sub163
    I97 (JR_12 JW_12 \~R0_27 \~R0_26 \~R0_25 \~R0_24 \~R1_27 \~R1_26 \~R1_25 \~R1_24 \~W0_27 \~W0_26 \~W0_25 \~W0_24 \~W1_27 \~W1_26 \~W1_25 \~W1_24) _sub163
    I89 (JR_11 JW_11 \~R0_27 \~R0_26 \~R0_25 \~R0_24 \~R1_27 \~R1_26 \~R1_25 \~R1_24 \~W0_27 \~W0_26 \~W0_25 \~W0_24 \~W1_27 \~W1_26 \~W1_25 \~W1_24) _sub163
    I81 (JR_10 JW_10 \~R0_27 \~R0_26 \~R0_25 \~R0_24 \~R1_27 \~R1_26 \~R1_25 \~R1_24 \~W0_27 \~W0_26 \~W0_25 \~W0_24 \~W1_27 \~W1_26 \~W1_25 \~W1_24) _sub163
    I73 (JR_9 JW_9 \~R0_27 \~R0_26 \~R0_25 \~R0_24 \~R1_27 \~R1_26 \~R1_25 \~R1_24 \~W0_27 \~W0_26 \~W0_25 \~W0_24 \~W1_27 \~W1_26 \~W1_25 \~W1_24) _sub163
    I65 (JR_8 JW_8 \~R0_27 \~R0_26 \~R0_25 \~R0_24 \~R1_27 \~R1_26 \~R1_25 \~R1_24 \~W0_27 \~W0_26 \~W0_25 \~W0_24 \~W1_27 \~W1_26 \~W1_25 \~W1_24) _sub163
    I57 (JR_7 JW_7 \~R0_27 \~R0_26 \~R0_25 \~R0_24 \~R1_27 \~R1_26 \~R1_25 \~R1_24 \~W0_27 \~W0_26 \~W0_25 \~W0_24 \~W1_27 \~W1_26 \~W1_25 \~W1_24) _sub163
    I49 (JR_6 JW_6 \~R0_27 \~R0_26 \~R0_25 \~R0_24 \~R1_27 \~R1_26 \~R1_25 \~R1_24 \~W0_27 \~W0_26 \~W0_25 \~W0_24 \~W1_27 \~W1_26 \~W1_25 \~W1_24) _sub163
    I41 (JR_5 JW_5 \~R0_27 \~R0_26 \~R0_25 \~R0_24 \~R1_27 \~R1_26 \~R1_25 \~R1_24 \~W0_27 \~W0_26 \~W0_25 \~W0_24 \~W1_27 \~W1_26 \~W1_25 \~W1_24) _sub163
    I33 (JR_4 JW_4 \~R0_27 \~R0_26 \~R0_25 \~R0_24 \~R1_27 \~R1_26 \~R1_25 \~R1_24 \~W0_27 \~W0_26 \~W0_25 \~W0_24 \~W1_27 \~W1_26 \~W1_25 \~W1_24) _sub163
    I25 (JR_3 JW_3 \~R0_27 \~R0_26 \~R0_25 \~R0_24 \~R1_27 \~R1_26 \~R1_25 \~R1_24 \~W0_27 \~W0_26 \~W0_25 \~W0_24 \~W1_27 \~W1_26 \~W1_25 \~W1_24) _sub163
    I17 (JR_2 JW_2 \~R0_27 \~R0_26 \~R0_25 \~R0_24 \~R1_27 \~R1_26 \~R1_25 \~R1_24 \~W0_27 \~W0_26 \~W0_25 \~W0_24 \~W1_27 \~W1_26 \~W1_25 \~W1_24) _sub163
    I9 (JR_1 JW_1 \~R0_27 \~R0_26 \~R0_25 \~R0_24 \~R1_27 \~R1_26 \~R1_25 \~R1_24 \~W0_27 \~W0_26 \~W0_25 \~W0_24 \~W1_27 \~W1_26 \~W1_25 \~W1_24) _sub163
    I248 (JR_31 JW_31 \~R0_31 \~R0_30 \~R0_29 \~R0_28 \~R1_31 \~R1_30 \~R1_29 \~R1_28 \~W0_31 \~W0_30 \~W0_29 \~W0_28 \~W1_31 \~W1_30 \~W1_29 \~W1_28) _sub163
    I240 (JR_30 JW_30 \~R0_31 \~R0_30 \~R0_29 \~R0_28 \~R1_31 \~R1_30 \~R1_29 \~R1_28 \~W0_31 \~W0_30 \~W0_29 \~W0_28 \~W1_31 \~W1_30 \~W1_29 \~W1_28) _sub163
    I232 (JR_29 JW_29 \~R0_31 \~R0_30 \~R0_29 \~R0_28 \~R1_31 \~R1_30 \~R1_29 \~R1_28 \~W0_31 \~W0_30 \~W0_29 \~W0_28 \~W1_31 \~W1_30 \~W1_29 \~W1_28) _sub163
    I224 (JR_28 JW_28 \~R0_31 \~R0_30 \~R0_29 \~R0_28 \~R1_31 \~R1_30 \~R1_29 \~R1_28 \~W0_31 \~W0_30 \~W0_29 \~W0_28 \~W1_31 \~W1_30 \~W1_29 \~W1_28) _sub163
    I216 (JR_27 JW_27 \~R0_31 \~R0_30 \~R0_29 \~R0_28 \~R1_31 \~R1_30 \~R1_29 \~R1_28 \~W0_31 \~W0_30 \~W0_29 \~W0_28 \~W1_31 \~W1_30 \~W1_29 \~W1_28) _sub163
    I208 (JR_26 JW_26 \~R0_31 \~R0_30 \~R0_29 \~R0_28 \~R1_31 \~R1_30 \~R1_29 \~R1_28 \~W0_31 \~W0_30 \~W0_29 \~W0_28 \~W1_31 \~W1_30 \~W1_29 \~W1_28) _sub163
    I200 (JR_25 JW_25 \~R0_31 \~R0_30 \~R0_29 \~R0_28 \~R1_31 \~R1_30 \~R1_29 \~R1_28 \~W0_31 \~W0_30 \~W0_29 \~W0_28 \~W1_31 \~W1_30 \~W1_29 \~W1_28) _sub163
    I192 (JR_24 JW_24 \~R0_31 \~R0_30 \~R0_29 \~R0_28 \~R1_31 \~R1_30 \~R1_29 \~R1_28 \~W0_31 \~W0_30 \~W0_29 \~W0_28 \~W1_31 \~W1_30 \~W1_29 \~W1_28) _sub163
    I184 (JR_23 JW_23 \~R0_31 \~R0_30 \~R0_29 \~R0_28 \~R1_31 \~R1_30 \~R1_29 \~R1_28 \~W0_31 \~W0_30 \~W0_29 \~W0_28 \~W1_31 \~W1_30 \~W1_29 \~W1_28) _sub163
    I176 (JR_22 JW_22 \~R0_31 \~R0_30 \~R0_29 \~R0_28 \~R1_31 \~R1_30 \~R1_29 \~R1_28 \~W0_31 \~W0_30 \~W0_29 \~W0_28 \~W1_31 \~W1_30 \~W1_29 \~W1_28) _sub163
    I168 (JR_21 JW_21 \~R0_31 \~R0_30 \~R0_29 \~R0_28 \~R1_31 \~R1_30 \~R1_29 \~R1_28 \~W0_31 \~W0_30 \~W0_29 \~W0_28 \~W1_31 \~W1_30 \~W1_29 \~W1_28) _sub163
    I160 (JR_20 JW_20 \~R0_31 \~R0_30 \~R0_29 \~R0_28 \~R1_31 \~R1_30 \~R1_29 \~R1_28 \~W0_31 \~W0_30 \~W0_29 \~W0_28 \~W1_31 \~W1_30 \~W1_29 \~W1_28) _sub163
    I152 (JR_19 JW_19 \~R0_31 \~R0_30 \~R0_29 \~R0_28 \~R1_31 \~R1_30 \~R1_29 \~R1_28 \~W0_31 \~W0_30 \~W0_29 \~W0_28 \~W1_31 \~W1_30 \~W1_29 \~W1_28) _sub163
    I144 (JR_18 JW_18 \~R0_31 \~R0_30 \~R0_29 \~R0_28 \~R1_31 \~R1_30 \~R1_29 \~R1_28 \~W0_31 \~W0_30 \~W0_29 \~W0_28 \~W1_31 \~W1_30 \~W1_29 \~W1_28) _sub163
    I136 (JR_17 JW_17 \~R0_31 \~R0_30 \~R0_29 \~R0_28 \~R1_31 \~R1_30 \~R1_29 \~R1_28 \~W0_31 \~W0_30 \~W0_29 \~W0_28 \~W1_31 \~W1_30 \~W1_29 \~W1_28) _sub163
    I128 (JR_16 JW_16 \~R0_31 \~R0_30 \~R0_29 \~R0_28 \~R1_31 \~R1_30 \~R1_29 \~R1_28 \~W0_31 \~W0_30 \~W0_29 \~W0_28 \~W1_31 \~W1_30 \~W1_29 \~W1_28) _sub163
    I120 (JR_15 JW_15 \~R0_31 \~R0_30 \~R0_29 \~R0_28 \~R1_31 \~R1_30 \~R1_29 \~R1_28 \~W0_31 \~W0_30 \~W0_29 \~W0_28 \~W1_31 \~W1_30 \~W1_29 \~W1_28) _sub163
    I112 (JR_14 JW_14 \~R0_31 \~R0_30 \~R0_29 \~R0_28 \~R1_31 \~R1_30 \~R1_29 \~R1_28 \~W0_31 \~W0_30 \~W0_29 \~W0_28 \~W1_31 \~W1_30 \~W1_29 \~W1_28) _sub163
    I104 (JR_13 JW_13 \~R0_31 \~R0_30 \~R0_29 \~R0_28 \~R1_31 \~R1_30 \~R1_29 \~R1_28 \~W0_31 \~W0_30 \~W0_29 \~W0_28 \~W1_31 \~W1_30 \~W1_29 \~W1_28) _sub163
    I96 (JR_12 JW_12 \~R0_31 \~R0_30 \~R0_29 \~R0_28 \~R1_31 \~R1_30 \~R1_29 \~R1_28 \~W0_31 \~W0_30 \~W0_29 \~W0_28 \~W1_31 \~W1_30 \~W1_29 \~W1_28) _sub163
    I88 (JR_11 JW_11 \~R0_31 \~R0_30 \~R0_29 \~R0_28 \~R1_31 \~R1_30 \~R1_29 \~R1_28 \~W0_31 \~W0_30 \~W0_29 \~W0_28 \~W1_31 \~W1_30 \~W1_29 \~W1_28) _sub163
    I80 (JR_10 JW_10 \~R0_31 \~R0_30 \~R0_29 \~R0_28 \~R1_31 \~R1_30 \~R1_29 \~R1_28 \~W0_31 \~W0_30 \~W0_29 \~W0_28 \~W1_31 \~W1_30 \~W1_29 \~W1_28) _sub163
    I72 (JR_9 JW_9 \~R0_31 \~R0_30 \~R0_29 \~R0_28 \~R1_31 \~R1_30 \~R1_29 \~R1_28 \~W0_31 \~W0_30 \~W0_29 \~W0_28 \~W1_31 \~W1_30 \~W1_29 \~W1_28) _sub163
    I64 (JR_8 JW_8 \~R0_31 \~R0_30 \~R0_29 \~R0_28 \~R1_31 \~R1_30 \~R1_29 \~R1_28 \~W0_31 \~W0_30 \~W0_29 \~W0_28 \~W1_31 \~W1_30 \~W1_29 \~W1_28) _sub163
    I56 (JR_7 JW_7 \~R0_31 \~R0_30 \~R0_29 \~R0_28 \~R1_31 \~R1_30 \~R1_29 \~R1_28 \~W0_31 \~W0_30 \~W0_29 \~W0_28 \~W1_31 \~W1_30 \~W1_29 \~W1_28) _sub163
    I48 (JR_6 JW_6 \~R0_31 \~R0_30 \~R0_29 \~R0_28 \~R1_31 \~R1_30 \~R1_29 \~R1_28 \~W0_31 \~W0_30 \~W0_29 \~W0_28 \~W1_31 \~W1_30 \~W1_29 \~W1_28) _sub163
    I40 (JR_5 JW_5 \~R0_31 \~R0_30 \~R0_29 \~R0_28 \~R1_31 \~R1_30 \~R1_29 \~R1_28 \~W0_31 \~W0_30 \~W0_29 \~W0_28 \~W1_31 \~W1_30 \~W1_29 \~W1_28) _sub163
    I32 (JR_4 JW_4 \~R0_31 \~R0_30 \~R0_29 \~R0_28 \~R1_31 \~R1_30 \~R1_29 \~R1_28 \~W0_31 \~W0_30 \~W0_29 \~W0_28 \~W1_31 \~W1_30 \~W1_29 \~W1_28) _sub163
    I24 (JR_3 JW_3 \~R0_31 \~R0_30 \~R0_29 \~R0_28 \~R1_31 \~R1_30 \~R1_29 \~R1_28 \~W0_31 \~W0_30 \~W0_29 \~W0_28 \~W1_31 \~W1_30 \~W1_29 \~W1_28) _sub163
    I16 (JR_2 JW_2 \~R0_31 \~R0_30 \~R0_29 \~R0_28 \~R1_31 \~R1_30 \~R1_29 \~R1_28 \~W0_31 \~W0_30 \~W0_29 \~W0_28 \~W1_31 \~W1_30 \~W1_29 \~W1_28) _sub163
    I8 (JR_1 JW_1 \~R0_31 \~R0_30 \~R0_29 \~R0_28 \~R1_31 \~R1_30 \~R1_29 \~R1_28 \~W0_31 \~W0_30 \~W0_29 \~W0_28 \~W1_31 \~W1_30 \~W1_29 \~W1_28) _sub163
    I7 (JR_0 JW_0 \~R0_3 \~R0_2 \~R0_1 \~R0_0 \~R1_3 \~R1_2 \~R1_1 \~R1_0 \~W0_3 \~W0_2 \~W0_1 \~W0_0 \~W1_3 \~W1_2 \~W1_1 \~W1_0) _sub163
    I6 (JR_0 JW_0 \~R0_7 \~R0_6 \~R0_5 \~R0_4 \~R1_7 \~R1_6 \~R1_5 \~R1_4 \~W0_7 \~W0_6 \~W0_5 \~W0_4 \~W1_7 \~W1_6 \~W1_5 \~W1_4) _sub163
    I5 (JR_0 JW_0 \~R0_11 \~R0_10 \~R0_9 \~R0_8 \~R1_11 \~R1_10 \~R1_9 \~R1_8 \~W0_11 \~W0_10 \~W0_9 \~W0_8 \~W1_11 \~W1_10 \~W1_9 \~W1_8) _sub163
    I4 (JR_0 JW_0 \~R0_15 \~R0_14 \~R0_13 \~R0_12 \~R1_15 \~R1_14 \~R1_13 \~R1_12 \~W0_15 \~W0_14 \~W0_13 \~W0_12 \~W1_15 \~W1_14 \~W1_13 \~W1_12) _sub163
    I3 (JR_0 JW_0 \~R0_19 \~R0_18 \~R0_17 \~R0_16 \~R1_19 \~R1_18 \~R1_17 \~R1_16 \~W0_19 \~W0_18 \~W0_17 \~W0_16 \~W1_19 \~W1_18 \~W1_17 \~W1_16) _sub163
    I2 (JR_0 JW_0 \~R0_23 \~R0_22 \~R0_21 \~R0_20 \~R1_23 \~R1_22 \~R1_21 \~R1_20 \~W0_23 \~W0_22 \~W0_21 \~W0_20 \~W1_23 \~W1_22 \~W1_21 \~W1_20) _sub163
    I1 (JR_0 JW_0 \~R0_27 \~R0_26 \~R0_25 \~R0_24 \~R1_27 \~R1_26 \~R1_25 \~R1_24 \~W0_27 \~W0_26 \~W0_25 \~W0_24 \~W1_27 \~W1_26 \~W1_25 \~W1_24) _sub163
    I0 (JR_0 JW_0 \~R0_31 \~R0_30 \~R0_29 \~R0_28 \~R1_31 \~R1_30 \~R1_29 \~R1_28 \~W0_31 \~W0_30 \~W0_29 \~W0_28 \~W1_31 \~W1_30 \~W1_29 \~W1_28) _sub163
ends _sub164

// 16nm/and2/schematic
//system verilogNetlist schematic cmos.sch cmos_sch veriloga ahdl
subckt and2 A B Y
    I8 (ntYbar Y) inv_1x
    I7 (A B ntYbar) nand_1x
ends and2

// 16nm/nand3_1x/schematic
//system verilogNetlist schematic cmos.sch cmos_sch veriloga ahdl
subckt nand3_1x A B C Y
    M4 (Y C vdd! vdd!) pfet w=80n l=16n m=1 region=off
    M1 (Y B vdd! vdd!) pfet w=80n l=16n m=1 region=off
    M0 (Y A vdd! vdd!) pfet w=80n l=16n m=1 region=off
    M6 (net026 C 0 0) nfet w=120n l=16n m=1
    M3 (net22 B net026 0) nfet w=120n l=16n m=1
    M2 (Y A net22 0) nfet w=120n l=16n m=1
ends nand3_1x

// 16nm/and3/schematic
//system verilogNetlist schematic cmos.sch cmos_sch veriloga ahdl
subckt and3 A B C Y
    I6 (A B C net1) nand3_1x
    I7 (net1 Y) inv_1x
ends and3

// 16nm/nor_1x/schematic
//system verilogNetlist schematic cmos.sch cmos_sch veriloga ahdl
subckt nor_1x A B Y
    M3 (Y B or_pd_ps vdd!) pfet w=160n l=16n m=1
    M2 (or_pd_ps A vdd! vdd!) pfet w=160n l=16n m=1
    M1 (Y B 0 0) nfet w=40n l=16n m=1
    M0 (Y A 0 0) nfet w=40n l=16n m=1
ends nor_1x

// 16nm/or2_1x/schematic
//system verilogNetlist schematic cmos.sch cmos_sch veriloga ahdl
subckt or2_1x A B Y
    I6 (A B AnorB) nor_1x
    I7 (AnorB Y) inv_1x
ends or2_1x

// 16nm/Decode_4to16/schematic
//system verilogNetlist schematic cmos.sch cmos_sch veriloga ahdl
subckt Decode_4to16 A_15 A_14 A_13 A_12 A_11 A_10 A_9 A_8 A_7 A_6 A_5 A_4 A_3 A_2 A_1 A_0 En I_3 I_2 I_1 I_0 Reset
    I7 (net5 net11 net1) and2
    I6 (I_0 net11 net064) and2
    I5 (net5 I_1 net062) and2
    I4 (I_0 I_1 net068) and2
    I3 (net37 net14 net079) and2
    I2 (I_2 net14 net069) and2
    I1 (net37 I_3 net19) and2
    I0 (I_2 I_3 net055) and2
    I11 (I_0 net5) inv_1x
    I10 (I_1 net11) inv_1x
    I9 (I_2 net37) inv_1x
    I8 (I_3 net14) inv_1x
    I59 (net068 net055 En net015) and3
    I58 (net062 net055 En net014) and3
    I57 (net064 net055 En net013) and3
    I56 (net1 net055 En net012) and3
    I55 (net068 net19 En net011) and3
    I54 (net062 net19 En net016) and3
    I53 (net064 net19 En net017) and3
    I52 (net1 net19 En net018) and3
    I51 (net068 net069 En net019) and3
    I50 (net062 net069 En net020) and3
    I49 (net064 net069 En net021) and3
    I48 (net1 net069 En net022) and3
    I47 (net068 net079 En net023) and3
    I46 (net062 net079 En net024) and3
    I45 (net064 net079 En net099) and3
    I44 (net1 net079 En net0100) and3
    I75 (Reset net015 A_15) or2_1x
    I74 (Reset net014 A_14) or2_1x
    I73 (Reset net013 A_13) or2_1x
    I72 (Reset net012 A_12) or2_1x
    I71 (Reset net011 A_11) or2_1x
    I70 (Reset net016 A_10) or2_1x
    I69 (Reset net017 A_9) or2_1x
    I68 (Reset net018 A_8) or2_1x
    I67 (Reset net019 A_7) or2_1x
    I66 (Reset net020 A_6) or2_1x
    I65 (Reset net021 A_5) or2_1x
    I64 (Reset net022 A_4) or2_1x
    I63 (Reset net023 A_3) or2_1x
    I62 (Reset net024 A_2) or2_1x
    I61 (Reset net099 A_1) or2_1x
    I60 (Reset net0100 A_0) or2_1x
ends Decode_4to16

// 16nm/Decode_1to2/schematic
//system verilogNetlist schematic cmos.sch cmos_sch veriloga ahdl
subckt Decode_1to2 En I Sel_1 Sel_0
    I6 (net8 net11) inv_1x
    I4 (I net8) inv_1x
    I0 (net8 En Sel_0) and2
    I1 (net11 En Sel_1) and2
ends Decode_1to2

// 16nm/nand4_1x/schematic
//system verilogNetlist schematic cmos.sch cmos_sch veriloga ahdl
subckt nand4_1x A B C D Y
    M5 (Y D vdd! vdd!) pfet w=90n l=20n ld=105n ls=105n m=1 region=sat degradation=no
    M4 (Y C vdd! vdd!) pfet w=90n l=20n ld=105n ls=105n m=1 region=sat degradation=no
    M1 (Y B vdd! vdd!) pfet w=90n l=20n ld=105n ls=105n m=1 region=sat degradation=no
    M0 (Y A vdd! vdd!) pfet w=90n l=20n ld=105n ls=105n m=1 region=sat degradation=no
    M7 (net23 D 0 0) nfet w=288n l=20n ld=105n ls=105n m=1 region=sat degradation=no
    M6 (net25 C net23 0) nfet w=288n l=20n ld=105n ls=105n m=1 region=sat degradation=no
    M3 (net24 B net25 0) nfet w=288n l=20n ld=105n ls=105n m=1 region=sat degradation=no
    M2 (Y A net24 0) nfet w=288n l=20n ld=105n ls=105n m=1 region=sat degradation=no
ends nand4_1x

// 16nm/and4_1x/schematic
//system verilogNetlist schematic cmos.sch cmos_sch veriloga ahdl
subckt and4_1x A B C D Y
    I15 (A B C D net1) nand4_1x
    I16 (net1 Y) inv_1x
ends and4_1x

// 16nm/nor4_1x/schematic
//system verilogNetlist schematic cmos.sch cmos_sch veriloga ahdl
subckt nor4_1x A B C D Y
    M5 (net017 C net21 vdd!) pfet w=360n l=16n m=1
    M4 (Y D net017 vdd!) pfet w=360n l=16n m=1
    M3 (net21 B net018 vdd!) pfet w=360n l=16n m=1
    M2 (net018 A vdd! vdd!) pfet w=360n l=16n m=1
    M7 (Y D 0 0) nfet w=40n l=16n m=1
    M6 (Y C 0 0) nfet w=40n l=16n m=1
    M1 (Y A 0 0) nfet w=40n l=16n m=1
    M0 (Y B 0 0) nfet w=40n l=16n m=1
ends nor4_1x

// 16nm/10T_DUAL_SRAM_AddrCtrl_aValid/schematic
//system verilogNetlist schematic cmos.sch cmos_sch veriloga ahdl
subckt _sub165 GoR GoW I_Read_4 I_Read_3 I_Read_2 I_Read_1 I_Read_0 I_Write_4 I_Write_3 I_Write_2 I_Write_1 I_Write_0 JRi_31 JRi_30 JRi_29 JRi_28 JRi_27 JRi_26 JRi_25 JRi_24 JRi_23 JRi_22 JRi_21 JRi_20 JRi_19 JRi_18 JRi_17 JRi_16 JRi_15 JRi_14 JRi_13 JRi_12 JRi_11 JRi_10 JRi_9 JRi_8 JRi_7 JRi_6 JRi_5 JRi_4 JRi_3 JRi_2 JRi_1 JRi_0 JWi_31 JWi_30 JWi_29 JWi_28 JWi_27 JWi_26 JWi_25 JWi_24 JWi_23 JWi_22 JWi_21 JWi_20 JWi_19 JWi_18 JWi_17 JWi_16 JWi_15 JWi_14 JWi_13 JWi_12 JWi_11 JWi_10 JWi_9 JWi_8 JWi_7 JWi_6 JWi_5 JWi_4 JWi_3 JWi_2 JWi_1 JWi_0 KRv KWv Reset
    I19 (JRi_15 JRi_14 JRi_13 JRi_12 JRi_11 JRi_10 JRi_9 JRi_8 JRi_7 JRi_6 JRi_5 JRi_4 JRi_3 JRi_2 JRi_1 JRi_0 RSel_0 I_Read_3 I_Read_2 I_Read_1 I_Read_0 net20) Decode_4to16
    I25 (JRi_31 JRi_30 JRi_29 JRi_28 JRi_27 JRi_26 JRi_25 JRi_24 JRi_23 JRi_22 JRi_21 JRi_20 JRi_19 JRi_18 JRi_17 JRi_16 RSel_1 I_Read_3 I_Read_2 I_Read_1 I_Read_0 net21) Decode_4to16
    I11 (JWi_31 JWi_30 JWi_29 JWi_28 JWi_27 JWi_26 JWi_25 JWi_24 JWi_23 JWi_22 JWi_21 JWi_20 JWi_19 JWi_18 JWi_17 JWi_16 WSel_1 I_Write_3 I_Write_2 I_Write_1 I_Write_0 Reset) Decode_4to16
    I5 (JWi_15 JWi_14 JWi_13 JWi_12 JWi_11 JWi_10 JWi_9 JWi_8 JWi_7 JWi_6 JWi_5 JWi_4 JWi_3 JWi_2 JWi_1 JWi_0 WSel_0 I_Write_3 I_Write_2 I_Write_1 I_Write_0 Reset) Decode_4to16
    I16 (GoR I_Read_4 RSel_1 RSel_0) Decode_1to2
    I2 (GoW I_Write_4 WSel_1 WSel_0) Decode_1to2
    I17 (rn1 rn2 rn3 rn4 rn9) and4_1x
    I24 (rn5 rn6 rn7 rn8 rn10) and4_1x
    I3 (wn1 wn2 wn3 wn4 wn9) and4_1x
    I10 (wn5 wn6 wn7 wn8 wn10) and4_1x
    I14 (JRi_0 JRi_1 JRi_2 JRi_3 rn1) nor4_1x
    I15 (JRi_4 JRi_5 JRi_6 JRi_7 rn2) nor4_1x
    I18 (JRi_8 JRi_9 JRi_10 JRi_11 rn3) nor4_1x
    I20 (JRi_12 JRi_13 JRi_14 JRi_15 rn4) nor4_1x
    I22 (JRi_16 JRi_17 JRi_18 JRi_19 rn5) nor4_1x
    I23 (JRi_20 JRi_21 JRi_22 JRi_23 rn6) nor4_1x
    I26 (JRi_24 JRi_25 JRi_26 JRi_27 rn7) nor4_1x
    I13 (JWi_28 JWi_29 JWi_30 JWi_31 wn8) nor4_1x
    I12 (JWi_24 JWi_25 JWi_26 JWi_27 wn7) nor4_1x
    I9 (JWi_20 JWi_21 JWi_22 JWi_23 wn6) nor4_1x
    I8 (JWi_16 JWi_17 JWi_18 JWi_19 wn5) nor4_1x
    I6 (JWi_12 JWi_13 JWi_14 JWi_15 wn4) nor4_1x
    I4 (JWi_8 JWi_9 JWi_10 JWi_11 wn3) nor4_1x
    I0 (JWi_0 JWi_1 JWi_2 JWi_3 wn1) nor4_1x
    I1 (JWi_4 JWi_5 JWi_6 JWi_7 wn2) nor4_1x
    I27 (JRi_28 JRi_29 JRi_30 JRi_31 rn8) nor4_1x
    I21 (rn9 rn10 KRv) nand_1x
    I7 (wn9 wn10 KWv) nand_1x
ends _sub165

// 16nm/10T_RPrecharge/schematic
//system verilogNetlist schematic cmos.sch cmos_sch veriloga ahdl
subckt _sub166 Re Re2 \~R0 \~R1
    I1 (\~R1 Pch vdd! vdd!) pfet w=80n l=16n m=1
    I0 (\~R0 Pch vdd! vdd!) pfet w=80n l=16n m=1
    I3 (Re2 Re Pch) TH22
ends _sub166

// 16nm/10T_DUAL_SRAM_RPrecharge/schematic
//system verilogNetlist schematic cmos.sch cmos_sch veriloga ahdl
subckt _sub167 Re Re2_7 Re2_6 Re2_5 Re2_4 Re2_3 Re2_2 Re2_1 Re2_0 \~R0_31 \~R0_30 \~R0_29 \~R0_28 \~R0_27 \~R0_26 \~R0_25 \~R0_24 \~R0_23 \~R0_22 \~R0_21 \~R0_20 \~R0_19 \~R0_18 \~R0_17 \~R0_16 \~R0_15 \~R0_14 \~R0_13 \~R0_12 \~R0_11 \~R0_10 \~R0_9 \~R0_8 \~R0_7 \~R0_6 \~R0_5 \~R0_4 \~R0_3 \~R0_2 \~R0_1 \~R0_0 \~R1_31 \~R1_30 \~R1_29 \~R1_28 \~R1_27 \~R1_26 \~R1_25 \~R1_24 \~R1_23 \~R1_22 \~R1_21 \~R1_20 \~R1_19 \~R1_18 \~R1_17 \~R1_16 \~R1_15 \~R1_14 \~R1_13 \~R1_12 \~R1_11 \~R1_10 \~R1_9 \~R1_8 \~R1_7 \~R1_6 \~R1_5 \~R1_4 \~R1_3 \~R1_2 \~R1_1 \~R1_0
    I3_3 (Re Re2_0 \~R0_3 \~R1_3) _sub166
    I3_2 (Re Re2_0 \~R0_2 \~R1_2) _sub166
    I3_1 (Re Re2_0 \~R0_1 \~R1_1) _sub166
    I3_0 (Re Re2_0 \~R0_0 \~R1_0) _sub166
    I4_3 (Re Re2_1 \~R0_7 \~R1_7) _sub166
    I4_2 (Re Re2_1 \~R0_6 \~R1_6) _sub166
    I4_1 (Re Re2_1 \~R0_5 \~R1_5) _sub166
    I4_0 (Re Re2_1 \~R0_4 \~R1_4) _sub166
    I5_3 (Re Re2_2 \~R0_11 \~R1_11) _sub166
    I5_2 (Re Re2_2 \~R0_10 \~R1_10) _sub166
    I5_1 (Re Re2_2 \~R0_9 \~R1_9) _sub166
    I5_0 (Re Re2_2 \~R0_8 \~R1_8) _sub166
    I6_3 (Re Re2_3 \~R0_15 \~R1_15) _sub166
    I6_2 (Re Re2_3 \~R0_14 \~R1_14) _sub166
    I6_1 (Re Re2_3 \~R0_13 \~R1_13) _sub166
    I6_0 (Re Re2_3 \~R0_12 \~R1_12) _sub166
    I7_3 (Re Re2_4 \~R0_19 \~R1_19) _sub166
    I7_2 (Re Re2_4 \~R0_18 \~R1_18) _sub166
    I7_1 (Re Re2_4 \~R0_17 \~R1_17) _sub166
    I7_0 (Re Re2_4 \~R0_16 \~R1_16) _sub166
    I8_3 (Re Re2_5 \~R0_23 \~R1_23) _sub166
    I8_2 (Re Re2_5 \~R0_22 \~R1_22) _sub166
    I8_1 (Re Re2_5 \~R0_21 \~R1_21) _sub166
    I8_0 (Re Re2_5 \~R0_20 \~R1_20) _sub166
    I9_3 (Re Re2_6 \~R0_27 \~R1_27) _sub166
    I9_2 (Re Re2_6 \~R0_26 \~R1_26) _sub166
    I9_1 (Re Re2_6 \~R0_25 \~R1_25) _sub166
    I9_0 (Re Re2_6 \~R0_24 \~R1_24) _sub166
    I10_3 (Re Re2_7 \~R0_31 \~R1_31) _sub166
    I10_2 (Re Re2_7 \~R0_30 \~R1_30) _sub166
    I10_1 (Re Re2_7 \~R0_29 \~R1_29) _sub166
    I10_0 (Re Re2_7 \~R0_28 \~R1_28) _sub166
ends _sub167

// 16nm/10T_DUAL_SRAM_REGFILE/schematic
//system verilogNetlist schematic cmos.sch cmos_sch veriloga ahdl
subckt _sub168 GoR GoW KRe KWe R0_31 R0_30 R0_29 R0_28 R0_27 R0_26 R0_25 R0_24 R0_23 R0_22 R0_21 R0_20 R0_19 R0_18 R0_17 R0_16 R0_15 R0_14 R0_13 R0_12 R0_11 R0_10 R0_9 R0_8 R0_7 R0_6 R0_5 R0_4 R0_3 R0_2 R0_1 R0_0 R1_31 R1_30 R1_29 R1_28 R1_27 R1_26 R1_25 R1_24 R1_23 R1_22 R1_21 R1_20 R1_19 R1_18 R1_17 R1_16 R1_15 R1_14 R1_13 R1_12 R1_11 R1_10 R1_9 R1_8 R1_7 R1_6 R1_5 R1_4 R1_3 R1_2 R1_1 R1_0 R_Addr_4 R_Addr_3 R_Addr_2 R_Addr_1 R_Addr_0 Re Reset W0_31 W0_30 W0_29 W0_28 W0_27 W0_26 W0_25 W0_24 W0_23 W0_22 W0_21 W0_20 W0_19 W0_18 W0_17 W0_16 W0_15 W0_14 W0_13 W0_12 W0_11 W0_10 W0_9 W0_8 W0_7 W0_6 W0_5 W0_4 W0_3 W0_2 W0_1 W0_0 W1_31 W1_30 W1_29 W1_28 W1_27 W1_26 W1_25 W1_24 W1_23 W1_22 W1_21 W1_20 W1_19 W1_18 W1_17 W1_16 W1_15 W1_14 W1_13 W1_12 W1_11 W1_10 W1_9 W1_8 W1_7 W1_6 W1_5 W1_4 W1_3 W1_2 W1_1 W1_0 W_Addr_4 W_Addr_3 W_Addr_2 W_Addr_1 W_Addr_0 We_7 We_6 We_5 We_4 We_3 We_2 We_1 We_0
    I0 (KRe KRv KWe KWv R0_31 R0_30 R0_29 R0_28 R0_27 R0_26 R0_25 R0_24 R0_23 R0_22 R0_21 R0_20 R0_19 R0_18 R0_17 R0_16 R0_15 R0_14 R0_13 R0_12 R0_11 R0_10 R0_9 R0_8 R0_7 R0_6 R0_5 R0_4 R0_3 R0_2 R0_1 R0_0 R1_31 R1_30 R1_29 R1_28 R1_27 R1_26 R1_25 R1_24 R1_23 R1_22 R1_21 R1_20 R1_19 R1_18 R1_17 R1_16 R1_15 R1_14 R1_13 R1_12 R1_11 R1_10 R1_9 R1_8 R1_7 R1_6 R1_5 R1_4 R1_3 R1_2 R1_1 R1_0 Re2_7 Re2_6 Re2_5 Re2_4 Re2_3 Re2_2 Re2_1 Re2_0 W0_31 W0_30 W0_29 W0_28 W0_27 W0_26 W0_25 W0_24 W0_23 W0_22 W0_21 W0_20 W0_19 W0_18 W0_17 W0_16 W0_15 W0_14 W0_13 W0_12 W0_11 W0_10 W0_9 W0_8 W0_7 W0_6 W0_5 W0_4 W0_3 W0_2 W0_1 W0_0 W1_31 W1_30 W1_29 W1_28 W1_27 W1_26 W1_25 W1_24 W1_23 W1_22 W1_21 W1_20 W1_19 W1_18 W1_17 W1_16 W1_15 W1_14 W1_13 W1_12 W1_11 W1_10 W1_9 W1_8 W1_7 W1_6 W1_5 W1_4 W1_3 W1_2 W1_1 W1_0 We_7 We_6 We_5 We_4 We_3 We_2 We_1 We_0 \~R0_31 \~R0_30 \~R0_29 \~R0_28 \~R0_27 \~R0_26 \~R0_25 \~R0_24 \~R0_23 \~R0_22 \~R0_21 \~R0_20 \~R0_19 \~R0_18 \~R0_17 \~R0_16 \~R0_15 \~R0_14 \~R0_13 \~R0_12 \~R0_11 \~R0_10 \~R0_9 \~R0_8 \~R0_7 \~R0_6 \~R0_5 \~R0_4 \~R0_3 \~R0_2 \~R0_1 \~R0_0 \~R1_31 \~R1_30 \~R1_29 \~R1_28 \~R1_27 \~R1_26 \~R1_25 \~R1_24 \~R1_23 \~R1_22 \~R1_21 \~R1_20 \~R1_19 \~R1_18 \~R1_17 \~R1_16 \~R1_15 \~R1_14 \~R1_13 \~R1_12 \~R1_11 \~R1_10 \~R1_9 \~R1_8 \~R1_7 \~R1_6 \~R1_5 \~R1_4 \~R1_3 \~R1_2 \~R1_1 \~R1_0 \~W0_31 \~W0_30 \~W0_29 \~W0_28 \~W0_27 \~W0_26 \~W0_25 \~W0_24 \~W0_23 \~W0_22 \~W0_21 \~W0_20 \~W0_19 \~W0_18 \~W0_17 \~W0_16 \~W0_15 \~W0_14 \~W0_13 \~W0_12 \~W0_11 \~W0_10 \~W0_9 \~W0_8 \~W0_7 \~W0_6 \~W0_5 \~W0_4 \~W0_3 \~W0_2 \~W0_1 \~W0_0 \~W1_31 \~W1_30 \~W1_29 \~W1_28 \~W1_27 \~W1_26 \~W1_25 \~W1_24 \~W1_23 \~W1_22 \~W1_21 \~W1_20 \~W1_19 \~W1_18 \~W1_17 \~W1_16 \~W1_15 \~W1_14 \~W1_13 \~W1_12 \~W1_11 \~W1_10 \~W1_9 \~W1_8 \~W1_7 \~W1_6 \~W1_5 \~W1_4 \~W1_3 \~W1_2 \~W1_1 \~W1_0) _sub161
    I1 (JRi_31 JRi_30 JRi_29 JRi_28 JRi_27 JRi_26 JRi_25 JRi_24 JRi_23 JRi_22 JRi_21 JRi_20 JRi_19 JRi_18 JRi_17 JRi_16 JRi_15 JRi_14 JRi_13 JRi_12 JRi_11 JRi_10 JRi_9 JRi_8 JRi_7 JRi_6 JRi_5 JRi_4 JRi_3 JRi_2 JRi_1 JRi_0 JWi_31 JWi_30 JWi_29 JWi_28 JWi_27 JWi_26 JWi_25 JWi_24 JWi_23 JWi_22 JWi_21 JWi_20 JWi_19 JWi_18 JWi_17 JWi_16 JWi_15 JWi_14 JWi_13 JWi_12 JWi_11 JWi_10 JWi_9 JWi_8 JWi_7 JWi_6 JWi_5 JWi_4 JWi_3 JWi_2 JWi_1 JWi_0 \~R0_31 \~R0_30 \~R0_29 \~R0_28 \~R0_27 \~R0_26 \~R0_25 \~R0_24 \~R0_23 \~R0_22 \~R0_21 \~R0_20 \~R0_19 \~R0_18 \~R0_17 \~R0_16 \~R0_15 \~R0_14 \~R0_13 \~R0_12 \~R0_11 \~R0_10 \~R0_9 \~R0_8 \~R0_7 \~R0_6 \~R0_5 \~R0_4 \~R0_3 \~R0_2 \~R0_1 \~R0_0 \~R1_31 \~R1_30 \~R1_29 \~R1_28 \~R1_27 \~R1_26 \~R1_25 \~R1_24 \~R1_23 \~R1_22 \~R1_21 \~R1_20 \~R1_19 \~R1_18 \~R1_17 \~R1_16 \~R1_15 \~R1_14 \~R1_13 \~R1_12 \~R1_11 \~R1_10 \~R1_9 \~R1_8 \~R1_7 \~R1_6 \~R1_5 \~R1_4 \~R1_3 \~R1_2 \~R1_1 \~R1_0 \~W0_31 \~W0_30 \~W0_29 \~W0_28 \~W0_27 \~W0_26 \~W0_25 \~W0_24 \~W0_23 \~W0_22 \~W0_21 \~W0_20 \~W0_19 \~W0_18 \~W0_17 \~W0_16 \~W0_15 \~W0_14 \~W0_13 \~W0_12 \~W0_11 \~W0_10 \~W0_9 \~W0_8 \~W0_7 \~W0_6 \~W0_5 \~W0_4 \~W0_3 \~W0_2 \~W0_1 \~W0_0 \~W1_31 \~W1_30 \~W1_29 \~W1_28 \~W1_27 \~W1_26 \~W1_25 \~W1_24 \~W1_23 \~W1_22 \~W1_21 \~W1_20 \~W1_19 \~W1_18 \~W1_17 \~W1_16 \~W1_15 \~W1_14 \~W1_13 \~W1_12 \~W1_11 \~W1_10 \~W1_9 \~W1_8 \~W1_7 \~W1_6 \~W1_5 \~W1_4 \~W1_3 \~W1_2 \~W1_1 \~W1_0) _sub164
    I2 (GoR GoW R_Addr_4 R_Addr_3 R_Addr_2 R_Addr_1 R_Addr_0 W_Addr_4 W_Addr_3 W_Addr_2 W_Addr_1 W_Addr_0 JRi_31 JRi_30 JRi_29 JRi_28 JRi_27 JRi_26 JRi_25 JRi_24 JRi_23 JRi_22 JRi_21 JRi_20 JRi_19 JRi_18 JRi_17 JRi_16 JRi_15 JRi_14 JRi_13 JRi_12 JRi_11 JRi_10 JRi_9 JRi_8 JRi_7 JRi_6 JRi_5 JRi_4 JRi_3 JRi_2 JRi_1 JRi_0 JWi_31 JWi_30 JWi_29 JWi_28 JWi_27 JWi_26 JWi_25 JWi_24 JWi_23 JWi_22 JWi_21 JWi_20 JWi_19 JWi_18 JWi_17 JWi_16 JWi_15 JWi_14 JWi_13 JWi_12 JWi_11 JWi_10 JWi_9 JWi_8 JWi_7 JWi_6 JWi_5 JWi_4 JWi_3 JWi_2 JWi_1 JWi_0 KRv KWv Reset) _sub165
    I3 (Re Re2_7 Re2_6 Re2_5 Re2_4 Re2_3 Re2_2 Re2_1 Re2_0 \~R0_31 \~R0_30 \~R0_29 \~R0_28 \~R0_27 \~R0_26 \~R0_25 \~R0_24 \~R0_23 \~R0_22 \~R0_21 \~R0_20 \~R0_19 \~R0_18 \~R0_17 \~R0_16 \~R0_15 \~R0_14 \~R0_13 \~R0_12 \~R0_11 \~R0_10 \~R0_9 \~R0_8 \~R0_7 \~R0_6 \~R0_5 \~R0_4 \~R0_3 \~R0_2 \~R0_1 \~R0_0 \~R1_31 \~R1_30 \~R1_29 \~R1_28 \~R1_27 \~R1_26 \~R1_25 \~R1_24 \~R1_23 \~R1_22 \~R1_21 \~R1_20 \~R1_19 \~R1_18 \~R1_17 \~R1_16 \~R1_15 \~R1_14 \~R1_13 \~R1_12 \~R1_11 \~R1_10 \~R1_9 \~R1_8 \~R1_7 \~R1_6 \~R1_5 \~R1_4 \~R1_3 \~R1_2 \~R1_1 \~R1_0) _sub167
ends _sub168

// 16nm/Decode_2to4/schematic
//system verilogNetlist schematic cmos.sch cmos_sch veriloga ahdl
subckt Decode_2to4 En I_1 I_0 Sel_3 Sel_2 Sel_1 Sel_0
    I5 (I_1 net6) inv_1x
    I4 (I_0 net10) inv_1x
    I3 (I_0 En I_1 Sel_3) and3
    I2 (net10 En I_1 Sel_2) and3
    I1 (I_0 En net6 Sel_1) and3
    I0 (net10 En net6 Sel_0) and3
ends Decode_2to4

// 16nm/Mux_128to32/schematic
//system verilogNetlist schematic cmos.sch cmos_sch veriloga ahdl
subckt Mux_128to32 En S_1 S_0 X1_31 X1_30 X1_29 X1_28 X1_27 X1_26 X1_25 X1_24 X1_23 X1_22 X1_21 X1_20 X1_19 X1_18 X1_17 X1_16 X1_15 X1_14 X1_13 X1_12 X1_11 X1_10 X1_9 X1_8 X1_7 X1_6 X1_5 X1_4 X1_3 X1_2 X1_1 X1_0 X2_31 X2_30 X2_29 X2_28 X2_27 X2_26 X2_25 X2_24 X2_23 X2_22 X2_21 X2_20 X2_19 X2_18 X2_17 X2_16 X2_15 X2_14 X2_13 X2_12 X2_11 X2_10 X2_9 X2_8 X2_7 X2_6 X2_5 X2_4 X2_3 X2_2 X2_1 X2_0 X3_31 X3_30 X3_29 X3_28 X3_27 X3_26 X3_25 X3_24 X3_23 X3_22 X3_21 X3_20 X3_19 X3_18 X3_17 X3_16 X3_15 X3_14 X3_13 X3_12 X3_11 X3_10 X3_9 X3_8 X3_7 X3_6 X3_5 X3_4 X3_3 X3_2 X3_1 X3_0 X4_31 X4_30 X4_29 X4_28 X4_27 X4_26 X4_25 X4_24 X4_23 X4_22 X4_21 X4_20 X4_19 X4_18 X4_17 X4_16 X4_15 X4_14 X4_13 X4_12 X4_11 X4_10 X4_9 X4_8 X4_7 X4_6 X4_5 X4_4 X4_3 X4_2 X4_1 X4_0 Y_31 Y_30 Y_29 Y_28 Y_27 Y_26 Y_25 Y_24 Y_23 Y_22 Y_21 Y_20 Y_19 Y_18 Y_17 Y_16 Y_15 Y_14 Y_13 Y_12 Y_11 Y_10 Y_9 Y_8 Y_7 Y_6 Y_5 Y_4 Y_3 Y_2 Y_1 Y_0
    I4_1 (S_1 \~S_1) inv_1x
    I4_0 (S_0 \~S_0) inv_1x
    I0_31 (X1_31 En \~S_0 \~S_1 net25_0) nand4_1x
    I0_30 (X1_30 En \~S_0 \~S_1 net25_1) nand4_1x
    I0_29 (X1_29 En \~S_0 \~S_1 net25_2) nand4_1x
    I0_28 (X1_28 En \~S_0 \~S_1 net25_3) nand4_1x
    I0_27 (X1_27 En \~S_0 \~S_1 net25_4) nand4_1x
    I0_26 (X1_26 En \~S_0 \~S_1 net25_5) nand4_1x
    I0_25 (X1_25 En \~S_0 \~S_1 net25_6) nand4_1x
    I0_24 (X1_24 En \~S_0 \~S_1 net25_7) nand4_1x
    I0_23 (X1_23 En \~S_0 \~S_1 net25_8) nand4_1x
    I0_22 (X1_22 En \~S_0 \~S_1 net25_9) nand4_1x
    I0_21 (X1_21 En \~S_0 \~S_1 net25_10) nand4_1x
    I0_20 (X1_20 En \~S_0 \~S_1 net25_11) nand4_1x
    I0_19 (X1_19 En \~S_0 \~S_1 net25_12) nand4_1x
    I0_18 (X1_18 En \~S_0 \~S_1 net25_13) nand4_1x
    I0_17 (X1_17 En \~S_0 \~S_1 net25_14) nand4_1x
    I0_16 (X1_16 En \~S_0 \~S_1 net25_15) nand4_1x
    I0_15 (X1_15 En \~S_0 \~S_1 net25_16) nand4_1x
    I0_14 (X1_14 En \~S_0 \~S_1 net25_17) nand4_1x
    I0_13 (X1_13 En \~S_0 \~S_1 net25_18) nand4_1x
    I0_12 (X1_12 En \~S_0 \~S_1 net25_19) nand4_1x
    I0_11 (X1_11 En \~S_0 \~S_1 net25_20) nand4_1x
    I0_10 (X1_10 En \~S_0 \~S_1 net25_21) nand4_1x
    I0_9 (X1_9 En \~S_0 \~S_1 net25_22) nand4_1x
    I0_8 (X1_8 En \~S_0 \~S_1 net25_23) nand4_1x
    I0_7 (X1_7 En \~S_0 \~S_1 net25_24) nand4_1x
    I0_6 (X1_6 En \~S_0 \~S_1 net25_25) nand4_1x
    I0_5 (X1_5 En \~S_0 \~S_1 net25_26) nand4_1x
    I0_4 (X1_4 En \~S_0 \~S_1 net25_27) nand4_1x
    I0_3 (X1_3 En \~S_0 \~S_1 net25_28) nand4_1x
    I0_2 (X1_2 En \~S_0 \~S_1 net25_29) nand4_1x
    I0_1 (X1_1 En \~S_0 \~S_1 net25_30) nand4_1x
    I0_0 (X1_0 En \~S_0 \~S_1 net25_31) nand4_1x
    I6_31 (net25_0 net24_0 net23_0 net22_0 Y_31) nand4_1x
    I6_30 (net25_1 net24_1 net23_1 net22_1 Y_30) nand4_1x
    I6_29 (net25_2 net24_2 net23_2 net22_2 Y_29) nand4_1x
    I6_28 (net25_3 net24_3 net23_3 net22_3 Y_28) nand4_1x
    I6_27 (net25_4 net24_4 net23_4 net22_4 Y_27) nand4_1x
    I6_26 (net25_5 net24_5 net23_5 net22_5 Y_26) nand4_1x
    I6_25 (net25_6 net24_6 net23_6 net22_6 Y_25) nand4_1x
    I6_24 (net25_7 net24_7 net23_7 net22_7 Y_24) nand4_1x
    I6_23 (net25_8 net24_8 net23_8 net22_8 Y_23) nand4_1x
    I6_22 (net25_9 net24_9 net23_9 net22_9 Y_22) nand4_1x
    I6_21 (net25_10 net24_10 net23_10 net22_10 Y_21) nand4_1x
    I6_20 (net25_11 net24_11 net23_11 net22_11 Y_20) nand4_1x
    I6_19 (net25_12 net24_12 net23_12 net22_12 Y_19) nand4_1x
    I6_18 (net25_13 net24_13 net23_13 net22_13 Y_18) nand4_1x
    I6_17 (net25_14 net24_14 net23_14 net22_14 Y_17) nand4_1x
    I6_16 (net25_15 net24_15 net23_15 net22_15 Y_16) nand4_1x
    I6_15 (net25_16 net24_16 net23_16 net22_16 Y_15) nand4_1x
    I6_14 (net25_17 net24_17 net23_17 net22_17 Y_14) nand4_1x
    I6_13 (net25_18 net24_18 net23_18 net22_18 Y_13) nand4_1x
    I6_12 (net25_19 net24_19 net23_19 net22_19 Y_12) nand4_1x
    I6_11 (net25_20 net24_20 net23_20 net22_20 Y_11) nand4_1x
    I6_10 (net25_21 net24_21 net23_21 net22_21 Y_10) nand4_1x
    I6_9 (net25_22 net24_22 net23_22 net22_22 Y_9) nand4_1x
    I6_8 (net25_23 net24_23 net23_23 net22_23 Y_8) nand4_1x
    I6_7 (net25_24 net24_24 net23_24 net22_24 Y_7) nand4_1x
    I6_6 (net25_25 net24_25 net23_25 net22_25 Y_6) nand4_1x
    I6_5 (net25_26 net24_26 net23_26 net22_26 Y_5) nand4_1x
    I6_4 (net25_27 net24_27 net23_27 net22_27 Y_4) nand4_1x
    I6_3 (net25_28 net24_28 net23_28 net22_28 Y_3) nand4_1x
    I6_2 (net25_29 net24_29 net23_29 net22_29 Y_2) nand4_1x
    I6_1 (net25_30 net24_30 net23_30 net22_30 Y_1) nand4_1x
    I6_0 (net25_31 net24_31 net23_31 net22_31 Y_0) nand4_1x
    I3_31 (X4_31 En S_0 S_1 net22_0) nand4_1x
    I3_30 (X4_30 En S_0 S_1 net22_1) nand4_1x
    I3_29 (X4_29 En S_0 S_1 net22_2) nand4_1x
    I3_28 (X4_28 En S_0 S_1 net22_3) nand4_1x
    I3_27 (X4_27 En S_0 S_1 net22_4) nand4_1x
    I3_26 (X4_26 En S_0 S_1 net22_5) nand4_1x
    I3_25 (X4_25 En S_0 S_1 net22_6) nand4_1x
    I3_24 (X4_24 En S_0 S_1 net22_7) nand4_1x
    I3_23 (X4_23 En S_0 S_1 net22_8) nand4_1x
    I3_22 (X4_22 En S_0 S_1 net22_9) nand4_1x
    I3_21 (X4_21 En S_0 S_1 net22_10) nand4_1x
    I3_20 (X4_20 En S_0 S_1 net22_11) nand4_1x
    I3_19 (X4_19 En S_0 S_1 net22_12) nand4_1x
    I3_18 (X4_18 En S_0 S_1 net22_13) nand4_1x
    I3_17 (X4_17 En S_0 S_1 net22_14) nand4_1x
    I3_16 (X4_16 En S_0 S_1 net22_15) nand4_1x
    I3_15 (X4_15 En S_0 S_1 net22_16) nand4_1x
    I3_14 (X4_14 En S_0 S_1 net22_17) nand4_1x
    I3_13 (X4_13 En S_0 S_1 net22_18) nand4_1x
    I3_12 (X4_12 En S_0 S_1 net22_19) nand4_1x
    I3_11 (X4_11 En S_0 S_1 net22_20) nand4_1x
    I3_10 (X4_10 En S_0 S_1 net22_21) nand4_1x
    I3_9 (X4_9 En S_0 S_1 net22_22) nand4_1x
    I3_8 (X4_8 En S_0 S_1 net22_23) nand4_1x
    I3_7 (X4_7 En S_0 S_1 net22_24) nand4_1x
    I3_6 (X4_6 En S_0 S_1 net22_25) nand4_1x
    I3_5 (X4_5 En S_0 S_1 net22_26) nand4_1x
    I3_4 (X4_4 En S_0 S_1 net22_27) nand4_1x
    I3_3 (X4_3 En S_0 S_1 net22_28) nand4_1x
    I3_2 (X4_2 En S_0 S_1 net22_29) nand4_1x
    I3_1 (X4_1 En S_0 S_1 net22_30) nand4_1x
    I3_0 (X4_0 En S_0 S_1 net22_31) nand4_1x
    I2_31 (X3_31 En \~S_0 S_1 net23_0) nand4_1x
    I2_30 (X3_30 En \~S_0 S_1 net23_1) nand4_1x
    I2_29 (X3_29 En \~S_0 S_1 net23_2) nand4_1x
    I2_28 (X3_28 En \~S_0 S_1 net23_3) nand4_1x
    I2_27 (X3_27 En \~S_0 S_1 net23_4) nand4_1x
    I2_26 (X3_26 En \~S_0 S_1 net23_5) nand4_1x
    I2_25 (X3_25 En \~S_0 S_1 net23_6) nand4_1x
    I2_24 (X3_24 En \~S_0 S_1 net23_7) nand4_1x
    I2_23 (X3_23 En \~S_0 S_1 net23_8) nand4_1x
    I2_22 (X3_22 En \~S_0 S_1 net23_9) nand4_1x
    I2_21 (X3_21 En \~S_0 S_1 net23_10) nand4_1x
    I2_20 (X3_20 En \~S_0 S_1 net23_11) nand4_1x
    I2_19 (X3_19 En \~S_0 S_1 net23_12) nand4_1x
    I2_18 (X3_18 En \~S_0 S_1 net23_13) nand4_1x
    I2_17 (X3_17 En \~S_0 S_1 net23_14) nand4_1x
    I2_16 (X3_16 En \~S_0 S_1 net23_15) nand4_1x
    I2_15 (X3_15 En \~S_0 S_1 net23_16) nand4_1x
    I2_14 (X3_14 En \~S_0 S_1 net23_17) nand4_1x
    I2_13 (X3_13 En \~S_0 S_1 net23_18) nand4_1x
    I2_12 (X3_12 En \~S_0 S_1 net23_19) nand4_1x
    I2_11 (X3_11 En \~S_0 S_1 net23_20) nand4_1x
    I2_10 (X3_10 En \~S_0 S_1 net23_21) nand4_1x
    I2_9 (X3_9 En \~S_0 S_1 net23_22) nand4_1x
    I2_8 (X3_8 En \~S_0 S_1 net23_23) nand4_1x
    I2_7 (X3_7 En \~S_0 S_1 net23_24) nand4_1x
    I2_6 (X3_6 En \~S_0 S_1 net23_25) nand4_1x
    I2_5 (X3_5 En \~S_0 S_1 net23_26) nand4_1x
    I2_4 (X3_4 En \~S_0 S_1 net23_27) nand4_1x
    I2_3 (X3_3 En \~S_0 S_1 net23_28) nand4_1x
    I2_2 (X3_2 En \~S_0 S_1 net23_29) nand4_1x
    I2_1 (X3_1 En \~S_0 S_1 net23_30) nand4_1x
    I2_0 (X3_0 En \~S_0 S_1 net23_31) nand4_1x
    I1_31 (X2_31 En S_0 \~S_1 net24_0) nand4_1x
    I1_30 (X2_30 En S_0 \~S_1 net24_1) nand4_1x
    I1_29 (X2_29 En S_0 \~S_1 net24_2) nand4_1x
    I1_28 (X2_28 En S_0 \~S_1 net24_3) nand4_1x
    I1_27 (X2_27 En S_0 \~S_1 net24_4) nand4_1x
    I1_26 (X2_26 En S_0 \~S_1 net24_5) nand4_1x
    I1_25 (X2_25 En S_0 \~S_1 net24_6) nand4_1x
    I1_24 (X2_24 En S_0 \~S_1 net24_7) nand4_1x
    I1_23 (X2_23 En S_0 \~S_1 net24_8) nand4_1x
    I1_22 (X2_22 En S_0 \~S_1 net24_9) nand4_1x
    I1_21 (X2_21 En S_0 \~S_1 net24_10) nand4_1x
    I1_20 (X2_20 En S_0 \~S_1 net24_11) nand4_1x
    I1_19 (X2_19 En S_0 \~S_1 net24_12) nand4_1x
    I1_18 (X2_18 En S_0 \~S_1 net24_13) nand4_1x
    I1_17 (X2_17 En S_0 \~S_1 net24_14) nand4_1x
    I1_16 (X2_16 En S_0 \~S_1 net24_15) nand4_1x
    I1_15 (X2_15 En S_0 \~S_1 net24_16) nand4_1x
    I1_14 (X2_14 En S_0 \~S_1 net24_17) nand4_1x
    I1_13 (X2_13 En S_0 \~S_1 net24_18) nand4_1x
    I1_12 (X2_12 En S_0 \~S_1 net24_19) nand4_1x
    I1_11 (X2_11 En S_0 \~S_1 net24_20) nand4_1x
    I1_10 (X2_10 En S_0 \~S_1 net24_21) nand4_1x
    I1_9 (X2_9 En S_0 \~S_1 net24_22) nand4_1x
    I1_8 (X2_8 En S_0 \~S_1 net24_23) nand4_1x
    I1_7 (X2_7 En S_0 \~S_1 net24_24) nand4_1x
    I1_6 (X2_6 En S_0 \~S_1 net24_25) nand4_1x
    I1_5 (X2_5 En S_0 \~S_1 net24_26) nand4_1x
    I1_4 (X2_4 En S_0 \~S_1 net24_27) nand4_1x
    I1_3 (X2_3 En S_0 \~S_1 net24_28) nand4_1x
    I1_2 (X2_2 En S_0 \~S_1 net24_29) nand4_1x
    I1_1 (X2_1 En S_0 \~S_1 net24_30) nand4_1x
    I1_0 (X2_0 En S_0 \~S_1 net24_31) nand4_1x
ends Mux_128to32

// 16nm/Dcache_TagMem/schematic
//system verilogNetlist schematic cmos.sch cmos_sch veriloga ahdl
subckt Dcache_TagMem GoR GoW KRe KWe R1_31 R1_30 R1_29 R1_28 R1_27 R1_26 R1_25 R1_24 R1_23 R1_22 R1_21 R1_20 R1_19 R1_18 R1_17 R1_16 R1_15 R1_14 R1_13 R1_12 R1_11 R1_10 R1_9 R1_8 R1_7 R1_6 R1_5 R1_4 R1_3 R1_2 R1_1 R1_0 R_Addr_6 R_Addr_5 R_Addr_4 R_Addr_3 R_Addr_2 R_Addr_1 R_Addr_0 Reset W0_31 W0_30 W0_29 W0_28 W0_27 W0_26 W0_25 W0_24 W0_23 W0_22 W0_21 W0_20 W0_19 W0_18 W0_17 W0_16 W0_15 W0_14 W0_13 W0_12 W0_11 W0_10 W0_9 W0_8 W0_7 W0_6 W0_5 W0_4 W0_3 W0_2 W0_1 W0_0 W1_31 W1_30 W1_29 W1_28 W1_27 W1_26 W1_25 W1_24 W1_23 W1_22 W1_21 W1_20 W1_19 W1_18 W1_17 W1_16 W1_15 W1_14 W1_13 W1_12 W1_11 W1_10 W1_9 W1_8 W1_7 W1_6 W1_5 W1_4 W1_3 W1_2 W1_1 W1_0 W_Addr_6 W_Addr_5 W_Addr_4 W_Addr_3 W_Addr_2 W_Addr_1 W_Addr_0 R0_31 R0_30 R0_29 R0_28 R0_27 R0_26 R0_25 R0_24 R0_23 R0_22 R0_21 R0_20 R0_19 R0_18 R0_17 R0_16 R0_15 R0_14 R0_13 R0_12 R0_11 R0_10 R0_9 R0_8 R0_7 R0_6 R0_5 R0_4 R0_3 R0_2 R0_1 R0_0
    I0 (Rs_0 Ws_0 KR_0 KW_0 RO_Reg1_31 RO_Reg1_30 RO_Reg1_29 RO_Reg1_28 RO_Reg1_27 RO_Reg1_26 RO_Reg1_25 RO_Reg1_24 RO_Reg1_23 RO_Reg1_22 RO_Reg1_21 RO_Reg1_20 RO_Reg1_19 RO_Reg1_18 RO_Reg1_17 RO_Reg1_16 RO_Reg1_15 RO_Reg1_14 RO_Reg1_13 RO_Reg1_12 RO_Reg1_11 RO_Reg1_10 RO_Reg1_9 RO_Reg1_8 RO_Reg1_7 RO_Reg1_6 RO_Reg1_5 RO_Reg1_4 RO_Reg1_3 RO_Reg1_2 RO_Reg1_1 RO_Reg1_0 R1_Reg1_31 R1_Reg1_30 R1_Reg1_29 R1_Reg1_28 R1_Reg1_27 R1_Reg1_26 R1_Reg1_25 R1_Reg1_24 R1_Reg1_23 R1_Reg1_22 R1_Reg1_21 R1_Reg1_20 R1_Reg1_19 R1_Reg1_18 R1_Reg1_17 R1_Reg1_16 R1_Reg1_15 R1_Reg1_14 R1_Reg1_13 R1_Reg1_12 R1_Reg1_11 R1_Reg1_10 R1_Reg1_9 R1_Reg1_8 R1_Reg1_7 R1_Reg1_6 R1_Reg1_5 R1_Reg1_4 R1_Reg1_3 R1_Reg1_2 R1_Reg1_1 R1_Reg1_0 R_Addr_4 R_Addr_3 R_Addr_2 R_Addr_1 R_Addr_0 Rs_0 Reset W0_31 W0_30 W0_29 W0_28 W0_27 W0_26 W0_25 W0_24 W0_23 W0_22 W0_21 W0_20 W0_19 W0_18 W0_17 W0_16 W0_15 W0_14 W0_13 W0_12 W0_11 W0_10 W0_9 W0_8 W0_7 W0_6 W0_5 W0_4 W0_3 W0_2 W0_1 W0_0 W1_31 W1_30 W1_29 W1_28 W1_27 W1_26 W1_25 W1_24 W1_23 W1_22 W1_21 W1_20 W1_19 W1_18 W1_17 W1_16 W1_15 W1_14 W1_13 W1_12 W1_11 W1_10 W1_9 W1_8 W1_7 W1_6 W1_5 W1_4 W1_3 W1_2 W1_1 W1_0 W_Addr_4 W_Addr_3 W_Addr_2 W_Addr_1 W_Addr_0 net59_0 net59_1 net59_2 net59_3 net59_4 net59_5 net59_6 net59_7) _sub168
    I2 (Rs_1 Ws_1 KR_1 KW_1 RO_Reg2_31 RO_Reg2_30 RO_Reg2_29 RO_Reg2_28 RO_Reg2_27 RO_Reg2_26 RO_Reg2_25 RO_Reg2_24 RO_Reg2_23 RO_Reg2_22 RO_Reg2_21 RO_Reg2_20 RO_Reg2_19 RO_Reg2_18 RO_Reg2_17 RO_Reg2_16 RO_Reg2_15 RO_Reg2_14 RO_Reg2_13 RO_Reg2_12 RO_Reg2_11 RO_Reg2_10 RO_Reg2_9 RO_Reg2_8 RO_Reg2_7 RO_Reg2_6 RO_Reg2_5 RO_Reg2_4 RO_Reg2_3 RO_Reg2_2 RO_Reg2_1 RO_Reg2_0 R1_Reg2_31 R1_Reg2_30 R1_Reg2_29 R1_Reg2_28 R1_Reg2_27 R1_Reg2_26 R1_Reg2_25 R1_Reg2_24 R1_Reg2_23 R1_Reg2_22 R1_Reg2_21 R1_Reg2_20 R1_Reg2_19 R1_Reg2_18 R1_Reg2_17 R1_Reg2_16 R1_Reg2_15 R1_Reg2_14 R1_Reg2_13 R1_Reg2_12 R1_Reg2_11 R1_Reg2_10 R1_Reg2_9 R1_Reg2_8 R1_Reg2_7 R1_Reg2_6 R1_Reg2_5 R1_Reg2_4 R1_Reg2_3 R1_Reg2_2 R1_Reg2_1 R1_Reg2_0 R_Addr_4 R_Addr_3 R_Addr_2 R_Addr_1 R_Addr_0 Rs_1 Reset W0_31 W0_30 W0_29 W0_28 W0_27 W0_26 W0_25 W0_24 W0_23 W0_22 W0_21 W0_20 W0_19 W0_18 W0_17 W0_16 W0_15 W0_14 W0_13 W0_12 W0_11 W0_10 W0_9 W0_8 W0_7 W0_6 W0_5 W0_4 W0_3 W0_2 W0_1 W0_0 W1_31 W1_30 W1_29 W1_28 W1_27 W1_26 W1_25 W1_24 W1_23 W1_22 W1_21 W1_20 W1_19 W1_18 W1_17 W1_16 W1_15 W1_14 W1_13 W1_12 W1_11 W1_10 W1_9 W1_8 W1_7 W1_6 W1_5 W1_4 W1_3 W1_2 W1_1 W1_0 W_Addr_4 W_Addr_3 W_Addr_2 W_Addr_1 W_Addr_0 net61_0 net61_1 net61_2 net61_3 net61_4 net61_5 net61_6 net61_7) _sub168
    I6 (Rs_2 Ws_2 KR_2 KW_2 R0_Reg3_31 R0_Reg3_30 R0_Reg3_29 R0_Reg3_28 R0_Reg3_27 R0_Reg3_26 R0_Reg3_25 R0_Reg3_24 R0_Reg3_23 R0_Reg3_22 R0_Reg3_21 R0_Reg3_20 R0_Reg3_19 R0_Reg3_18 R0_Reg3_17 R0_Reg3_16 R0_Reg3_15 R0_Reg3_14 R0_Reg3_13 R0_Reg3_12 R0_Reg3_11 R0_Reg3_10 R0_Reg3_9 R0_Reg3_8 R0_Reg3_7 R0_Reg3_6 R0_Reg3_5 R0_Reg3_4 R0_Reg3_3 R0_Reg3_2 R0_Reg3_1 R0_Reg3_0 R1_Reg3_31 R1_Reg3_30 R1_Reg3_29 R1_Reg3_28 R1_Reg3_27 R1_Reg3_26 R1_Reg3_25 R1_Reg3_24 R1_Reg3_23 R1_Reg3_22 R1_Reg3_21 R1_Reg3_20 R1_Reg3_19 R1_Reg3_18 R1_Reg3_17 R1_Reg3_16 R1_Reg3_15 R1_Reg3_14 R1_Reg3_13 R1_Reg3_12 R1_Reg3_11 R1_Reg3_10 R1_Reg3_9 R1_Reg3_8 R1_Reg3_7 R1_Reg3_6 R1_Reg3_5 R1_Reg3_4 R1_Reg3_3 R1_Reg3_2 R1_Reg3_1 R1_Reg3_0 R_Addr_4 R_Addr_3 R_Addr_2 R_Addr_1 R_Addr_0 Rs_2 Reset W0_31 W0_30 W0_29 W0_28 W0_27 W0_26 W0_25 W0_24 W0_23 W0_22 W0_21 W0_20 W0_19 W0_18 W0_17 W0_16 W0_15 W0_14 W0_13 W0_12 W0_11 W0_10 W0_9 W0_8 W0_7 W0_6 W0_5 W0_4 W0_3 W0_2 W0_1 W0_0 W1_31 W1_30 W1_29 W1_28 W1_27 W1_26 W1_25 W1_24 W1_23 W1_22 W1_21 W1_20 W1_19 W1_18 W1_17 W1_16 W1_15 W1_14 W1_13 W1_12 W1_11 W1_10 W1_9 W1_8 W1_7 W1_6 W1_5 W1_4 W1_3 W1_2 W1_1 W1_0 W_Addr_4 W_Addr_3 W_Addr_2 W_Addr_1 W_Addr_0 net63_0 net63_1 net63_2 net63_3 net63_4 net63_5 net63_6 net63_7) _sub168
    I8 (Rs_3 Ws_3 KR_3 KW_3 R0_Reg4_31 R0_Reg4_30 R0_Reg4_29 R0_Reg4_28 R0_Reg4_27 R0_Reg4_26 R0_Reg4_25 R0_Reg4_24 R0_Reg4_23 R0_Reg4_22 R0_Reg4_21 R0_Reg4_20 R0_Reg4_19 R0_Reg4_18 R0_Reg4_17 R0_Reg4_16 R0_Reg4_15 R0_Reg4_14 R0_Reg4_13 R0_Reg4_12 R0_Reg4_11 R0_Reg4_10 R0_Reg4_9 R0_Reg4_8 R0_Reg4_7 R0_Reg4_6 R0_Reg4_5 R0_Reg4_4 R0_Reg4_3 R0_Reg4_2 R0_Reg4_1 R0_Reg4_0 R1_Reg4_31 R1_Reg4_30 R1_Reg4_29 R1_Reg4_28 R1_Reg4_27 R1_Reg4_26 R1_Reg4_25 R1_Reg4_24 R1_Reg4_23 R1_Reg4_22 R1_Reg4_21 R1_Reg4_20 R1_Reg4_19 R1_Reg4_18 R1_Reg4_17 R1_Reg4_16 R1_Reg4_15 R1_Reg4_14 R1_Reg4_13 R1_Reg4_12 R1_Reg4_11 R1_Reg4_10 R1_Reg4_9 R1_Reg4_8 R1_Reg4_7 R1_Reg4_6 R1_Reg4_5 R1_Reg4_4 R1_Reg4_3 R1_Reg4_2 R1_Reg4_1 R1_Reg4_0 R_Addr_4 R_Addr_3 R_Addr_2 R_Addr_1 R_Addr_0 Rs_3 Reset W0_31 W0_30 W0_29 W0_28 W0_27 W0_26 W0_25 W0_24 W0_23 W0_22 W0_21 W0_20 W0_19 W0_18 W0_17 W0_16 W0_15 W0_14 W0_13 W0_12 W0_11 W0_10 W0_9 W0_8 W0_7 W0_6 W0_5 W0_4 W0_3 W0_2 W0_1 W0_0 W1_31 W1_30 W1_29 W1_28 W1_27 W1_26 W1_25 W1_24 W1_23 W1_22 W1_21 W1_20 W1_19 W1_18 W1_17 W1_16 W1_15 W1_14 W1_13 W1_12 W1_11 W1_10 W1_9 W1_8 W1_7 W1_6 W1_5 W1_4 W1_3 W1_2 W1_1 W1_0 W_Addr_4 W_Addr_3 W_Addr_2 W_Addr_1 W_Addr_0 net65_0 net65_1 net65_2 net65_3 net65_4 net65_5 net65_6 net65_7) _sub168
    I4 (GoR R_Addr_6 R_Addr_5 Rs_3 Rs_2 Rs_1 Rs_0) Decode_2to4
    I1 (GoW W_Addr_6 W_Addr_5 Ws_3 Ws_2 Ws_1 Ws_0) Decode_2to4
    I10 (KW_0 KW_1 KW_2 KW_3 \~KWe) nand4_1x
    I11 (KR_0 KR_1 KR_2 KR_3 \~KRe) nand4_1x
    I9 (REnOut net059_0 net059_1 RO_Reg1_31 RO_Reg1_30 RO_Reg1_29 RO_Reg1_28 RO_Reg1_27 RO_Reg1_26 RO_Reg1_25 RO_Reg1_24 RO_Reg1_23 RO_Reg1_22 RO_Reg1_21 RO_Reg1_20 RO_Reg1_19 RO_Reg1_18 RO_Reg1_17 RO_Reg1_16 RO_Reg1_15 RO_Reg1_14 RO_Reg1_13 RO_Reg1_12 RO_Reg1_11 RO_Reg1_10 RO_Reg1_9 RO_Reg1_8 RO_Reg1_7 RO_Reg1_6 RO_Reg1_5 RO_Reg1_4 RO_Reg1_3 RO_Reg1_2 RO_Reg1_1 RO_Reg1_0 RO_Reg2_31 RO_Reg2_30 RO_Reg2_29 RO_Reg2_28 RO_Reg2_27 RO_Reg2_26 RO_Reg2_25 RO_Reg2_24 RO_Reg2_23 RO_Reg2_22 RO_Reg2_21 RO_Reg2_20 RO_Reg2_19 RO_Reg2_18 RO_Reg2_17 RO_Reg2_16 RO_Reg2_15 RO_Reg2_14 RO_Reg2_13 RO_Reg2_12 RO_Reg2_11 RO_Reg2_10 RO_Reg2_9 RO_Reg2_8 RO_Reg2_7 RO_Reg2_6 RO_Reg2_5 RO_Reg2_4 RO_Reg2_3 RO_Reg2_2 RO_Reg2_1 RO_Reg2_0 R0_Reg3_31 R0_Reg3_30 R0_Reg3_29 R0_Reg3_28 R0_Reg3_27 R0_Reg3_26 R0_Reg3_25 R0_Reg3_24 R0_Reg3_23 R0_Reg3_22 R0_Reg3_21 R0_Reg3_20 R0_Reg3_19 R0_Reg3_18 R0_Reg3_17 R0_Reg3_16 R0_Reg3_15 R0_Reg3_14 R0_Reg3_13 R0_Reg3_12 R0_Reg3_11 R0_Reg3_10 R0_Reg3_9 R0_Reg3_8 R0_Reg3_7 R0_Reg3_6 R0_Reg3_5 R0_Reg3_4 R0_Reg3_3 R0_Reg3_2 R0_Reg3_1 R0_Reg3_0 R0_Reg4_31 R0_Reg4_30 R0_Reg4_29 R0_Reg4_28 R0_Reg4_27 R0_Reg4_26 R0_Reg4_25 R0_Reg4_24 R0_Reg4_23 R0_Reg4_22 R0_Reg4_21 R0_Reg4_20 R0_Reg4_19 R0_Reg4_18 R0_Reg4_17 R0_Reg4_16 R0_Reg4_15 R0_Reg4_14 R0_Reg4_13 R0_Reg4_12 R0_Reg4_11 R0_Reg4_10 R0_Reg4_9 R0_Reg4_8 R0_Reg4_7 R0_Reg4_6 R0_Reg4_5 R0_Reg4_4 R0_Reg4_3 R0_Reg4_2 R0_Reg4_1 R0_Reg4_0 R0_31 R0_30 R0_29 R0_28 R0_27 R0_26 R0_25 R0_24 R0_23 R0_22 R0_21 R0_20 R0_19 R0_18 R0_17 R0_16 R0_15 R0_14 R0_13 R0_12 R0_11 R0_10 R0_9 R0_8 R0_7 R0_6 R0_5 R0_4 R0_3 R0_2 R0_1 R0_0) Mux_128to32
    I7 (REnOut net059_0 net059_1 R1_Reg1_31 R1_Reg1_30 R1_Reg1_29 R1_Reg1_28 R1_Reg1_27 R1_Reg1_26 R1_Reg1_25 R1_Reg1_24 R1_Reg1_23 R1_Reg1_22 R1_Reg1_21 R1_Reg1_20 R1_Reg1_19 R1_Reg1_18 R1_Reg1_17 R1_Reg1_16 R1_Reg1_15 R1_Reg1_14 R1_Reg1_13 R1_Reg1_12 R1_Reg1_11 R1_Reg1_10 R1_Reg1_9 R1_Reg1_8 R1_Reg1_7 R1_Reg1_6 R1_Reg1_5 R1_Reg1_4 R1_Reg1_3 R1_Reg1_2 R1_Reg1_1 R1_Reg1_0 R1_Reg2_31 R1_Reg2_30 R1_Reg2_29 R1_Reg2_28 R1_Reg2_27 R1_Reg2_26 R1_Reg2_25 R1_Reg2_24 R1_Reg2_23 R1_Reg2_22 R1_Reg2_21 R1_Reg2_20 R1_Reg2_19 R1_Reg2_18 R1_Reg2_17 R1_Reg2_16 R1_Reg2_15 R1_Reg2_14 R1_Reg2_13 R1_Reg2_12 R1_Reg2_11 R1_Reg2_10 R1_Reg2_9 R1_Reg2_8 R1_Reg2_7 R1_Reg2_6 R1_Reg2_5 R1_Reg2_4 R1_Reg2_3 R1_Reg2_2 R1_Reg2_1 R1_Reg2_0 R1_Reg3_31 R1_Reg3_30 R1_Reg3_29 R1_Reg3_28 R1_Reg3_27 R1_Reg3_26 R1_Reg3_25 R1_Reg3_24 R1_Reg3_23 R1_Reg3_22 R1_Reg3_21 R1_Reg3_20 R1_Reg3_19 R1_Reg3_18 R1_Reg3_17 R1_Reg3_16 R1_Reg3_15 R1_Reg3_14 R1_Reg3_13 R1_Reg3_12 R1_Reg3_11 R1_Reg3_10 R1_Reg3_9 R1_Reg3_8 R1_Reg3_7 R1_Reg3_6 R1_Reg3_5 R1_Reg3_4 R1_Reg3_3 R1_Reg3_2 R1_Reg3_1 R1_Reg3_0 R1_Reg4_31 R1_Reg4_30 R1_Reg4_29 R1_Reg4_28 R1_Reg4_27 R1_Reg4_26 R1_Reg4_25 R1_Reg4_24 R1_Reg4_23 R1_Reg4_22 R1_Reg4_21 R1_Reg4_20 R1_Reg4_19 R1_Reg4_18 R1_Reg4_17 R1_Reg4_16 R1_Reg4_15 R1_Reg4_14 R1_Reg4_13 R1_Reg4_12 R1_Reg4_11 R1_Reg4_10 R1_Reg4_9 R1_Reg4_8 R1_Reg4_7 R1_Reg4_6 R1_Reg4_5 R1_Reg4_4 R1_Reg4_3 R1_Reg4_2 R1_Reg4_1 R1_Reg4_0 R1_31 R1_30 R1_29 R1_28 R1_27 R1_26 R1_25 R1_24 R1_23 R1_22 R1_21 R1_20 R1_19 R1_18 R1_17 R1_16 R1_15 R1_14 R1_13 R1_12 R1_11 R1_10 R1_9 R1_8 R1_7 R1_6 R1_5 R1_4 R1_3 R1_2 R1_1 R1_0) Mux_128to32
    I24_1 (R_Addr_6 net058_0) inv_1x
    I24_0 (R_Addr_5 net058_1) inv_1x
    I25_1 (net058_0 net059_0) inv_1x
    I25_0 (net058_1 net059_1) inv_1x
    I23 (net056 REnOut) inv_1x
    I16 (\~KWe KWe) inv_1x
    I22 (GoR net056) inv_1x
    I19 (\~KRe KRe) inv_1x
ends Dcache_TagMem

// 16nm/DFlop/schematic
//system verilogNetlist schematic cmos.sch cmos_sch veriloga ahdl
subckt DFlop CLK D Q \~Q
    I4 (net3 CLK net07 net4) nand3_1x
    I0 (net07 net3 net011) nand_1x
    I5 (net4 D net07) nand_1x
    I1 (net011 CLK net3) nand_1x
    I3 (Q net4 \~Q) nand_1x
    I2 (net3 \~Q Q) nand_1x
ends DFlop

// 16nm/HS_Cordic/schematic
//system verilogNetlist schematic cmos.sch cmos_sch veriloga ahdl
subckt HS_Cordic ack_a ack_b req_a req_b
    I1 (ack_a net10 req_b) TH22
    I0 (net9 req_a ack_a) TH22
    I3 (ack_b net10) inv_1x
    I2 (req_b net9) inv_1x
ends HS_Cordic

// 16nm/and_1x/schematic
//system verilogNetlist schematic cmos.sch cmos_sch veriloga ahdl
subckt and_1x A B Y
    I7 (A B ntYbar) nand_1x
    I6 (ntYbar Y) inv_1x
ends and_1x

// 16nm/DR_encoder/schematic
//system verilogNetlist schematic cmos.sch cmos_sch veriloga ahdl
subckt DR_encoder d q0 q1 req
    I1 (d req q1) and_1x
    I0 (net10 req q0) and_1x
    I2 (d net10) inv_1x
ends DR_encoder

// 16nm/Compare_DR/schematic
//system verilogNetlist schematic cmos.sch cmos_sch veriloga ahdl
subckt Compare_DR a0 a1 b0 b1 v y0 y1
    M10 (y0 v vdd! vdd!) pfet w=80n l=16n m=1
    M0 (y1 v vdd! vdd!) pfet w=80n l=16n m=1
    M9 (net26 v 0 0) nfet w=120n l=16n m=1
    M8 (y0 a1 net35 0) nfet w=120n l=16n m=1
    M7 (net35 b0 net26 0) nfet w=120n l=16n m=1
    M6 (net36 b1 net26 0) nfet w=120n l=16n m=1
    M5 (y0 a1 net36 0) nfet w=120n l=16n m=1
    M4 (net38 b0 net26 0) nfet w=120n l=16n m=1
    M3 (net37 b1 net26 0) nfet w=120n l=16n m=1
    M2 (y1 a1 net37 0) nfet w=120n l=16n m=1
    M1 (y1 a0 net38 0) nfet w=120n l=16n m=1
ends Compare_DR

// 16nm/Valid_DR/schematic
//system verilogNetlist schematic cmos.sch cmos_sch veriloga ahdl
subckt Valid_DR a0 a1 b0 b1 v
    I1 (b0 b1 net11) nor_1x
    I0 (a0 a1 net12) nor_1x
    I2 (net12 net11 v) _sub160
ends Valid_DR

// 16nm/Compare4_DR/schematic
//system verilogNetlist schematic cmos.sch cmos_sch veriloga ahdl
subckt Compare4_DR a0_3 a0_2 a0_1 a0_0 a1_3 a1_2 a1_1 a1_0 b0_3 b0_2 b0_1 b0_0 b1_3 b1_2 b1_1 b1_0 y0_3 y0_2 y0_1 y0_0 y1_3 y1_2 y1_1 y1_0
    I6 (a0_3 a1_3 b0_3 b1_3 net13 y0_3 y1_3) Compare_DR
    I4 (a0_2 a1_2 b0_2 b1_2 net14 y0_2 y1_2) Compare_DR
    I2 (a0_1 a1_1 b0_1 b1_1 net15 y0_1 y1_1) Compare_DR
    I0 (a0_0 a1_0 b0_0 b1_0 net16 y0_0 y1_0) Compare_DR
    I7 (a0_3 a1_3 b0_3 b1_3 net13) Valid_DR
    I5 (a0_2 a1_2 b0_2 b1_2 net14) Valid_DR
    I3 (a0_1 a1_1 b0_1 b1_1 net15) Valid_DR
    I1 (a0_0 a1_0 b0_0 b1_0 net16) Valid_DR
ends Compare4_DR

// 16nm/Compare22_DR/schematic
//system verilogNetlist schematic cmos.sch cmos_sch veriloga ahdl
subckt Compare22_DR Hit Miss Valid a0_21 a0_20 a0_19 a0_18 a0_17 a0_16 a0_15 a0_14 a0_13 a0_12 a0_11 a0_10 a0_9 a0_8 a0_7 a0_6 a0_5 a0_4 a0_3 a0_2 a0_1 a0_0 a1_21 a1_20 a1_19 a1_18 a1_17 a1_16 a1_15 a1_14 a1_13 a1_12 a1_11 a1_10 a1_9 a1_8 a1_7 a1_6 a1_5 a1_4 a1_3 a1_2 a1_1 a1_0 b0_21 b0_20 b0_19 b0_18 b0_17 b0_16 b0_15 b0_14 b0_13 b0_12 b0_11 b0_10 b0_9 b0_8 b0_7 b0_6 b0_5 b0_4 b0_3 b0_2 b0_1 b0_0 b1_21 b1_20 b1_19 b1_18 b1_17 b1_16 b1_15 b1_14 b1_13 b1_12 b1_11 b1_10 b1_9 b1_8 b1_7 b1_6 b1_5 b1_4 b1_3 b1_2 b1_1 b1_0
    I16 (a0_19 a0_18 a0_17 a0_16 a1_19 a1_18 a1_17 a1_16 b0_19 b0_18 b0_17 b0_16 b1_19 b1_18 b1_17 b1_16 _5y0_3 _5y0_2 _5y0_1 _5y0_0 _5y1_3 _5y1_2 _5y1_1 _5y1_0) Compare4_DR
    I11 (a0_7 a0_6 a0_5 a0_4 a1_7 a1_6 a1_5 a1_4 b0_7 b0_6 b0_5 b0_4 b1_7 b1_6 b1_5 b1_4 _2y0_3 _2y0_2 _2y0_1 _2y0_0 _2y1_3 _2y1_2 _2y1_1 _2y1_0) Compare4_DR
    I10 (a0_3 a0_2 a0_1 a0_0 a1_3 a1_2 a1_1 a1_0 b0_3 b0_2 b0_1 b0_0 b1_3 b1_2 b1_1 b1_0 _1y0_3 _1y0_2 _1y0_1 _1y0_0 _1y1_3 _1y1_2 _1y1_1 _1y1_0) Compare4_DR
    I14 (a0_11 a0_10 a0_9 a0_8 a1_11 a1_10 a1_9 a1_8 b0_11 b0_10 b0_9 b0_8 b1_11 b1_10 b1_9 b1_8 _3y0_3 _3y0_2 _3y0_1 _3y0_0 _3y1_3 _3y1_2 _3y1_1 _3y1_0) Compare4_DR
    I13 (a0_15 a0_14 a0_13 a0_12 a1_15 a1_14 a1_13 a1_12 b0_15 b0_14 b0_13 b0_12 b1_15 b1_14 b1_13 b1_12 _4y0_3 _4y0_2 _4y0_1 _4y0_0 _4y1_3 _4y1_2 _4y1_1 _4y1_0) Compare4_DR
    I2 (a0_21 a1_21 b0_21 b1_21 net39 net60 net42) Compare_DR
    I0 (a0_20 a1_20 b0_20 b1_20 net40 net41 net43) Compare_DR
    I37 (net56 net53 net55 net57 net59) nand4_1x
    I27 (net49 net47 net46 net48 net52) nand4_1x
    I3 (a0_21 a1_21 b0_21 b1_21 net39) Valid_DR
    I1 (a0_20 a1_20 b0_20 b1_20 net40) Valid_DR
    I21 (_5y1_0 _5y1_1 _5y1_2 _5y1_3 net61) and4_1x
    I23 (_4y1_0 _4y1_1 _4y1_2 _4y1_3 net48) and4_1x
    I24 (_3y1_0 _3y1_1 _3y1_2 _3y1_3 net46) and4_1x
    I25 (_2y1_0 _2y1_1 _2y1_2 _2y1_3 net47) and4_1x
    I26 (_1y1_0 _1y1_1 _1y1_2 _1y1_3 net49) and4_1x
    I22 (net43 net42 net45) and_1x
    I38 (net54 net50 net58) nand_1x
    I28 (net61 net45 net51) nand_1x
    I35 (net41 net60 net50) nor_1x
    I29 (net52 net51 Hit) nor_1x
    I34 (_5y0_0 _5y0_1 _5y0_2 _5y0_3 net54) nor4_1x
    I33 (_4y0_0 _4y0_1 _4y0_2 _4y0_3 net57) nor4_1x
    I32 (_3y0_0 _3y0_1 _3y0_2 _3y0_3 net55) nor4_1x
    I31 (_2y0_0 _2y0_1 _2y0_2 _2y0_3 net53) nor4_1x
    I30 (_1y0_0 _1y0_1 _1y0_2 _1y0_3 net56) nor4_1x
    I40 (Hit Miss Valid) or2_1x
    I39 (net59 net58 Miss) or2_1x
ends Compare22_DR

// 16nm/6T/schematic
//system verilogNetlist schematic cmos.sch cmos_sch veriloga ahdl
subckt _sub169 A B0 B1
    M5 (Q0 Q1 0 0) nfet w=80n l=16n m=1
    M4 (Q1 Q0 0 0) nfet w=80n l=16n m=1
    M1 (Q1 A B1 0) nfet w=40n l=16n m=1
    M0 (Q0 A B0 0) nfet w=40n l=16n m=1
    M3 (Q0 Q1 vdd! vdd!) pfet w=40n l=16n m=1
    M2 (Q1 Q0 vdd! vdd!) pfet w=40n l=16n m=1
ends _sub169

// 16nm/6T_4x/schematic
//system verilogNetlist schematic cmos.sch cmos_sch veriloga ahdl
subckt _sub170 A_3 A_2 A_1 A_0 B0 B1
    I3 (A_0 B0 B1) _sub169
    I2 (A_1 B0 B1) _sub169
    I1 (A_2 B0 B1) _sub169
    I0 (A_3 B0 B1) _sub169
ends _sub170

// 16nm/6T_32x/schematic
//system verilogNetlist schematic cmos.sch cmos_sch veriloga ahdl
subckt _sub171 A_31 A_30 A_29 A_28 A_27 A_26 A_25 A_24 A_23 A_22 A_21 A_20 A_19 A_18 A_17 A_16 A_15 A_14 A_13 A_12 A_11 A_10 A_9 A_8 A_7 A_6 A_5 A_4 A_3 A_2 A_1 A_0 B0 B1
    I7 (A_3 A_2 A_1 A_0 B0 B1) _sub170
    I6 (A_7 A_6 A_5 A_4 B0 B1) _sub170
    I5 (A_11 A_10 A_9 A_8 B0 B1) _sub170
    I4 (A_15 A_14 A_13 A_12 B0 B1) _sub170
    I3 (A_19 A_18 A_17 A_16 B0 B1) _sub170
    I2 (A_23 A_22 A_21 A_20 B0 B1) _sub170
    I1 (A_27 A_26 A_25 A_24 B0 B1) _sub170
    I0 (A_31 A_30 A_29 A_28 B0 B1) _sub170
ends _sub171

// 16nm/6T_32x_CTRL/schematic
//system verilogNetlist schematic cmos.sch cmos_sch veriloga ahdl
subckt _sub172 B0 B1 S W0 W1
    M10 (B1 B0 net22 vdd!) pfet w=40n l=20n m=1
    M9 (net22 W0 vdd! vdd!) pfet w=40n l=20n m=1
    M8 (B0 B1 net23 vdd!) pfet w=40n l=20n m=1
    M7 (net23 W1 vdd! vdd!) pfet w=40n l=20n m=1
    M2 (B1 S vdd! vdd!) pfet w=40n l=16n m=1
    M0 (B0 S vdd! vdd!) pfet w=40n l=16n m=1
    M6 (B1 W0 net24 0) nfet w=80n l=20n m=1
    M5 (net24 S 0 0) nfet w=80n l=20n m=1
    M4 (net25 S 0 0) nfet w=80n l=20n m=1
    M3 (B0 W1 net25 0) nfet w=80n l=20n m=1
ends _sub172

// 16nm/6T_32x4/schematic
//system verilogNetlist schematic cmos.sch cmos_sch veriloga ahdl
subckt _sub173 A_31 A_30 A_29 A_28 A_27 A_26 A_25 A_24 A_23 A_22 A_21 A_20 A_19 A_18 A_17 A_16 A_15 A_14 A_13 A_12 A_11 A_10 A_9 A_8 A_7 A_6 A_5 A_4 A_3 A_2 A_1 A_0 B0 B1 S_3 S_2 S_1 S_0 W0 W1 SM0 SM1
    I3 (A_31 A_30 A_29 A_28 A_27 A_26 A_25 A_24 A_23 A_22 A_21 A_20 A_19 A_18 A_17 A_16 A_15 A_14 A_13 A_12 A_11 A_10 A_9 A_8 A_7 A_6 A_5 A_4 A_3 A_2 A_1 A_0 B0P4 B1P4) _sub171
    I1 (A_31 A_30 A_29 A_28 A_27 A_26 A_25 A_24 A_23 A_22 A_21 A_20 A_19 A_18 A_17 A_16 A_15 A_14 A_13 A_12 A_11 A_10 A_9 A_8 A_7 A_6 A_5 A_4 A_3 A_2 A_1 A_0 B0P2 B1P2) _sub171
    I2 (A_31 A_30 A_29 A_28 A_27 A_26 A_25 A_24 A_23 A_22 A_21 A_20 A_19 A_18 A_17 A_16 A_15 A_14 A_13 A_12 A_11 A_10 A_9 A_8 A_7 A_6 A_5 A_4 A_3 A_2 A_1 A_0 B0P3 B1P3) _sub171
    I0 (A_31 A_30 A_29 A_28 A_27 A_26 A_25 A_24 A_23 A_22 A_21 A_20 A_19 A_18 A_17 A_16 A_15 A_14 A_13 A_12 A_11 A_10 A_9 A_8 A_7 A_6 A_5 A_4 A_3 A_2 A_1 A_0 B0P1 B1P1) _sub171
    M0 (B0P1 B0 net67 0) nfet w=40n l=20n m=1
    M1 (net67 S_0 0 0) nfet w=40n l=20n m=1
    M2 (net66 S_0 0 0) nfet w=40n l=20n m=1
    M8 (B1P2 B1 net65 0) nfet w=40n l=20n m=1
    M9 (net65 S_1 0 0) nfet w=40n l=20n m=1
    M10 (net64 S_1 0 0) nfet w=40n l=20n m=1
    M11 (B0P2 B0 net64 0) nfet w=40n l=20n m=1
    M12 (B0P3 B0 net63 0) nfet w=40n l=20n m=1
    M13 (net63 S_2 0 0) nfet w=40n l=20n m=1
    M14 (net62 S_2 0 0) nfet w=40n l=20n m=1
    M15 (B1P3 B1 net62 0) nfet w=40n l=20n m=1
    M16 (B1P4 B1 net61 0) nfet w=40n l=20n m=1
    M17 (net61 S_3 0 0) nfet w=40n l=20n m=1
    M18 (net60 S_3 0 0) nfet w=40n l=20n m=1
    M19 (B0P4 B0 net60 0) nfet w=40n l=20n m=1
    M3 (B1P1 B1 net66 0) nfet w=40n l=20n m=1
    I4 (B0P1 B1P1 S_0 W0 W1) _sub172
    I5 (B0P2 B1P2 S_1 W0 W1) _sub172
    I6 (B0P3 B1P3 S_2 W0 W1) _sub172
    I7 (B0P4 B1P4 S_3 W0 W1) _sub172
    I11 (B1P1 B1P2 B1P3 B1P4 SM1) nand4_1x
    I10 (B0P1 B0P2 B0P3 B0P4 SM0) nand4_1x
    C7 (B1P4 0) capacitor c=106.7a m=1
    C6 (B1P2 0) capacitor c=106.7a m=1
    C5 (B1P3 0) capacitor c=106.7a m=1
    C4 (B0P4 0) capacitor c=106.7a m=1
    C3 (B0P3 0) capacitor c=106.7a m=1
    C2 (B0P2 0) capacitor c=106.7a m=1
    C1 (B1P1 0) capacitor c=106.7a m=1
    C0 (B0P1 0) capacitor c=106.7a m=1
ends _sub173

// 16nm/6T_SetRead/schematic
//system verilogNetlist schematic cmos.sch cmos_sch veriloga ahdl
subckt _sub174 Go SM0_0 SM0_1 SM1_0 SM1_1 \~R0 \~R1
    M6 (net18 Go 0 0) nfet w=40n l=16n m=1
    M5 (\~R0 SM0_0 net18 0) nfet w=40n l=16n m=1
    M3 (\~R0 SM0_1 net18 0) nfet w=40n l=16n m=1
    M2 (net12 Go 0 0) nfet w=40n l=16n m=1
    M1 (\~R1 SM1_1 net12 0) nfet w=40n l=16n m=1
    M0 (\~R1 SM1_0 net12 0) nfet w=40n l=16n m=1
ends _sub174

// 16nm/6T_CHUNK/schematic
//system verilogNetlist schematic cmos.sch cmos_sch veriloga ahdl
subckt _sub175 A_63 A_62 A_61 A_60 A_59 A_58 A_57 A_56 A_55 A_54 A_53 A_52 A_51 A_50 A_49 A_48 A_47 A_46 A_45 A_44 A_43 A_42 A_41 A_40 A_39 A_38 A_37 A_36 A_35 A_34 A_33 A_32 A_31 A_30 A_29 A_28 A_27 A_26 A_25 A_24 A_23 A_22 A_21 A_20 A_19 A_18 A_17 A_16 A_15 A_14 A_13 A_12 A_11 A_10 A_9 A_8 A_7 A_6 A_5 A_4 A_3 A_2 A_1 A_0 B0_3 B0_2 B0_1 B0_0 B1_3 B1_2 B1_1 B1_0 Go S_7 S_6 S_5 S_4 S_3 S_2 S_1 S_0 W0_3 W0_2 W0_1 W0_0 W1_3 W1_2 W1_1 W1_0 \~R0_3 \~R0_2 \~R0_1 \~R0_0 \~R1_3 \~R1_2 \~R1_1 \~R1_0
    I11 (A_63 A_62 A_61 A_60 A_59 A_58 A_57 A_56 A_55 A_54 A_53 A_52 A_51 A_50 A_49 A_48 A_47 A_46 A_45 A_44 A_43 A_42 A_41 A_40 A_39 A_38 A_37 A_36 A_35 A_34 A_33 A_32 B0_3 B1_3 S_7 S_6 S_5 S_4 W0_3 W1_3 SM0_1_bit3 SM1_1_bit3) _sub173
    I10 (A_63 A_62 A_61 A_60 A_59 A_58 A_57 A_56 A_55 A_54 A_53 A_52 A_51 A_50 A_49 A_48 A_47 A_46 A_45 A_44 A_43 A_42 A_41 A_40 A_39 A_38 A_37 A_36 A_35 A_34 A_33 A_32 B0_2 B1_2 S_7 S_6 S_5 S_4 W0_2 W1_2 SM0_1_bit2 SM1_1_bit2) _sub173
    I9 (A_63 A_62 A_61 A_60 A_59 A_58 A_57 A_56 A_55 A_54 A_53 A_52 A_51 A_50 A_49 A_48 A_47 A_46 A_45 A_44 A_43 A_42 A_41 A_40 A_39 A_38 A_37 A_36 A_35 A_34 A_33 A_32 B0_1 B1_1 S_7 S_6 S_5 S_4 W0_1 W1_1 SM0_1_bit1 SM1_1_bit1) _sub173
    I8 (A_63 A_62 A_61 A_60 A_59 A_58 A_57 A_56 A_55 A_54 A_53 A_52 A_51 A_50 A_49 A_48 A_47 A_46 A_45 A_44 A_43 A_42 A_41 A_40 A_39 A_38 A_37 A_36 A_35 A_34 A_33 A_32 B0_0 B1_0 S_7 S_6 S_5 S_4 W0_0 W1_0 SM0_1_bit0 SM1_1_bit0) _sub173
    I3 (A_31 A_30 A_29 A_28 A_27 A_26 A_25 A_24 A_23 A_22 A_21 A_20 A_19 A_18 A_17 A_16 A_15 A_14 A_13 A_12 A_11 A_10 A_9 A_8 A_7 A_6 A_5 A_4 A_3 A_2 A_1 A_0 B0_3 B1_3 S_3 S_2 S_1 S_0 W0_3 W1_3 SM0_0_bit3 SM1_0_bit3) _sub173
    I2 (A_31 A_30 A_29 A_28 A_27 A_26 A_25 A_24 A_23 A_22 A_21 A_20 A_19 A_18 A_17 A_16 A_15 A_14 A_13 A_12 A_11 A_10 A_9 A_8 A_7 A_6 A_5 A_4 A_3 A_2 A_1 A_0 B0_2 B1_2 S_3 S_2 S_1 S_0 W0_2 W1_2 SM0_0_bit2 SM1_0_bit2) _sub173
    I1 (A_31 A_30 A_29 A_28 A_27 A_26 A_25 A_24 A_23 A_22 A_21 A_20 A_19 A_18 A_17 A_16 A_15 A_14 A_13 A_12 A_11 A_10 A_9 A_8 A_7 A_6 A_5 A_4 A_3 A_2 A_1 A_0 B0_1 B1_1 S_3 S_2 S_1 S_0 W0_1 W1_1 SM0_0_bit1 SM1_0_bit1) _sub173
    I0 (A_31 A_30 A_29 A_28 A_27 A_26 A_25 A_24 A_23 A_22 A_21 A_20 A_19 A_18 A_17 A_16 A_15 A_14 A_13 A_12 A_11 A_10 A_9 A_8 A_7 A_6 A_5 A_4 A_3 A_2 A_1 A_0 B0_0 B1_0 S_3 S_2 S_1 S_0 W0_0 W1_0 SM0_0_bit0 SM1_0_bit0) _sub173
    I7 (Go SM0_0_bit3 SM0_1_bit3 SM1_0_bit3 SM1_1_bit3 \~R0_3 \~R1_3) _sub174
    I6 (Go SM0_0_bit2 SM0_1_bit2 SM1_0_bit2 SM1_1_bit2 \~R0_2 \~R1_2) _sub174
    I5 (Go SM0_0_bit1 SM0_1_bit1 SM1_0_bit1 SM1_1_bit1 \~R0_1 \~R1_1) _sub174
    I4 (Go SM0_0_bit0 SM0_1_bit0 SM1_0_bit0 SM1_1_bit0 \~R0_0 \~R1_0) _sub174
ends _sub175

// 16nm/Demux_2e1of4/schematic
//system verilogNetlist schematic cmos.sch cmos_sch veriloga ahdl
subckt Demux_2e1of4 _1of4_1_3 _1of4_1_2 _1of4_1_1 _1of4_1_0 _1of4_2_3 _1of4_2_2 _1of4_2_1 _1of4_2_0 A_15 A_14 A_13 A_12 A_11 A_10 A_9 A_8 A_7 A_6 A_5 A_4 A_3 A_2 A_1 A_0 En EnOut
    I15 (_1of4_1_3 _1of4_2_3 EnOut En A_15) and4_1x
    I14 (_1of4_1_2 _1of4_2_3 EnOut En A_14) and4_1x
    I13 (_1of4_1_1 _1of4_2_3 EnOut En A_13) and4_1x
    I12 (_1of4_1_0 _1of4_2_3 EnOut En A_12) and4_1x
    I11 (_1of4_1_3 _1of4_2_2 EnOut En A_11) and4_1x
    I10 (_1of4_1_2 _1of4_2_2 EnOut En A_10) and4_1x
    I9 (_1of4_1_1 _1of4_2_2 EnOut En A_9) and4_1x
    I8 (_1of4_1_0 _1of4_2_2 EnOut En A_8) and4_1x
    I7 (_1of4_1_3 _1of4_2_1 EnOut En A_7) and4_1x
    I6 (_1of4_1_2 _1of4_2_1 EnOut En A_6) and4_1x
    I5 (_1of4_1_1 _1of4_2_1 EnOut En A_5) and4_1x
    I4 (_1of4_1_0 _1of4_2_1 EnOut En A_4) and4_1x
    I3 (_1of4_1_3 _1of4_2_0 EnOut En A_3) and4_1x
    I2 (_1of4_1_2 _1of4_2_0 EnOut En A_2) and4_1x
    I1 (_1of4_1_1 _1of4_2_0 EnOut En A_1) and4_1x
    I0 (_1of4_1_0 _1of4_2_0 EnOut En A_0) and4_1x
ends Demux_2e1of4

// 16nm/or32_1x/schematic
//system verilogNetlist schematic cmos.sch cmos_sch veriloga ahdl
subckt or32_1x X_31 X_30 X_29 X_28 X_27 X_26 X_25 X_24 X_23 X_22 X_21 X_20 X_19 X_18 X_17 X_16 X_15 X_14 X_13 X_12 X_11 X_10 X_9 X_8 X_7 X_6 X_5 X_4 X_3 X_2 X_1 X_0 Y
    I5 (net15 net14 Y) nand_1x
    I0 (X_0 X_1 X_2 X_3 net13) nor4_1x
    I1 (X_4 X_5 X_6 X_7 net9) nor4_1x
    I3 (X_8 X_9 X_10 X_11 net8) nor4_1x
    I4 (X_12 X_13 X_14 X_15 net12) nor4_1x
    I6 (X_16 X_17 X_18 X_19 net11) nor4_1x
    I7 (X_20 X_21 X_22 X_23 net7) nor4_1x
    I9 (X_24 X_25 X_26 X_27 net6) nor4_1x
    I10 (X_28 X_29 X_30 X_31 net10) nor4_1x
    I2 (net13 net9 net8 net12 net15) and4_1x
    I8 (net11 net7 net6 net10 net14) and4_1x
ends or32_1x

// 16nm/Demux_3e1of4/schematic
//system verilogNetlist schematic cmos.sch cmos_sch veriloga ahdl
subckt Demux_3e1of4 _1of4_1_3 _1of4_1_2 _1of4_1_1 _1of4_1_0 _1of4_2_3 _1of4_2_2 _1of4_2_1 _1of4_2_0 _1of4_3_3 _1of4_3_2 _1of4_3_1 _1of4_3_0 A_63 A_62 A_61 A_60 A_59 A_58 A_57 A_56 A_55 A_54 A_53 A_52 A_51 A_50 A_49 A_48 A_47 A_46 A_45 A_44 A_43 A_42 A_41 A_40 A_39 A_38 A_37 A_36 A_35 A_34 A_33 A_32 A_31 A_30 A_29 A_28 A_27 A_26 A_25 A_24 A_23 A_22 A_21 A_20 A_19 A_18 A_17 A_16 A_15 A_14 A_13 A_12 A_11 A_10 A_9 A_8 A_7 A_6 A_5 A_4 A_3 A_2 A_1 A_0 En Valid_1 Valid_0
    I3 (_1of4_1_3 _1of4_1_2 _1of4_1_1 _1of4_1_0 _1of4_2_3 _1of4_2_2 _1of4_2_1 _1of4_2_0 A_63 A_62 A_61 A_60 A_59 A_58 A_57 A_56 A_55 A_54 A_53 A_52 A_51 A_50 A_49 A_48 En _1of4_3_3) Demux_2e1of4
    I2 (_1of4_1_3 _1of4_1_2 _1of4_1_1 _1of4_1_0 _1of4_2_3 _1of4_2_2 _1of4_2_1 _1of4_2_0 A_47 A_46 A_45 A_44 A_43 A_42 A_41 A_40 A_39 A_38 A_37 A_36 A_35 A_34 A_33 A_32 En _1of4_3_2) Demux_2e1of4
    I1 (_1of4_1_3 _1of4_1_2 _1of4_1_1 _1of4_1_0 _1of4_2_3 _1of4_2_2 _1of4_2_1 _1of4_2_0 A_31 A_30 A_29 A_28 A_27 A_26 A_25 A_24 A_23 A_22 A_21 A_20 A_19 A_18 A_17 A_16 En _1of4_3_1) Demux_2e1of4
    I0 (_1of4_1_3 _1of4_1_2 _1of4_1_1 _1of4_1_0 _1of4_2_3 _1of4_2_2 _1of4_2_1 _1of4_2_0 A_15 A_14 A_13 A_12 A_11 A_10 A_9 A_8 A_7 A_6 A_5 A_4 A_3 A_2 A_1 A_0 En _1of4_3_0) Demux_2e1of4
    I5 (A_63 A_62 A_61 A_60 A_59 A_58 A_57 A_56 A_55 A_54 A_53 A_52 A_51 A_50 A_49 A_48 A_47 A_46 A_45 A_44 A_43 A_42 A_41 A_40 A_39 A_38 A_37 A_36 A_35 A_34 A_33 A_32 Valid_1) or32_1x
    I4 (A_31 A_30 A_29 A_28 A_27 A_26 A_25 A_24 A_23 A_22 A_21 A_20 A_19 A_18 A_17 A_16 A_15 A_14 A_13 A_12 A_11 A_10 A_9 A_8 A_7 A_6 A_5 A_4 A_3 A_2 A_1 A_0 Valid_0) or32_1x
ends Demux_3e1of4

// 16nm/6T_DEMUX/schematic
//system verilogNetlist schematic cmos.sch cmos_sch veriloga ahdl
subckt _sub176 _1of4_1_3 _1of4_1_2 _1of4_1_1 _1of4_1_0 _1of4_2_3 _1of4_2_2 _1of4_2_1 _1of4_2_0 _1of4_3_3 _1of4_3_2 _1of4_3_1 _1of4_3_0 _1of4_4_3 _1of4_4_2 _1of4_4_1 _1of4_4_0 A_63 A_62 A_61 A_60 A_59 A_58 A_57 A_56 A_55 A_54 A_53 A_52 A_51 A_50 A_49 A_48 A_47 A_46 A_45 A_44 A_43 A_42 A_41 A_40 A_39 A_38 A_37 A_36 A_35 A_34 A_33 A_32 A_31 A_30 A_29 A_28 A_27 A_26 A_25 A_24 A_23 A_22 A_21 A_20 A_19 A_18 A_17 A_16 A_15 A_14 A_13 A_12 A_11 A_10 A_9 A_8 A_7 A_6 A_5 A_4 A_3 A_2 A_1 A_0 En S_7 S_6 S_5 S_4 S_3 S_2 S_1 S_0 Ack
    I0 (_1of4_1_3 _1of4_1_2 _1of4_1_1 _1of4_1_0 _1of4_2_3 _1of4_2_2 _1of4_2_1 _1of4_2_0 _1of4_3_3 _1of4_3_2 _1of4_3_1 _1of4_3_0 A_63 A_62 A_61 A_60 A_59 A_58 A_57 A_56 A_55 A_54 A_53 A_52 A_51 A_50 A_49 A_48 A_47 A_46 A_45 A_44 A_43 A_42 A_41 A_40 A_39 A_38 A_37 A_36 A_35 A_34 A_33 A_32 A_31 A_30 A_29 A_28 A_27 A_26 A_25 A_24 A_23 A_22 A_21 A_20 A_19 A_18 A_17 A_16 A_15 A_14 A_13 A_12 A_11 A_10 A_9 A_8 A_7 A_6 A_5 A_4 A_3 A_2 A_1 A_0 En Valid_1 Valid_0) Demux_3e1of4
    I3 (Valid_1 Valid_0 Ack) or2_1x
    I1_3 (_1of4_4_3 Valid_0 En S_3) and3
    I1_2 (_1of4_4_2 Valid_0 En S_2) and3
    I1_1 (_1of4_4_1 Valid_0 En S_1) and3
    I1_0 (_1of4_4_0 Valid_0 En S_0) and3
    I2_3 (_1of4_4_3 Valid_1 En S_7) and3
    I2_2 (_1of4_4_2 Valid_1 En S_6) and3
    I2_1 (_1of4_4_1 Valid_1 En S_5) and3
    I2_0 (_1of4_4_0 Valid_1 En S_4) and3
ends _sub176

// 16nm/WCHB/schematic
//system verilogNetlist schematic cmos.sch cmos_sch veriloga ahdl
subckt WCHB L0 L1 Lack R0 R1 Rack \~R0 \~R1
    I2 (\~R1 \~R0 net21) nand_1x
    I5 (net21 Lack) inv_1x
    I4 (\~R1 R1) inv_1x
    I3 (\~R0 R0) inv_1x
    I1 (Rack L1 \~R1) _sub160
    I0 (L0 Rack \~R0) _sub160
ends WCHB

// 16nm/6T_DATA/schematic
//system verilogNetlist schematic cmos.sch cmos_sch veriloga ahdl
subckt _sub177 Ack B0_3 B0_2 B0_1 B0_0 B1_3 B1_2 B1_1 B1_0 Go R1_1of4_3 R1_1of4_2 R1_1of4_1 R1_1of4_0 R2_1of4_3 R2_1of4_2 R2_1of4_1 R2_1of4_0 RW_1 RW_0 Reset ValAddr W0_3 W0_2 W0_1 W0_0 W1_3 W1_2 W1_1 W1_0 W1_1of4_3 W1_1of4_2 W1_1of4_1 W1_1of4_0 W2_1of4_3 W2_1of4_2 W2_1of4_1 W2_1of4_0 AckThruBot AckThruTop RAck_1 RAck_0 WAck_1 WAck_0 \~R0_3 \~R0_2 \~R0_1 \~R0_0 \~R1_3 \~R1_2 \~R1_1 \~R1_0
    I45 (net030 RW_0 net047) nand_1x
    I46 (net047 net046 Ack) nand_1x
    I44 (RW_1 net054 net046) nand_1x
    I54 (Out0_2 Out1_3 R2_1of4_2) nor_1x
    I53 (Out0_3 Out0_2 R2_1of4_3) nor_1x
    I52 (Out0_3 Out1_2 R2_1of4_1) nor_1x
    I51 (Out1_3 Out1_2 R2_1of4_0) nor_1x
    I50 (Out0_1 Out0_0 R1_1of4_3) nor_1x
    I49 (Out1_1 Out0_0 R1_1of4_2) nor_1x
    I47 (Out1_1 Out1_0 R1_1of4_0) nor_1x
    I48 (Out1_0 Out0_1 R1_1of4_1) nor_1x
    I67_3 (net057_0 net058_0 Lack_3 net059_0 net060_0 Rack_3 Out0_3 Out1_3) WCHB
    I67_2 (net057_1 net058_1 Lack_2 net059_1 net060_1 Rack_2 Out0_2 Out1_2) WCHB
    I67_1 (net057_2 net058_2 Lack_1 net059_2 net060_2 Rack_1 Out0_1 Out1_1) WCHB
    I67_0 (net057_3 net058_3 Lack_0 net059_3 net060_3 Rack_0 Out0_0 Out1_0) WCHB
    I21 (nOr_1 nOr_0 wack_0 B0_0 B1_0 net036 net064 net065) WCHB
    I24 (nOr_7 nOr_6 wack_3 B0_3 B1_3 net036 net066 net067) WCHB
    I23 (nOr_5 nOr_4 wack_2 B0_2 B1_2 net036 net068 net069) WCHB
    I22 (nOr_3 nOr_2 wack_1 B0_1 B1_1 net036 net070 net071) WCHB
    I43 (Lack_3 Lack_2 Lack_1 Lack_0 net054) TH44
    I29 (wack_3 wack_2 wack_1 wack_0 net030) TH44
    I65 (RW_0 ValAddr net036) and_1x
    I37_3 (B0_3 net036 W0_3) and_1x
    I37_2 (B0_2 net036 W0_2) and_1x
    I37_1 (B0_1 net036 W0_1) and_1x
    I37_0 (B0_0 net036 W0_0) and_1x
    I36_3 (net036 B1_3 W1_3) and_1x
    I36_2 (net036 B1_2 W1_2) and_1x
    I36_1 (net036 B1_1 W1_1) and_1x
    I36_0 (net036 B1_0 W1_0) and_1x
    I38 (ValAddr RW_1 Go) and_1x
    M1_3 (\~R1_3 Go vdd! vdd!) pfet w=80n l=16n m=1
    M1_2 (\~R1_2 Go vdd! vdd!) pfet w=80n l=16n m=1
    M1_1 (\~R1_1 Go vdd! vdd!) pfet w=80n l=16n m=1
    M1_0 (\~R1_0 Go vdd! vdd!) pfet w=80n l=16n m=1
    M0_3 (\~R0_3 Go vdd! vdd!) pfet w=80n l=16n m=1
    M0_2 (\~R0_2 Go vdd! vdd!) pfet w=80n l=16n m=1
    M0_1 (\~R0_1 Go vdd! vdd!) pfet w=80n l=16n m=1
    M0_0 (\~R0_0 Go vdd! vdd!) pfet w=80n l=16n m=1
    I35_3 (\~R1_3 net058_0) inv_1x
    I35_2 (\~R1_2 net058_1) inv_1x
    I35_1 (\~R1_1 net058_2) inv_1x
    I35_0 (\~R1_0 net058_3) inv_1x
    I34_3 (\~R0_3 net057_0) inv_1x
    I34_2 (\~R0_2 net057_1) inv_1x
    I34_1 (\~R0_1 net057_2) inv_1x
    I34_0 (\~R0_0 net057_3) inv_1x
    I64 (RAck_0 Rack_0) iprobe
    I63 (RAck_0 Rack_1) iprobe
    I62 (RAck_1 Rack_2) iprobe
    I56 (AckThruBot AckThruTop) iprobe
    I61 (RAck_1 Rack_3) iprobe
    I58 (wack_1 wack_0 WAck_0) TH22
    I57 (wack_2 wack_3 WAck_1) TH22
    I18 (W2_1of4_2 W2_1of4_3 nOr_7) or2_1x
    I17 (W2_1of4_0 W2_1of4_1 nOr_6) or2_1x
    I11 (W1_1of4_2 W1_1of4_3 nOr_3) or2_1x
    I10 (W1_1of4_0 W1_1of4_1 nOr_2) or2_1x
    I16 (W2_1of4_1 W2_1of4_3 nOr_5) or2_1x
    I15 (W2_1of4_0 W2_1of4_2 nOr_4) or2_1x
    I1 (W1_1of4_1 W1_1of4_3 nOr_1) or2_1x
    I0 (W1_1of4_0 W1_1of4_2 nOr_0) or2_1x
ends _sub177

// 16nm/or16_1x/schematic
//system verilogNetlist schematic cmos.sch cmos_sch veriloga ahdl
subckt or16_1x Y X_15 X_14 X_13 X_12 X_11 X_10 X_9 X_8 X_7 X_6 X_5 X_4 X_3 X_2 X_1 X_0
    I2 (nX30 nX74 nX118 nX1512 Y) nand4_1x
    I0 (X_0 X_1 X_2 X_3 nX30) nor4_1x
    I1 (X_4 X_5 X_6 X_7 nX74) nor4_1x
    I3 (X_8 X_9 X_10 X_11 nX118) nor4_1x
    I4 (X_12 X_13 X_14 X_15 nX1512) nor4_1x
ends or16_1x

// 16nm/or4_1x/schematic
//system verilogNetlist schematic cmos.sch cmos_sch veriloga ahdl
subckt or4_1x A B C D Y
    I0 (A B C D net11) nor4_1x
    I1 (net11 Y) inv_1x
ends or4_1x

// 16nm/6T_CONTROL/schematic
//system verilogNetlist schematic cmos.sch cmos_sch veriloga ahdl
subckt _sub178 A_3 A_2 A_1 A_0 A_7 A_6 A_5 A_4 A_11 A_10 A_9 A_8 A_15 A_14 A_13 A_12 A_19 A_18 A_17 A_16 InAck_1 InAck_0 InAck_3 InAck_2 OutAck RW_1 RW_0 Reset ValAddr
    I17 (net8 A_15 A_14 A_13 A_12 A_11 A_10 A_9 A_8 A_7 A_6 A_5 A_4 A_3 A_2 A_1 A_0) or16_1x
    I15 (A_16 A_17 A_18 A_19 net7) or4_1x
    I16 (net8 net7 ValAddr) or2_1x
    I14 (InAck_0 InAck_1 InAck_2 InAck_3 OutAck) TH44
ends _sub178

// 16nm/6T_BANK/schematic
//system verilogNetlist schematic cmos.sch cmos_sch veriloga ahdl
subckt _sub179 A_19 A_18 A_17 A_16 A_15 A_14 A_13 A_12 A_11 A_10 A_9 A_8 A_7 A_6 A_5 A_4 A_3 A_2 A_1 A_0 Ack Ctrl_Ack_4 Ctrl_Ack_3 Ctrl_Ack_2 Ctrl_Ack_1 Ctrl_Ack_0 RD_8of32_31 RD_8of32_30 RD_8of32_29 RD_8of32_28 RD_8of32_27 RD_8of32_26 RD_8of32_25 RD_8of32_24 RD_8of32_23 RD_8of32_22 RD_8of32_21 RD_8of32_20 RD_8of32_19 RD_8of32_18 RD_8of32_17 RD_8of32_16 RD_8of32_15 RD_8of32_14 RD_8of32_13 RD_8of32_12 RD_8of32_11 RD_8of32_10 RD_8of32_9 RD_8of32_8 RD_8of32_7 RD_8of32_6 RD_8of32_5 RD_8of32_4 RD_8of32_3 RD_8of32_2 RD_8of32_1 RD_8of32_0 RD_Ack_7 RD_Ack_6 RD_Ack_5 RD_Ack_4 RD_Ack_3 RD_Ack_2 RD_Ack_1 RD_Ack_0 RW_1 RW_0 WD_8of32_31 WD_8of32_30 WD_8of32_29 WD_8of32_28 WD_8of32_27 WD_8of32_26 WD_8of32_25 WD_8of32_24 WD_8of32_23 WD_8of32_22 WD_8of32_21 WD_8of32_20 WD_8of32_19 WD_8of32_18 WD_8of32_17 WD_8of32_16 WD_8of32_15 WD_8of32_14 WD_8of32_13 WD_8of32_12 WD_8of32_11 WD_8of32_10 WD_8of32_9 WD_8of32_8 WD_8of32_7 WD_8of32_6 WD_8of32_5 WD_8of32_4 WD_8of32_3 WD_8of32_2 WD_8of32_1 WD_8of32_0 WD_Ack_7 WD_Ack_6 WD_Ack_5 WD_Ack_4 WD_Ack_3 WD_Ack_2 WD_Ack_1 WD_Ack_0
    I15 (net096_0 net096_1 net096_2 net096_3 net096_4 net096_5 net096_6 net096_7 net096_8 net096_9 net096_10 net096_11 net096_12 net096_13 net096_14 net096_15 net096_16 net096_17 net096_18 net096_19 net096_20 net096_21 net096_22 net096_23 net096_24 net096_25 net096_26 net096_27 net096_28 net096_29 net096_30 net096_31 net096_32 net096_33 net096_34 net096_35 net096_36 net096_37 net096_38 net096_39 net096_40 net096_41 net096_42 net096_43 net096_44 net096_45 net096_46 net096_47 net096_48 net096_49 net096_50 net096_51 net096_52 net096_53 net096_54 net096_55 net096_56 net096_57 net096_58 net096_59 net096_60 net096_61 net096_62 net096_63 B0_4_3 B0_4_2 B0_4_1 B0_4_0 B1_4_3 B1_4_2 B1_4_1 B1_4_0 G04 net068_0 net068_1 net068_2 net068_3 net068_4 net068_5 net068_6 net068_7 W0_4_3 W0_4_2 W0_4_1 W0_4_0 W1_4_3 W1_4_2 W1_4_1 W1_4_0 \~R0_4_3 \~R0_4_2 \~R0_4_1 \~R0_4_0 \~R1_4_3 \~R1_4_2 \~R1_4_1 \~R1_4_0) _sub175
    I14 (net0157_0 net0157_1 net0157_2 net0157_3 net0157_4 net0157_5 net0157_6 net0157_7 net0157_8 net0157_9 net0157_10 net0157_11 net0157_12 net0157_13 net0157_14 net0157_15 net0157_16 net0157_17 net0157_18 net0157_19 net0157_20 net0157_21 net0157_22 net0157_23 net0157_24 net0157_25 net0157_26 net0157_27 net0157_28 net0157_29 net0157_30 net0157_31 net0157_32 net0157_33 net0157_34 net0157_35 net0157_36 net0157_37 net0157_38 net0157_39 net0157_40 net0157_41 net0157_42 net0157_43 net0157_44 net0157_45 net0157_46 net0157_47 net0157_48 net0157_49 net0157_50 net0157_51 net0157_52 net0157_53 net0157_54 net0157_55 net0157_56 net0157_57 net0157_58 net0157_59 net0157_60 net0157_61 net0157_62 net0157_63 B0_4_3 B0_4_2 B0_4_1 B0_4_0 B1_4_3 B1_4_2 B1_4_1 B1_4_0 G04 net0131_0 net0131_1 net0131_2 net0131_3 net0131_4 net0131_5 net0131_6 net0131_7 W0_4_3 W0_4_2 W0_4_1 W0_4_0 W1_4_3 W1_4_2 W1_4_1 W1_4_0 \~R0_4_3 \~R0_4_2 \~R0_4_1 \~R0_4_0 \~R1_4_3 \~R1_4_2 \~R1_4_1 \~R1_4_0) _sub175
    I13 (net087_0 net087_1 net087_2 net087_3 net087_4 net087_5 net087_6 net087_7 net087_8 net087_9 net087_10 net087_11 net087_12 net087_13 net087_14 net087_15 net087_16 net087_17 net087_18 net087_19 net087_20 net087_21 net087_22 net087_23 net087_24 net087_25 net087_26 net087_27 net087_28 net087_29 net087_30 net087_31 net087_32 net087_33 net087_34 net087_35 net087_36 net087_37 net087_38 net087_39 net087_40 net087_41 net087_42 net087_43 net087_44 net087_45 net087_46 net087_47 net087_48 net087_49 net087_50 net087_51 net087_52 net087_53 net087_54 net087_55 net087_56 net087_57 net087_58 net087_59 net087_60 net087_61 net087_62 net087_63 B0_4_3 B0_4_2 B0_4_1 B0_4_0 B1_4_3 B1_4_2 B1_4_1 B1_4_0 G04 net059_0 net059_1 net059_2 net059_3 net059_4 net059_5 net059_6 net059_7 W0_4_3 W0_4_2 W0_4_1 W0_4_0 W1_4_3 W1_4_2 W1_4_1 W1_4_0 \~R0_4_3 \~R0_4_2 \~R0_4_1 \~R0_4_0 \~R1_4_3 \~R1_4_2 \~R1_4_1 \~R1_4_0) _sub175
    I12 (A_1_63 A_1_62 A_1_61 A_1_60 A_1_59 A_1_58 A_1_57 A_1_56 A_1_55 A_1_54 A_1_53 A_1_52 A_1_51 A_1_50 A_1_49 A_1_48 A_1_47 A_1_46 A_1_45 A_1_44 A_1_43 A_1_42 A_1_41 A_1_40 A_1_39 A_1_38 A_1_37 A_1_36 A_1_35 A_1_34 A_1_33 A_1_32 A_1_31 A_1_30 A_1_29 A_1_28 A_1_27 A_1_26 A_1_25 A_1_24 A_1_23 A_1_22 A_1_21 A_1_20 A_1_19 A_1_18 A_1_17 A_1_16 A_1_15 A_1_14 A_1_13 A_1_12 A_1_11 A_1_10 A_1_9 A_1_8 A_1_7 A_1_6 A_1_5 A_1_4 A_1_3 A_1_2 A_1_1 A_1_0 B0_4_3 B0_4_2 B0_4_1 B0_4_0 B1_4_3 B1_4_2 B1_4_1 B1_4_0 G04 S_1_7 S_1_6 S_1_5 S_1_4 S_1_3 S_1_2 S_1_1 S_1_0 W0_4_3 W0_4_2 W0_4_1 W0_4_0 W1_4_3 W1_4_2 W1_4_1 W1_4_0 \~R0_4_3 \~R0_4_2 \~R0_4_1 \~R0_4_0 \~R1_4_3 \~R1_4_2 \~R1_4_1 \~R1_4_0) _sub175
    I11 (net096_0 net096_1 net096_2 net096_3 net096_4 net096_5 net096_6 net096_7 net096_8 net096_9 net096_10 net096_11 net096_12 net096_13 net096_14 net096_15 net096_16 net096_17 net096_18 net096_19 net096_20 net096_21 net096_22 net096_23 net096_24 net096_25 net096_26 net096_27 net096_28 net096_29 net096_30 net096_31 net096_32 net096_33 net096_34 net096_35 net096_36 net096_37 net096_38 net096_39 net096_40 net096_41 net096_42 net096_43 net096_44 net096_45 net096_46 net096_47 net096_48 net096_49 net096_50 net096_51 net096_52 net096_53 net096_54 net096_55 net096_56 net096_57 net096_58 net096_59 net096_60 net096_61 net096_62 net096_63 B0_3_3 B0_3_2 B0_3_1 B0_3_0 B1_3_3 B1_3_2 B1_3_1 B1_3_0 G03 net068_0 net068_1 net068_2 net068_3 net068_4 net068_5 net068_6 net068_7 W0_3_3 W0_3_2 W0_3_1 W0_3_0 W1_3_3 W1_3_2 W1_3_1 W1_3_0 \~R0_3_3 \~R0_3_2 \~R0_3_1 \~R0_3_0 \~R1_3_3 \~R1_3_2 \~R1_3_1 \~R1_3_0) _sub175
    I10 (net0157_0 net0157_1 net0157_2 net0157_3 net0157_4 net0157_5 net0157_6 net0157_7 net0157_8 net0157_9 net0157_10 net0157_11 net0157_12 net0157_13 net0157_14 net0157_15 net0157_16 net0157_17 net0157_18 net0157_19 net0157_20 net0157_21 net0157_22 net0157_23 net0157_24 net0157_25 net0157_26 net0157_27 net0157_28 net0157_29 net0157_30 net0157_31 net0157_32 net0157_33 net0157_34 net0157_35 net0157_36 net0157_37 net0157_38 net0157_39 net0157_40 net0157_41 net0157_42 net0157_43 net0157_44 net0157_45 net0157_46 net0157_47 net0157_48 net0157_49 net0157_50 net0157_51 net0157_52 net0157_53 net0157_54 net0157_55 net0157_56 net0157_57 net0157_58 net0157_59 net0157_60 net0157_61 net0157_62 net0157_63 B0_3_3 B0_3_2 B0_3_1 B0_3_0 B1_3_3 B1_3_2 B1_3_1 B1_3_0 G03 net0131_0 net0131_1 net0131_2 net0131_3 net0131_4 net0131_5 net0131_6 net0131_7 W0_3_3 W0_3_2 W0_3_1 W0_3_0 W1_3_3 W1_3_2 W1_3_1 W1_3_0 \~R0_3_3 \~R0_3_2 \~R0_3_1 \~R0_3_0 \~R1_3_3 \~R1_3_2 \~R1_3_1 \~R1_3_0) _sub175
    I9 (net087_0 net087_1 net087_2 net087_3 net087_4 net087_5 net087_6 net087_7 net087_8 net087_9 net087_10 net087_11 net087_12 net087_13 net087_14 net087_15 net087_16 net087_17 net087_18 net087_19 net087_20 net087_21 net087_22 net087_23 net087_24 net087_25 net087_26 net087_27 net087_28 net087_29 net087_30 net087_31 net087_32 net087_33 net087_34 net087_35 net087_36 net087_37 net087_38 net087_39 net087_40 net087_41 net087_42 net087_43 net087_44 net087_45 net087_46 net087_47 net087_48 net087_49 net087_50 net087_51 net087_52 net087_53 net087_54 net087_55 net087_56 net087_57 net087_58 net087_59 net087_60 net087_61 net087_62 net087_63 B0_3_3 B0_3_2 B0_3_1 B0_3_0 B1_3_3 B1_3_2 B1_3_1 B1_3_0 G03 net059_0 net059_1 net059_2 net059_3 net059_4 net059_5 net059_6 net059_7 W0_3_3 W0_3_2 W0_3_1 W0_3_0 W1_3_3 W1_3_2 W1_3_1 W1_3_0 \~R0_3_3 \~R0_3_2 \~R0_3_1 \~R0_3_0 \~R1_3_3 \~R1_3_2 \~R1_3_1 \~R1_3_0) _sub175
    I8 (A_1_63 A_1_62 A_1_61 A_1_60 A_1_59 A_1_58 A_1_57 A_1_56 A_1_55 A_1_54 A_1_53 A_1_52 A_1_51 A_1_50 A_1_49 A_1_48 A_1_47 A_1_46 A_1_45 A_1_44 A_1_43 A_1_42 A_1_41 A_1_40 A_1_39 A_1_38 A_1_37 A_1_36 A_1_35 A_1_34 A_1_33 A_1_32 A_1_31 A_1_30 A_1_29 A_1_28 A_1_27 A_1_26 A_1_25 A_1_24 A_1_23 A_1_22 A_1_21 A_1_20 A_1_19 A_1_18 A_1_17 A_1_16 A_1_15 A_1_14 A_1_13 A_1_12 A_1_11 A_1_10 A_1_9 A_1_8 A_1_7 A_1_6 A_1_5 A_1_4 A_1_3 A_1_2 A_1_1 A_1_0 B0_3_3 B0_3_2 B0_3_1 B0_3_0 B1_3_3 B1_3_2 B1_3_1 B1_3_0 G03 S_1_7 S_1_6 S_1_5 S_1_4 S_1_3 S_1_2 S_1_1 S_1_0 W0_3_3 W0_3_2 W0_3_1 W0_3_0 W1_3_3 W1_3_2 W1_3_1 W1_3_0 \~R0_3_3 \~R0_3_2 \~R0_3_1 \~R0_3_0 \~R1_3_3 \~R1_3_2 \~R1_3_1 \~R1_3_0) _sub175
    I7 (net096_0 net096_1 net096_2 net096_3 net096_4 net096_5 net096_6 net096_7 net096_8 net096_9 net096_10 net096_11 net096_12 net096_13 net096_14 net096_15 net096_16 net096_17 net096_18 net096_19 net096_20 net096_21 net096_22 net096_23 net096_24 net096_25 net096_26 net096_27 net096_28 net096_29 net096_30 net096_31 net096_32 net096_33 net096_34 net096_35 net096_36 net096_37 net096_38 net096_39 net096_40 net096_41 net096_42 net096_43 net096_44 net096_45 net096_46 net096_47 net096_48 net096_49 net096_50 net096_51 net096_52 net096_53 net096_54 net096_55 net096_56 net096_57 net096_58 net096_59 net096_60 net096_61 net096_62 net096_63 B0_2_3 B0_2_2 B0_2_1 B0_2_0 B1_2_3 B1_2_2 B1_2_1 B1_2_0 G02 net068_0 net068_1 net068_2 net068_3 net068_4 net068_5 net068_6 net068_7 W0_2_3 W0_2_2 W0_2_1 W0_2_0 W1_2_3 W1_2_2 W1_2_1 W1_2_0 \~R0_2_3 \~R0_2_2 \~R0_2_1 \~R0_2_0 \~R1_2_3 \~R1_2_2 \~R1_2_1 \~R1_2_0) _sub175
    I6 (net0157_0 net0157_1 net0157_2 net0157_3 net0157_4 net0157_5 net0157_6 net0157_7 net0157_8 net0157_9 net0157_10 net0157_11 net0157_12 net0157_13 net0157_14 net0157_15 net0157_16 net0157_17 net0157_18 net0157_19 net0157_20 net0157_21 net0157_22 net0157_23 net0157_24 net0157_25 net0157_26 net0157_27 net0157_28 net0157_29 net0157_30 net0157_31 net0157_32 net0157_33 net0157_34 net0157_35 net0157_36 net0157_37 net0157_38 net0157_39 net0157_40 net0157_41 net0157_42 net0157_43 net0157_44 net0157_45 net0157_46 net0157_47 net0157_48 net0157_49 net0157_50 net0157_51 net0157_52 net0157_53 net0157_54 net0157_55 net0157_56 net0157_57 net0157_58 net0157_59 net0157_60 net0157_61 net0157_62 net0157_63 B0_2_3 B0_2_2 B0_2_1 B0_2_0 B1_2_3 B1_2_2 B1_2_1 B1_2_0 G02 net0131_0 net0131_1 net0131_2 net0131_3 net0131_4 net0131_5 net0131_6 net0131_7 W0_2_3 W0_2_2 W0_2_1 W0_2_0 W1_2_3 W1_2_2 W1_2_1 W1_2_0 \~R0_2_3 \~R0_2_2 \~R0_2_1 \~R0_2_0 \~R1_2_3 \~R1_2_2 \~R1_2_1 \~R1_2_0) _sub175
    I5 (net087_0 net087_1 net087_2 net087_3 net087_4 net087_5 net087_6 net087_7 net087_8 net087_9 net087_10 net087_11 net087_12 net087_13 net087_14 net087_15 net087_16 net087_17 net087_18 net087_19 net087_20 net087_21 net087_22 net087_23 net087_24 net087_25 net087_26 net087_27 net087_28 net087_29 net087_30 net087_31 net087_32 net087_33 net087_34 net087_35 net087_36 net087_37 net087_38 net087_39 net087_40 net087_41 net087_42 net087_43 net087_44 net087_45 net087_46 net087_47 net087_48 net087_49 net087_50 net087_51 net087_52 net087_53 net087_54 net087_55 net087_56 net087_57 net087_58 net087_59 net087_60 net087_61 net087_62 net087_63 B0_2_3 B0_2_2 B0_2_1 B0_2_0 B1_2_3 B1_2_2 B1_2_1 B1_2_0 G02 net059_0 net059_1 net059_2 net059_3 net059_4 net059_5 net059_6 net059_7 W0_2_3 W0_2_2 W0_2_1 W0_2_0 W1_2_3 W1_2_2 W1_2_1 W1_2_0 \~R0_2_3 \~R0_2_2 \~R0_2_1 \~R0_2_0 \~R1_2_3 \~R1_2_2 \~R1_2_1 \~R1_2_0) _sub175
    I4 (A_1_63 A_1_62 A_1_61 A_1_60 A_1_59 A_1_58 A_1_57 A_1_56 A_1_55 A_1_54 A_1_53 A_1_52 A_1_51 A_1_50 A_1_49 A_1_48 A_1_47 A_1_46 A_1_45 A_1_44 A_1_43 A_1_42 A_1_41 A_1_40 A_1_39 A_1_38 A_1_37 A_1_36 A_1_35 A_1_34 A_1_33 A_1_32 A_1_31 A_1_30 A_1_29 A_1_28 A_1_27 A_1_26 A_1_25 A_1_24 A_1_23 A_1_22 A_1_21 A_1_20 A_1_19 A_1_18 A_1_17 A_1_16 A_1_15 A_1_14 A_1_13 A_1_12 A_1_11 A_1_10 A_1_9 A_1_8 A_1_7 A_1_6 A_1_5 A_1_4 A_1_3 A_1_2 A_1_1 A_1_0 B0_2_3 B0_2_2 B0_2_1 B0_2_0 B1_2_3 B1_2_2 B1_2_1 B1_2_0 G02 S_1_7 S_1_6 S_1_5 S_1_4 S_1_3 S_1_2 S_1_1 S_1_0 W0_2_3 W0_2_2 W0_2_1 W0_2_0 W1_2_3 W1_2_2 W1_2_1 W1_2_0 \~R0_2_3 \~R0_2_2 \~R0_2_1 \~R0_2_0 \~R1_2_3 \~R1_2_2 \~R1_2_1 \~R1_2_0) _sub175
    I3 (net096_0 net096_1 net096_2 net096_3 net096_4 net096_5 net096_6 net096_7 net096_8 net096_9 net096_10 net096_11 net096_12 net096_13 net096_14 net096_15 net096_16 net096_17 net096_18 net096_19 net096_20 net096_21 net096_22 net096_23 net096_24 net096_25 net096_26 net096_27 net096_28 net096_29 net096_30 net096_31 net096_32 net096_33 net096_34 net096_35 net096_36 net096_37 net096_38 net096_39 net096_40 net096_41 net096_42 net096_43 net096_44 net096_45 net096_46 net096_47 net096_48 net096_49 net096_50 net096_51 net096_52 net096_53 net096_54 net096_55 net096_56 net096_57 net096_58 net096_59 net096_60 net096_61 net096_62 net096_63 B0_1_3 B0_1_2 B0_1_1 B0_1_0 B1_1_3 B1_1_2 B1_1_1 B1_1_0 G01 net068_0 net068_1 net068_2 net068_3 net068_4 net068_5 net068_6 net068_7 W0_1_3 W0_1_2 W0_1_1 W0_1_0 W1_1_3 W1_1_2 W1_1_1 W1_1_0 \~R0_1_3 \~R0_1_2 \~R0_1_1 \~R0_1_0 \~R1_1_3 \~R1_1_2 \~R1_1_1 \~R1_1_0) _sub175
    I2 (net0157_0 net0157_1 net0157_2 net0157_3 net0157_4 net0157_5 net0157_6 net0157_7 net0157_8 net0157_9 net0157_10 net0157_11 net0157_12 net0157_13 net0157_14 net0157_15 net0157_16 net0157_17 net0157_18 net0157_19 net0157_20 net0157_21 net0157_22 net0157_23 net0157_24 net0157_25 net0157_26 net0157_27 net0157_28 net0157_29 net0157_30 net0157_31 net0157_32 net0157_33 net0157_34 net0157_35 net0157_36 net0157_37 net0157_38 net0157_39 net0157_40 net0157_41 net0157_42 net0157_43 net0157_44 net0157_45 net0157_46 net0157_47 net0157_48 net0157_49 net0157_50 net0157_51 net0157_52 net0157_53 net0157_54 net0157_55 net0157_56 net0157_57 net0157_58 net0157_59 net0157_60 net0157_61 net0157_62 net0157_63 B0_1_3 B0_1_2 B0_1_1 B0_1_0 B1_1_3 B1_1_2 B1_1_1 B1_1_0 G01 net0131_0 net0131_1 net0131_2 net0131_3 net0131_4 net0131_5 net0131_6 net0131_7 W0_1_3 W0_1_2 W0_1_1 W0_1_0 W1_1_3 W1_1_2 W1_1_1 W1_1_0 \~R0_1_3 \~R0_1_2 \~R0_1_1 \~R0_1_0 \~R1_1_3 \~R1_1_2 \~R1_1_1 \~R1_1_0) _sub175
    I1 (net087_0 net087_1 net087_2 net087_3 net087_4 net087_5 net087_6 net087_7 net087_8 net087_9 net087_10 net087_11 net087_12 net087_13 net087_14 net087_15 net087_16 net087_17 net087_18 net087_19 net087_20 net087_21 net087_22 net087_23 net087_24 net087_25 net087_26 net087_27 net087_28 net087_29 net087_30 net087_31 net087_32 net087_33 net087_34 net087_35 net087_36 net087_37 net087_38 net087_39 net087_40 net087_41 net087_42 net087_43 net087_44 net087_45 net087_46 net087_47 net087_48 net087_49 net087_50 net087_51 net087_52 net087_53 net087_54 net087_55 net087_56 net087_57 net087_58 net087_59 net087_60 net087_61 net087_62 net087_63 B0_1_3 B0_1_2 B0_1_1 B0_1_0 B1_1_3 B1_1_2 B1_1_1 B1_1_0 G01 net059_0 net059_1 net059_2 net059_3 net059_4 net059_5 net059_6 net059_7 W0_1_3 W0_1_2 W0_1_1 W0_1_0 W1_1_3 W1_1_2 W1_1_1 W1_1_0 \~R0_1_3 \~R0_1_2 \~R0_1_1 \~R0_1_0 \~R1_1_3 \~R1_1_2 \~R1_1_1 \~R1_1_0) _sub175
    I0 (A_1_63 A_1_62 A_1_61 A_1_60 A_1_59 A_1_58 A_1_57 A_1_56 A_1_55 A_1_54 A_1_53 A_1_52 A_1_51 A_1_50 A_1_49 A_1_48 A_1_47 A_1_46 A_1_45 A_1_44 A_1_43 A_1_42 A_1_41 A_1_40 A_1_39 A_1_38 A_1_37 A_1_36 A_1_35 A_1_34 A_1_33 A_1_32 A_1_31 A_1_30 A_1_29 A_1_28 A_1_27 A_1_26 A_1_25 A_1_24 A_1_23 A_1_22 A_1_21 A_1_20 A_1_19 A_1_18 A_1_17 A_1_16 A_1_15 A_1_14 A_1_13 A_1_12 A_1_11 A_1_10 A_1_9 A_1_8 A_1_7 A_1_6 A_1_5 A_1_4 A_1_3 A_1_2 A_1_1 A_1_0 B0_1_3 B0_1_2 B0_1_1 B0_1_0 B1_1_3 B1_1_2 B1_1_1 B1_1_0 G01 S_1_7 S_1_6 S_1_5 S_1_4 S_1_3 S_1_2 S_1_1 S_1_0 W0_1_3 W0_1_2 W0_1_1 W0_1_0 W1_1_3 W1_1_2 W1_1_1 W1_1_0 \~R0_1_3 \~R0_1_2 \~R0_1_1 \~R0_1_0 \~R1_1_3 \~R1_1_2 \~R1_1_1 \~R1_1_0) _sub175
    I19 (A_3 A_2 A_1 A_0 A_7 A_6 A_5 A_4 A_11 A_10 A_9 A_8 A_15 A_14 A_13 A_12 net096_0 net096_1 net096_2 net096_3 net096_4 net096_5 net096_6 net096_7 net096_8 net096_9 net096_10 net096_11 net096_12 net096_13 net096_14 net096_15 net096_16 net096_17 net096_18 net096_19 net096_20 net096_21 net096_22 net096_23 net096_24 net096_25 net096_26 net096_27 net096_28 net096_29 net096_30 net096_31 net096_32 net096_33 net096_34 net096_35 net096_36 net096_37 net096_38 net096_39 net096_40 net096_41 net096_42 net096_43 net096_44 net096_45 net096_46 net096_47 net096_48 net096_49 net096_50 net096_51 net096_52 net096_53 net096_54 net096_55 net096_56 net096_57 net096_58 net096_59 net096_60 net096_61 net096_62 net096_63 A_19 net068_0 net068_1 net068_2 net068_3 net068_4 net068_5 net068_6 net068_7 net0252) _sub176
    I18 (A_3 A_2 A_1 A_0 A_7 A_6 A_5 A_4 A_11 A_10 A_9 A_8 A_15 A_14 A_13 A_12 net0157_0 net0157_1 net0157_2 net0157_3 net0157_4 net0157_5 net0157_6 net0157_7 net0157_8 net0157_9 net0157_10 net0157_11 net0157_12 net0157_13 net0157_14 net0157_15 net0157_16 net0157_17 net0157_18 net0157_19 net0157_20 net0157_21 net0157_22 net0157_23 net0157_24 net0157_25 net0157_26 net0157_27 net0157_28 net0157_29 net0157_30 net0157_31 net0157_32 net0157_33 net0157_34 net0157_35 net0157_36 net0157_37 net0157_38 net0157_39 net0157_40 net0157_41 net0157_42 net0157_43 net0157_44 net0157_45 net0157_46 net0157_47 net0157_48 net0157_49 net0157_50 net0157_51 net0157_52 net0157_53 net0157_54 net0157_55 net0157_56 net0157_57 net0157_58 net0157_59 net0157_60 net0157_61 net0157_62 net0157_63 A_18 net0131_0 net0131_1 net0131_2 net0131_3 net0131_4 net0131_5 net0131_6 net0131_7 net0256) _sub176
    I17 (A_3 A_2 A_1 A_0 A_7 A_6 A_5 A_4 A_11 A_10 A_9 A_8 A_15 A_14 A_13 A_12 net087_0 net087_1 net087_2 net087_3 net087_4 net087_5 net087_6 net087_7 net087_8 net087_9 net087_10 net087_11 net087_12 net087_13 net087_14 net087_15 net087_16 net087_17 net087_18 net087_19 net087_20 net087_21 net087_22 net087_23 net087_24 net087_25 net087_26 net087_27 net087_28 net087_29 net087_30 net087_31 net087_32 net087_33 net087_34 net087_35 net087_36 net087_37 net087_38 net087_39 net087_40 net087_41 net087_42 net087_43 net087_44 net087_45 net087_46 net087_47 net087_48 net087_49 net087_50 net087_51 net087_52 net087_53 net087_54 net087_55 net087_56 net087_57 net087_58 net087_59 net087_60 net087_61 net087_62 net087_63 A_17 net059_0 net059_1 net059_2 net059_3 net059_4 net059_5 net059_6 net059_7 net0260) _sub176
    I16 (A_3 A_2 A_1 A_0 A_7 A_6 A_5 A_4 A_11 A_10 A_9 A_8 A_15 A_14 A_13 A_12 A_1_63 A_1_62 A_1_61 A_1_60 A_1_59 A_1_58 A_1_57 A_1_56 A_1_55 A_1_54 A_1_53 A_1_52 A_1_51 A_1_50 A_1_49 A_1_48 A_1_47 A_1_46 A_1_45 A_1_44 A_1_43 A_1_42 A_1_41 A_1_40 A_1_39 A_1_38 A_1_37 A_1_36 A_1_35 A_1_34 A_1_33 A_1_32 A_1_31 A_1_30 A_1_29 A_1_28 A_1_27 A_1_26 A_1_25 A_1_24 A_1_23 A_1_22 A_1_21 A_1_20 A_1_19 A_1_18 A_1_17 A_1_16 A_1_15 A_1_14 A_1_13 A_1_12 A_1_11 A_1_10 A_1_9 A_1_8 A_1_7 A_1_6 A_1_5 A_1_4 A_1_3 A_1_2 A_1_1 A_1_0 A_16 S_1_7 S_1_6 S_1_5 S_1_4 S_1_3 S_1_2 S_1_1 S_1_0 net0264) _sub176
    I25 (net042 B0_4_3 B0_4_2 B0_4_1 B0_4_0 B1_4_3 B1_4_2 B1_4_1 B1_4_0 G04 RD_8of32_27 RD_8of32_26 RD_8of32_25 RD_8of32_24 RD_8of32_31 RD_8of32_30 RD_8of32_29 RD_8of32_28 RW_1 RW_0 Reset ValAddr W0_4_3 W0_4_2 W0_4_1 W0_4_0 W1_4_3 W1_4_2 W1_4_1 W1_4_0 WD_8of32_27 WD_8of32_26 WD_8of32_25 WD_8of32_24 WD_8of32_31 WD_8of32_30 WD_8of32_29 WD_8of32_28 0 net0170 RD_Ack_7 RD_Ack_6 WD_Ack_7 WD_Ack_6 \~R0_4_3 \~R0_4_2 \~R0_4_1 \~R0_4_0 \~R1_4_3 \~R1_4_2 \~R1_4_1 \~R1_4_0) _sub177
    I22 (ck_2 B0_3_3 B0_3_2 B0_3_1 B0_3_0 B1_3_3 B1_3_2 B1_3_1 B1_3_0 G03 RD_8of32_19 RD_8of32_18 RD_8of32_17 RD_8of32_16 RD_8of32_23 RD_8of32_22 RD_8of32_21 RD_8of32_20 RW_1 RW_0 Reset ValAddr W0_3_3 W0_3_2 W0_3_1 W0_3_0 W1_3_3 W1_3_2 W1_3_1 W1_3_0 WD_8of32_19 WD_8of32_18 WD_8of32_17 WD_8of32_16 WD_8of32_23 WD_8of32_22 WD_8of32_21 WD_8of32_20 net042 ck_3 RD_Ack_5 RD_Ack_4 WD_Ack_5 WD_Ack_4 \~R0_3_3 \~R0_3_2 \~R0_3_1 \~R0_3_0 \~R1_3_3 \~R1_3_2 \~R1_3_1 \~R1_3_0) _sub177
    I21 (ck_0 B0_2_3 B0_2_2 B0_2_1 B0_2_0 B1_2_3 B1_2_2 B1_2_1 B1_2_0 G02 RD_8of32_11 RD_8of32_10 RD_8of32_9 RD_8of32_8 RD_8of32_15 RD_8of32_14 RD_8of32_13 RD_8of32_12 RW_1 RW_0 Reset ValAddr W0_2_3 W0_2_2 W0_2_1 W0_2_0 W1_2_3 W1_2_2 W1_2_1 W1_2_0 WD_8of32_11 WD_8of32_10 WD_8of32_9 WD_8of32_8 WD_8of32_15 WD_8of32_14 WD_8of32_13 WD_8of32_12 ck_1 net027 RD_Ack_3 RD_Ack_2 WD_Ack_3 WD_Ack_2 \~R0_2_3 \~R0_2_2 \~R0_2_1 \~R0_2_0 \~R1_2_3 \~R1_2_2 \~R1_2_1 \~R1_2_0) _sub177
    I20 (net027 B0_1_3 B0_1_2 B0_1_1 B0_1_0 B1_1_3 B1_1_2 B1_1_1 B1_1_0 G01 RD_8of32_3 RD_8of32_2 RD_8of32_1 RD_8of32_0 RD_8of32_7 RD_8of32_6 RD_8of32_5 RD_8of32_4 RW_1 RW_0 Reset ValAddr W0_1_3 W0_1_2 W0_1_1 W0_1_0 W1_1_3 W1_1_2 W1_1_1 W1_1_0 WD_8of32_3 WD_8of32_2 WD_8of32_1 WD_8of32_0 WD_8of32_7 WD_8of32_6 WD_8of32_5 WD_8of32_4 net0173 0 RD_Ack_1 RD_Ack_0 WD_Ack_1 WD_Ack_0 \~R0_1_3 \~R0_1_2 \~R0_1_1 \~R0_1_0 \~R1_1_3 \~R1_1_2 \~R1_1_1 \~R1_1_0) _sub177
    I24 (A_3 A_2 A_1 A_0 A_7 A_6 A_5 A_4 A_11 A_10 A_9 A_8 A_15 A_14 A_13 A_12 A_19 A_18 A_17 A_16 ck_1 ck_0 ck_3 ck_2 Ack RW_1 RW_0 Reset ValAddr) _sub178
    I29_4 (Ack Ctrl_Ack_4) inv_1x
    I29_3 (Ack Ctrl_Ack_3) inv_1x
    I29_2 (Ack Ctrl_Ack_2) inv_1x
    I29_1 (Ack Ctrl_Ack_1) inv_1x
    I29_0 (Ack Ctrl_Ack_0) inv_1x
ends _sub179

// 16nm/TH33~/schematic
//system verilogNetlist schematic cmos.sch cmos_sch veriloga ahdl
subckt _sub180 A B C Y
    M19 (net13 A 0 0) nfet w=80n l=16n m=1
    M18 (net13 B 0 0) nfet w=80n l=16n m=1
    M17 (net13 C 0 0) nfet w=80n l=16n m=1
    M15 (net09 net44 0 0) nfet w=40n l=16n m=1
    M14 (net42 A 0 0) nfet w=120n l=16n m=1
    M13 (net43 B net42 0) nfet w=120n l=16n m=1
    M12 (net44 C net43 0) nfet w=120n l=16n m=1
    M10 (net44 net09 net13 0) nfet w=80n l=16n m=1
    I6 (net09 Y) inv_1x
    M9 (net09 net44 vdd! vdd!) pfet w=80n l=16n m=1
    M8 (net44 net09 net15 vdd!) pfet w=160n l=16n m=1
    M6 (net15 C vdd! vdd!) pfet w=160n l=16n m=1
    M5 (net15 B vdd! vdd!) pfet w=160n l=16n m=1
    M4 (net15 A vdd! vdd!) pfet w=160n l=16n m=1
    M2 (net44 C net46 vdd!) pfet w=240n l=16n m=1
    M1 (net46 B net47 vdd!) pfet w=240n l=16n m=1
    M0 (net47 A vdd! vdd!) pfet w=240n l=16n m=1
ends _sub180

// 16nm/6T_1of4Merge/schematic
//system verilogNetlist schematic cmos.sch cmos_sch veriloga ahdl
subckt _sub181 a_3 a_2 a_1 a_0 a_ack ack asel b_3 b_2 b_1 b_0 b_ack bsel out_3 out_2 out_1 out_0
    I13 (net31 net29 net27 net25 b_ack) nand4_1x
    I12 (net26 net28 net30 net32 a_ack) nand4_1x
    I11 (net42 ack out_0) TH22
    I10 (net41 ack out_1) TH22
    I9 (net40 ack out_2) TH22
    I8 (net39 ack out_3) TH22
    I7 (b_0 bsel net21 net31) _sub180
    I6 (b_1 bsel net22 net29) _sub180
    I5 (b_2 bsel net23 net27) _sub180
    I4 (b_3 bsel net24 net25) _sub180
    I3 (a_3 asel net24 net32) _sub180
    I2 (a_2 asel net23 net30) _sub180
    I1 (a_1 asel net22 net28) _sub180
    I0 (a_0 asel net21 net26) _sub180
    I17 (net32 net25 net39) nand_1x
    I16 (net30 net27 net40) nand_1x
    I15 (net28 net29 net41) nand_1x
    I14 (net26 net31 net42) nand_1x
    I21 (out_0 net21) inv_1x
    I20 (out_1 net22) inv_1x
    I19 (out_2 net23) inv_1x
    I18 (out_3 net24) inv_1x
ends _sub181

// 16nm/6T_4of16Merge/schematic
//system verilogNetlist schematic cmos.sch cmos_sch veriloga ahdl
subckt _sub182 A1_1of4_3 A1_1of4_2 A1_1of4_1 A1_1of4_0 A2_1of4_3 A2_1of4_2 A2_1of4_1 A2_1of4_0 A3_1of4_3 A3_1of4_2 A3_1of4_1 A3_1of4_0 A4_1of4_3 A4_1of4_2 A4_1of4_1 A4_1of4_0 A_Ack_3 A_Ack_2 A_Ack_1 A_Ack_0 Asel B1_1of4_3 B1_1of4_2 B1_1of4_1 B1_1of4_0 B2_1of4_3 B2_1of4_2 B2_1of4_1 B2_1of4_0 B3_1of4_3 B3_1of4_2 B3_1of4_1 B3_1of4_0 B4_1of4_3 B4_1of4_2 B4_1of4_1 B4_1of4_0 B_Ack_3 B_Ack_2 B_Ack_1 B_Ack_0 Bsel C1_1of4_3 C1_1of4_2 C1_1of4_1 C1_1of4_0 C2_1of4_3 C2_1of4_2 C2_1of4_1 C2_1of4_0 C3_1of4_3 C3_1of4_2 C3_1of4_1 C3_1of4_0 C4_1of4_3 C4_1of4_2 C4_1of4_1 C4_1of4_0 C_Ack_3 C_Ack_2 C_Ack_1 C_Ack_0
    I25 (A4_1of4_3 A4_1of4_2 A4_1of4_1 A4_1of4_0 A_Ack_3 C_Ack_3 Asel B4_1of4_3 B4_1of4_2 B4_1of4_1 B4_1of4_0 B_Ack_3 Bsel C4_1of4_3 C4_1of4_2 C4_1of4_1 C4_1of4_0) _sub181
    I24 (A3_1of4_3 A3_1of4_2 A3_1of4_1 A3_1of4_0 A_Ack_2 C_Ack_2 Asel B3_1of4_3 B3_1of4_2 B3_1of4_1 B3_1of4_0 B_Ack_2 Bsel C3_1of4_3 C3_1of4_2 C3_1of4_1 C3_1of4_0) _sub181
    I23 (A2_1of4_3 A2_1of4_2 A2_1of4_1 A2_1of4_0 A_Ack_1 C_Ack_1 Asel B2_1of4_3 B2_1of4_2 B2_1of4_1 B2_1of4_0 B_Ack_1 Bsel C2_1of4_3 C2_1of4_2 C2_1of4_1 C2_1of4_0) _sub181
    I22 (A1_1of4_3 A1_1of4_2 A1_1of4_1 A1_1of4_0 A_Ack_0 C_Ack_0 Asel B1_1of4_3 B1_1of4_2 B1_1of4_1 B1_1of4_0 B_Ack_0 Bsel C1_1of4_3 C1_1of4_2 C1_1of4_1 C1_1of4_0) _sub181
ends _sub182

// 16nm/6T_1of2Merge/schematic
//system verilogNetlist schematic cmos.sch cmos_sch veriloga ahdl
subckt _sub183 a_1 a_0 a_ack ack asel b_1 b_0 b_ack bsel out_1 out_0
    I11 (net42 ack out_0) TH22
    I10 (net41 ack out_1) TH22
    I7 (b_0 bsel net21 net31) _sub180
    I6 (b_1 bsel net22 net29) _sub180
    I1 (a_1 asel net22 net28) _sub180
    I0 (a_0 asel net21 net26) _sub180
    I15 (net28 net29 net41) nand_1x
    I14 (net26 net31 net42) nand_1x
    I13 (net31 net29 b_ack) nand_1x
    I12 (net26 net28 a_ack) nand_1x
    I21 (out_0 net21) inv_1x
    I20 (out_1 net22) inv_1x
ends _sub183

// 16nm/6T_AddressMerge/schematic
//system verilogNetlist schematic cmos.sch cmos_sch veriloga ahdl
subckt _sub184 Ack_4 Ack_3 Ack_2 Ack_1 Ack_0 Addr_19 Addr_18 Addr_17 Addr_16 Addr_15 Addr_14 Addr_13 Addr_12 Addr_11 Addr_10 Addr_9 Addr_8 Addr_7 Addr_6 Addr_5 Addr_4 Addr_3 Addr_2 Addr_1 Addr_0 RAddr_Ack_4 RAddr_Ack_3 RAddr_Ack_2 RAddr_Ack_1 RAddr_Ack_0 RW_1 RW_0 RW_Ack R_Addr_19 R_Addr_18 R_Addr_17 R_Addr_16 R_Addr_15 R_Addr_14 R_Addr_13 R_Addr_12 R_Addr_11 R_Addr_10 R_Addr_9 R_Addr_8 R_Addr_7 R_Addr_6 R_Addr_5 R_Addr_4 R_Addr_3 R_Addr_2 R_Addr_1 R_Addr_0 Read_1 Read_0 Read_Ack WAddr_Ack_4 WAddr_Ack_3 WAddr_Ack_2 WAddr_Ack_1 WAddr_Ack_0 W_Addr_19 W_Addr_18 W_Addr_17 W_Addr_16 W_Addr_15 W_Addr_14 W_Addr_13 W_Addr_12 W_Addr_11 W_Addr_10 W_Addr_9 W_Addr_8 W_Addr_7 W_Addr_6 W_Addr_5 W_Addr_4 W_Addr_3 W_Addr_2 W_Addr_1 W_Addr_0 Write_1 Write_0 Write_Ack
    I0 (W_Addr_3 W_Addr_2 W_Addr_1 W_Addr_0 W_Addr_7 W_Addr_6 W_Addr_5 W_Addr_4 W_Addr_11 W_Addr_10 W_Addr_9 W_Addr_8 W_Addr_15 W_Addr_14 W_Addr_13 W_Addr_12 WAddr_Ack_3 WAddr_Ack_2 WAddr_Ack_1 WAddr_Ack_0 Write_0 R_Addr_3 R_Addr_2 R_Addr_1 R_Addr_0 R_Addr_7 R_Addr_6 R_Addr_5 R_Addr_4 R_Addr_11 R_Addr_10 R_Addr_9 R_Addr_8 R_Addr_15 R_Addr_14 R_Addr_13 R_Addr_12 RAddr_Ack_3 RAddr_Ack_2 RAddr_Ack_1 RAddr_Ack_0 Read_1 Addr_3 Addr_2 Addr_1 Addr_0 Addr_7 Addr_6 Addr_5 Addr_4 Addr_11 Addr_10 Addr_9 Addr_8 Addr_15 Addr_14 Addr_13 Addr_12 Ack_3 Ack_2 Ack_1 Ack_0) _sub182
    I1 (W_Addr_19 W_Addr_18 W_Addr_17 W_Addr_16 WAddr_Ack_4 Ack_4 Write_0 R_Addr_19 R_Addr_18 R_Addr_17 R_Addr_16 RAddr_Ack_4 Read_1 Addr_19 Addr_18 Addr_17 Addr_16) _sub181
    I3 (Write_1 Write_0 Write_Ack RW_Ack Write_0 Read_1 Read_0 Read_Ack Read_1 RW_1 RW_0) _sub183
ends _sub184

// 16nm/6T_SDP_BANK/schematic
//system verilogNetlist schematic cmos.sch cmos_sch veriloga ahdl
subckt _sub185 RAddr_Ack_4 RAddr_Ack_3 RAddr_Ack_2 RAddr_Ack_1 RAddr_Ack_0 Read_1 Read_0 ReadAck_7 ReadAck_6 ReadAck_5 ReadAck_4 ReadAck_3 ReadAck_2 ReadAck_1 ReadAck_0 ReadData_31 ReadData_30 ReadData_29 ReadData_28 ReadData_27 ReadData_26 ReadData_25 ReadData_24 ReadData_23 ReadData_22 ReadData_21 ReadData_20 ReadData_19 ReadData_18 ReadData_17 ReadData_16 ReadData_15 ReadData_14 ReadData_13 ReadData_12 ReadData_11 ReadData_10 ReadData_9 ReadData_8 ReadData_7 ReadData_6 ReadData_5 ReadData_4 ReadData_3 ReadData_2 ReadData_1 ReadData_0 Read_Ack Read_Address_19 Read_Address_18 Read_Address_17 Read_Address_16 Read_Address_15 Read_Address_14 Read_Address_13 Read_Address_12 Read_Address_11 Read_Address_10 Read_Address_9 Read_Address_8 Read_Address_7 Read_Address_6 Read_Address_5 Read_Address_4 Read_Address_3 Read_Address_2 Read_Address_1 Read_Address_0 WAddr_Ack_4 WAddr_Ack_3 WAddr_Ack_2 WAddr_Ack_1 WAddr_Ack_0 Write_1 Write_0 WriteAck_7 WriteAck_6 WriteAck_5 WriteAck_4 WriteAck_3 WriteAck_2 WriteAck_1 WriteAck_0 WriteData_31 WriteData_30 WriteData_29 WriteData_28 WriteData_27 WriteData_26 WriteData_25 WriteData_24 WriteData_23 WriteData_22 WriteData_21 WriteData_20 WriteData_19 WriteData_18 WriteData_17 WriteData_16 WriteData_15 WriteData_14 WriteData_13 WriteData_12 WriteData_11 WriteData_10 WriteData_9 WriteData_8 WriteData_7 WriteData_6 WriteData_5 WriteData_4 WriteData_3 WriteData_2 WriteData_1 WriteData_0 Write_Ack Write_Address_19 Write_Address_18 Write_Address_17 Write_Address_16 Write_Address_15 Write_Address_14 Write_Address_13 Write_Address_12 Write_Address_11 Write_Address_10 Write_Address_9 Write_Address_8 Write_Address_7 Write_Address_6 Write_Address_5 Write_Address_4 Write_Address_3 Write_Address_2 Write_Address_1 Write_Address_0
    I0 (net016_0 net016_1 net016_2 net016_3 net016_4 net016_5 net016_6 net016_7 net016_8 net016_9 net016_10 net016_11 net016_12 net016_13 net016_14 net016_15 net016_16 net016_17 net016_18 net016_19 net1 net11_0 net11_1 net11_2 net11_3 net11_4 ReadData_31 ReadData_30 ReadData_29 ReadData_28 ReadData_27 ReadData_26 ReadData_25 ReadData_24 ReadData_23 ReadData_22 ReadData_21 ReadData_20 ReadData_19 ReadData_18 ReadData_17 ReadData_16 ReadData_15 ReadData_14 ReadData_13 ReadData_12 ReadData_11 ReadData_10 ReadData_9 ReadData_8 ReadData_7 ReadData_6 ReadData_5 ReadData_4 ReadData_3 ReadData_2 ReadData_1 ReadData_0 ReadAck_7 ReadAck_6 ReadAck_5 ReadAck_4 ReadAck_3 ReadAck_2 ReadAck_1 ReadAck_0 net017_0 net017_1 WriteData_31 WriteData_30 WriteData_29 WriteData_28 WriteData_27 WriteData_26 WriteData_25 WriteData_24 WriteData_23 WriteData_22 WriteData_21 WriteData_20 WriteData_19 WriteData_18 WriteData_17 WriteData_16 WriteData_15 WriteData_14 WriteData_13 WriteData_12 WriteData_11 WriteData_10 WriteData_9 WriteData_8 WriteData_7 WriteData_6 WriteData_5 WriteData_4 WriteData_3 WriteData_2 WriteData_1 WriteData_0 WriteAck_7 WriteAck_6 WriteAck_5 WriteAck_4 WriteAck_3 WriteAck_2 WriteAck_1 WriteAck_0) _sub179
    I1 (net11_0 net11_1 net11_2 net11_3 net11_4 net016_0 net016_1 net016_2 net016_3 net016_4 net016_5 net016_6 net016_7 net016_8 net016_9 net016_10 net016_11 net016_12 net016_13 net016_14 net016_15 net016_16 net016_17 net016_18 net016_19 RAddr_Ack_4 RAddr_Ack_3 RAddr_Ack_2 RAddr_Ack_1 RAddr_Ack_0 net017_0 net017_1 net1 Read_Address_19 Read_Address_18 Read_Address_17 Read_Address_16 Read_Address_15 Read_Address_14 Read_Address_13 Read_Address_12 Read_Address_11 Read_Address_10 Read_Address_9 Read_Address_8 Read_Address_7 Read_Address_6 Read_Address_5 Read_Address_4 Read_Address_3 Read_Address_2 Read_Address_1 Read_Address_0 Read_1 Read_0 Read_Ack WAddr_Ack_4 WAddr_Ack_3 WAddr_Ack_2 WAddr_Ack_1 WAddr_Ack_0 Write_Address_19 Write_Address_18 Write_Address_17 Write_Address_16 Write_Address_15 Write_Address_14 Write_Address_13 Write_Address_12 Write_Address_11 Write_Address_10 Write_Address_9 Write_Address_8 Write_Address_7 Write_Address_6 Write_Address_5 Write_Address_4 Write_Address_3 Write_Address_2 Write_Address_1 Write_Address_0 Write_1 Write_0 Write_Ack) _sub184
ends _sub185

// 16nm/TH33/schematic
//system verilogNetlist schematic cmos.sch cmos_sch veriloga ahdl
subckt TH33 A B C Y
    M19 (net13 A 0 0) nfet w=80n l=16n m=1
    M18 (net13 B 0 0) nfet w=80n l=16n m=1
    M17 (net13 C 0 0) nfet w=80n l=16n m=1
    M15 (Y net44 0 0) nfet w=40n l=16n m=1
    M14 (net42 A 0 0) nfet w=120n l=16n m=1
    M13 (net43 B net42 0) nfet w=120n l=16n m=1
    M12 (net44 C net43 0) nfet w=120n l=16n m=1
    M10 (net44 Y net13 0) nfet w=80n l=16n m=1
    M9 (Y net44 vdd! vdd!) pfet w=80n l=16n m=1
    M8 (net44 Y net15 vdd!) pfet w=160n l=16n m=1
    M6 (net15 C vdd! vdd!) pfet w=160n l=16n m=1
    M5 (net15 B vdd! vdd!) pfet w=160n l=16n m=1
    M4 (net15 A vdd! vdd!) pfet w=160n l=16n m=1
    M2 (net44 C net46 vdd!) pfet w=240n l=16n m=1
    M1 (net46 B net47 vdd!) pfet w=240n l=16n m=1
    M0 (net47 A vdd! vdd!) pfet w=240n l=16n m=1
ends TH33

// 16nm/6T_1of4Split4/schematic
//system verilogNetlist schematic cmos.sch cmos_sch veriloga ahdl
subckt _sub186 a_3 a_2 a_1 a_0 a_ack ack asel b_3 b_2 b_1 b_0 b_ack bsel c_3 c_2 c_1 c_0 c_ack csel d_3 d_2 d_1 d_0 d_ack dsel in_3 in_2 in_1 in_0
    I23 (c_3 a_3 d_3 b_3 net69) nor4_1x
    I22 (c_2 a_2 d_2 b_2 net68) nor4_1x
    I21 (c_1 a_1 d_1 b_1 net67) nor4_1x
    I20 (d_0 a_0 c_0 b_0 net66) nor4_1x
    I24 (net69 net68 net67 net66 ack) nand4_1x
    I19 (in_0 csel c_ack c_0) TH33
    I18 (in_1 csel c_ack c_1) TH33
    I17 (in_2 csel c_ack c_2) TH33
    I16 (in_3 csel c_ack c_3) TH33
    I15 (in_0 dsel d_ack d_0) TH33
    I14 (in_1 dsel d_ack d_1) TH33
    I13 (in_2 dsel d_ack d_2) TH33
    I12 (in_3 dsel d_ack d_3) TH33
    I0 (in_0 asel a_ack a_0) TH33
    I1 (in_1 asel a_ack a_1) TH33
    I2 (in_2 asel a_ack a_2) TH33
    I3 (in_3 asel a_ack a_3) TH33
    I7 (in_0 bsel b_ack b_0) TH33
    I6 (in_1 bsel b_ack b_1) TH33
    I5 (in_2 bsel b_ack b_2) TH33
    I4 (in_3 bsel b_ack b_3) TH33
ends _sub186

// 16nm/6T_4of16Split4/schematic
//system verilogNetlist schematic cmos.sch cmos_sch veriloga ahdl
subckt _sub187 A1_1of4_3 A1_1of4_2 A1_1of4_1 A1_1of4_0 A2_1of4_3 A2_1of4_2 A2_1of4_1 A2_1of4_0 A3_1of4_3 A3_1of4_2 A3_1of4_1 A3_1of4_0 A4_1of4_3 A4_1of4_2 A4_1of4_1 A4_1of4_0 A_Ack_3 A_Ack_2 A_Ack_1 A_Ack_0 Ack_3 Ack_2 Ack_1 Ack_0 Asel B1_1of4_3 B1_1of4_2 B1_1of4_1 B1_1of4_0 B2_1of4_3 B2_1of4_2 B2_1of4_1 B2_1of4_0 B3_1of4_3 B3_1of4_2 B3_1of4_1 B3_1of4_0 B4_1of4_3 B4_1of4_2 B4_1of4_1 B4_1of4_0 B_Ack_3 B_Ack_2 B_Ack_1 B_Ack_0 Bsel C1_1of4_3 C1_1of4_2 C1_1of4_1 C1_1of4_0 C2_1of4_3 C2_1of4_2 C2_1of4_1 C2_1of4_0 C3_1of4_3 C3_1of4_2 C3_1of4_1 C3_1of4_0 C4_1of4_3 C4_1of4_2 C4_1of4_1 C4_1of4_0 C_Ack_3 C_Ack_2 C_Ack_1 C_Ack_0 Csel D1_1of4_3 D1_1of4_2 D1_1of4_1 D1_1of4_0 D2_1of4_3 D2_1of4_2 D2_1of4_1 D2_1of4_0 D3_1of4_3 D3_1of4_2 D3_1of4_1 D3_1of4_0 D4_1of4_3 D4_1of4_2 D4_1of4_1 D4_1of4_0 D_Ack_3 D_Ack_2 D_Ack_1 D_Ack_0 Dsel I1_1of4_3 I1_1of4_2 I1_1of4_1 I1_1of4_0 I2_1of4_3 I2_1of4_2 I2_1of4_1 I2_1of4_0 I3_1of4_3 I3_1of4_2 I3_1of4_1 I3_1of4_0 I4_1of4_3 I4_1of4_2 I4_1of4_1 I4_1of4_0
    I15 (A1_1of4_3 A1_1of4_2 A1_1of4_1 A1_1of4_0 A_Ack_0 Ack_0 Asel B1_1of4_3 B1_1of4_2 B1_1of4_1 B1_1of4_0 B_Ack_0 Bsel C1_1of4_3 C1_1of4_2 C1_1of4_1 C1_1of4_0 C_Ack_0 Csel D1_1of4_3 D1_1of4_2 D1_1of4_1 D1_1of4_0 D_Ack_0 Dsel I1_1of4_3 I1_1of4_2 I1_1of4_1 I1_1of4_0) _sub186
    I14 (A2_1of4_3 A2_1of4_2 A2_1of4_1 A2_1of4_0 A_Ack_1 Ack_1 Asel B2_1of4_3 B2_1of4_2 B2_1of4_1 B2_1of4_0 B_Ack_1 Bsel C2_1of4_3 C2_1of4_2 C2_1of4_1 C2_1of4_0 C_Ack_1 Csel D2_1of4_3 D2_1of4_2 D2_1of4_1 D2_1of4_0 D_Ack_1 Dsel I2_1of4_3 I2_1of4_2 I2_1of4_1 I2_1of4_0) _sub186
    I13 (A4_1of4_3 A4_1of4_2 A4_1of4_1 A4_1of4_0 A_Ack_3 Ack_3 Asel B4_1of4_3 B4_1of4_2 B4_1of4_1 B4_1of4_0 B_Ack_3 Bsel C4_1of4_3 C4_1of4_2 C4_1of4_1 C4_1of4_0 C_Ack_3 Csel D4_1of4_3 D4_1of4_2 D4_1of4_1 D4_1of4_0 D_Ack_3 Dsel I4_1of4_3 I4_1of4_2 I4_1of4_1 I4_1of4_0) _sub186
    I12 (A3_1of4_3 A3_1of4_2 A3_1of4_1 A3_1of4_0 A_Ack_2 Ack_2 Asel B3_1of4_3 B3_1of4_2 B3_1of4_1 B3_1of4_0 B_Ack_2 Bsel C3_1of4_3 C3_1of4_2 C3_1of4_1 C3_1of4_0 C_Ack_2 Csel D3_1of4_3 D3_1of4_2 D3_1of4_1 D3_1of4_0 D_Ack_2 Dsel I3_1of4_3 I3_1of4_2 I3_1of4_1 I3_1of4_0) _sub186
ends _sub187

// 16nm/6T_1of2Split4/schematic
//system verilogNetlist schematic cmos.sch cmos_sch veriloga ahdl
subckt _sub188 a_1 a_0 a_ack ack asel b_1 b_0 b_ack bsel c_1 c_0 c_ack csel d_1 d_0 d_ack dsel in_1 in_0
    I21 (d_1 a_1 c_1 b_1 net55) nor4_1x
    I20 (d_0 a_0 c_0 b_0 net54) nor4_1x
    I19 (in_0 csel c_ack c_0) TH33
    I18 (in_1 csel c_ack c_1) TH33
    I15 (in_0 dsel d_ack d_0) TH33
    I14 (in_1 dsel d_ack d_1) TH33
    I0 (in_0 asel a_ack a_0) TH33
    I1 (in_1 asel a_ack a_1) TH33
    I7 (in_0 bsel b_ack b_0) TH33
    I6 (in_1 bsel b_ack b_1) TH33
    I24 (net55 net54 ack) nand_1x
ends _sub188

// 16nm/6T_AddressSplit4/schematic
//system verilogNetlist schematic cmos.sch cmos_sch veriloga ahdl
subckt _sub189 A_19 A_18 A_17 A_16 A_15 A_14 A_13 A_12 A_11 A_10 A_9 A_8 A_7 A_6 A_5 A_4 A_3 A_2 A_1 A_0 Ack_4 Ack_3 Ack_2 Ack_1 Ack_0 Asel Bk0_Ack_4 Bk0_Ack_3 Bk0_Ack_2 Bk0_Ack_1 Bk0_Ack_0 Bk0_Addr_19 Bk0_Addr_18 Bk0_Addr_17 Bk0_Addr_16 Bk0_Addr_15 Bk0_Addr_14 Bk0_Addr_13 Bk0_Addr_12 Bk0_Addr_11 Bk0_Addr_10 Bk0_Addr_9 Bk0_Addr_8 Bk0_Addr_7 Bk0_Addr_6 Bk0_Addr_5 Bk0_Addr_4 Bk0_Addr_3 Bk0_Addr_2 Bk0_Addr_1 Bk0_Addr_0 Bk0_RW_1 Bk0_RW_0 Bk0_RWAck Bk1_Ack_4 Bk1_Ack_3 Bk1_Ack_2 Bk1_Ack_1 Bk1_Ack_0 Bk1_Addr_19 Bk1_Addr_18 Bk1_Addr_17 Bk1_Addr_16 Bk1_Addr_15 Bk1_Addr_14 Bk1_Addr_13 Bk1_Addr_12 Bk1_Addr_11 Bk1_Addr_10 Bk1_Addr_9 Bk1_Addr_8 Bk1_Addr_7 Bk1_Addr_6 Bk1_Addr_5 Bk1_Addr_4 Bk1_Addr_3 Bk1_Addr_2 Bk1_Addr_1 Bk1_Addr_0 Bk1_RW_1 Bk1_RW_0 Bk1_RWAck Bk2_Ack_4 Bk2_Ack_3 Bk2_Ack_2 Bk2_Ack_1 Bk2_Ack_0 Bk2_Addr_19 Bk2_Addr_18 Bk2_Addr_17 Bk2_Addr_16 Bk2_Addr_15 Bk2_Addr_14 Bk2_Addr_13 Bk2_Addr_12 Bk2_Addr_11 Bk2_Addr_10 Bk2_Addr_9 Bk2_Addr_8 Bk2_Addr_7 Bk2_Addr_6 Bk2_Addr_5 Bk2_Addr_4 Bk2_Addr_3 Bk2_Addr_2 Bk2_Addr_1 Bk2_Addr_0 Bk2_RW_1 Bk2_RW_0 Bk2_RWAck Bk3_Ack_4 Bk3_Ack_3 Bk3_Ack_2 Bk3_Ack_1 Bk3_Ack_0 Bk3_Addr_19 Bk3_Addr_18 Bk3_Addr_17 Bk3_Addr_16 Bk3_Addr_15 Bk3_Addr_14 Bk3_Addr_13 Bk3_Addr_12 Bk3_Addr_11 Bk3_Addr_10 Bk3_Addr_9 Bk3_Addr_8 Bk3_Addr_7 Bk3_Addr_6 Bk3_Addr_5 Bk3_Addr_4 Bk3_Addr_3 Bk3_Addr_2 Bk3_Addr_1 Bk3_Addr_0 Bk3_RW_1 Bk3_RW_0 Bk3_RWAck Bsel Csel Dsel RW_1 RW_0 RW_Ack
    I0 (Bk0_Addr_3 Bk0_Addr_2 Bk0_Addr_1 Bk0_Addr_0 Bk0_Addr_7 Bk0_Addr_6 Bk0_Addr_5 Bk0_Addr_4 Bk0_Addr_11 Bk0_Addr_10 Bk0_Addr_9 Bk0_Addr_8 Bk0_Addr_15 Bk0_Addr_14 Bk0_Addr_13 Bk0_Addr_12 Bk0_Ack_3 Bk0_Ack_2 Bk0_Ack_1 Bk0_Ack_0 Ack_3 Ack_2 Ack_1 Ack_0 Asel Bk1_Addr_3 Bk1_Addr_2 Bk1_Addr_1 Bk1_Addr_0 Bk1_Addr_7 Bk1_Addr_6 Bk1_Addr_5 Bk1_Addr_4 Bk1_Addr_11 Bk1_Addr_10 Bk1_Addr_9 Bk1_Addr_8 Bk1_Addr_15 Bk1_Addr_14 Bk1_Addr_13 Bk1_Addr_12 Bk1_Ack_3 Bk1_Ack_2 Bk1_Ack_1 Bk1_Ack_0 Bsel Bk2_Addr_3 Bk2_Addr_2 Bk2_Addr_1 Bk2_Addr_0 Bk2_Addr_7 Bk2_Addr_6 Bk2_Addr_5 Bk2_Addr_4 Bk2_Addr_11 Bk2_Addr_10 Bk2_Addr_9 Bk2_Addr_8 Bk2_Addr_15 Bk2_Addr_14 Bk2_Addr_13 Bk2_Addr_12 Bk2_Ack_3 Bk2_Ack_2 Bk2_Ack_1 Bk2_Ack_0 Csel Bk3_Addr_3 Bk3_Addr_2 Bk3_Addr_1 Bk3_Addr_0 Bk3_Addr_7 Bk3_Addr_6 Bk3_Addr_5 Bk3_Addr_4 Bk3_Addr_11 Bk3_Addr_10 Bk3_Addr_9 Bk3_Addr_8 Bk3_Addr_15 Bk3_Addr_14 Bk3_Addr_13 Bk3_Addr_12 Bk3_Ack_3 Bk3_Ack_2 Bk3_Ack_1 Bk3_Ack_0 Dsel A_3 A_2 A_1 A_0 A_7 A_6 A_5 A_4 A_11 A_10 A_9 A_8 A_15 A_14 A_13 A_12) _sub187
    I1 (Bk0_Addr_19 Bk0_Addr_18 Bk0_Addr_17 Bk0_Addr_16 Bk0_Ack_4 Ack_4 Asel Bk1_Addr_19 Bk1_Addr_18 Bk1_Addr_17 Bk1_Addr_16 Bk1_Ack_4 Bsel Bk2_Addr_19 Bk2_Addr_18 Bk2_Addr_17 Bk2_Addr_16 Bk2_Ack_4 Csel Bk3_Addr_19 Bk3_Addr_18 Bk3_Addr_17 Bk3_Addr_16 Bk3_Ack_4 Dsel A_19 A_18 A_17 A_16) _sub186
    I2 (Bk0_RW_1 Bk0_RW_0 Bk0_RWAck RW_Ack Asel Bk1_RW_1 Bk1_RW_0 Bk1_RWAck Bsel Bk2_RW_1 Bk2_RW_0 Bk2_RWAck Csel Bk3_RW_1 Bk3_RW_0 Bk3_RWAck Dsel RW_1 RW_0) _sub188
ends _sub189

// 16nm/6T_8of32Split4/schematic
//system verilogNetlist schematic cmos.sch cmos_sch veriloga ahdl
subckt _sub190 A_8of32_31 A_8of32_30 A_8of32_29 A_8of32_28 A_8of32_27 A_8of32_26 A_8of32_25 A_8of32_24 A_8of32_23 A_8of32_22 A_8of32_21 A_8of32_20 A_8of32_19 A_8of32_18 A_8of32_17 A_8of32_16 A_8of32_15 A_8of32_14 A_8of32_13 A_8of32_12 A_8of32_11 A_8of32_10 A_8of32_9 A_8of32_8 A_8of32_7 A_8of32_6 A_8of32_5 A_8of32_4 A_8of32_3 A_8of32_2 A_8of32_1 A_8of32_0 A_Ack_7 A_Ack_6 A_Ack_5 A_Ack_4 A_Ack_3 A_Ack_2 A_Ack_1 A_Ack_0 Ack_7 Ack_6 Ack_5 Ack_4 Ack_3 Ack_2 Ack_1 Ack_0 Asel B_8of32_31 B_8of32_30 B_8of32_29 B_8of32_28 B_8of32_27 B_8of32_26 B_8of32_25 B_8of32_24 B_8of32_23 B_8of32_22 B_8of32_21 B_8of32_20 B_8of32_19 B_8of32_18 B_8of32_17 B_8of32_16 B_8of32_15 B_8of32_14 B_8of32_13 B_8of32_12 B_8of32_11 B_8of32_10 B_8of32_9 B_8of32_8 B_8of32_7 B_8of32_6 B_8of32_5 B_8of32_4 B_8of32_3 B_8of32_2 B_8of32_1 B_8of32_0 B_Ack_7 B_Ack_6 B_Ack_5 B_Ack_4 B_Ack_3 B_Ack_2 B_Ack_1 B_Ack_0 Bsel C_8of32_31 C_8of32_30 C_8of32_29 C_8of32_28 C_8of32_27 C_8of32_26 C_8of32_25 C_8of32_24 C_8of32_23 C_8of32_22 C_8of32_21 C_8of32_20 C_8of32_19 C_8of32_18 C_8of32_17 C_8of32_16 C_8of32_15 C_8of32_14 C_8of32_13 C_8of32_12 C_8of32_11 C_8of32_10 C_8of32_9 C_8of32_8 C_8of32_7 C_8of32_6 C_8of32_5 C_8of32_4 C_8of32_3 C_8of32_2 C_8of32_1 C_8of32_0 C_Ack_7 C_Ack_6 C_Ack_5 C_Ack_4 C_Ack_3 C_Ack_2 C_Ack_1 C_Ack_0 Csel D_8of32_31 D_8of32_30 D_8of32_29 D_8of32_28 D_8of32_27 D_8of32_26 D_8of32_25 D_8of32_24 D_8of32_23 D_8of32_22 D_8of32_21 D_8of32_20 D_8of32_19 D_8of32_18 D_8of32_17 D_8of32_16 D_8of32_15 D_8of32_14 D_8of32_13 D_8of32_12 D_8of32_11 D_8of32_10 D_8of32_9 D_8of32_8 D_8of32_7 D_8of32_6 D_8of32_5 D_8of32_4 D_8of32_3 D_8of32_2 D_8of32_1 D_8of32_0 D_Ack_7 D_Ack_6 D_Ack_5 D_Ack_4 D_Ack_3 D_Ack_2 D_Ack_1 D_Ack_0 Dsel I1_1of4_3 I1_1of4_2 I1_1of4_1 I1_1of4_0 I2_1of4_3 I2_1of4_2 I2_1of4_1 I2_1of4_0 I3_1of4_3 I3_1of4_2 I3_1of4_1 I3_1of4_0 I4_1of4_3 I4_1of4_2 I4_1of4_1 I4_1of4_0 I5_1of4_3 I5_1of4_2 I5_1of4_1 I5_1of4_0 I6_1of4_3 I6_1of4_2 I6_1of4_1 I6_1of4_0 I7_1of4_3 I7_1of4_2 I7_1of4_1 I7_1of4_0 I8_1of4_3 I8_1of4_2 I8_1of4_1 I8_1of4_0
    I2 (A_8of32_19 A_8of32_18 A_8of32_17 A_8of32_16 A_8of32_23 A_8of32_22 A_8of32_21 A_8of32_20 A_8of32_27 A_8of32_26 A_8of32_25 A_8of32_24 A_8of32_31 A_8of32_30 A_8of32_29 A_8of32_28 A_Ack_7 A_Ack_6 A_Ack_5 A_Ack_4 Ack_7 Ack_6 Ack_5 Ack_4 Asel B_8of32_19 B_8of32_18 B_8of32_17 B_8of32_16 B_8of32_23 B_8of32_22 B_8of32_21 B_8of32_20 B_8of32_27 B_8of32_26 B_8of32_25 B_8of32_24 B_8of32_31 B_8of32_30 B_8of32_29 B_8of32_28 B_Ack_7 B_Ack_6 B_Ack_5 B_Ack_4 Bsel C_8of32_19 C_8of32_18 C_8of32_17 C_8of32_16 C_8of32_23 C_8of32_22 C_8of32_21 C_8of32_20 C_8of32_27 C_8of32_26 C_8of32_25 C_8of32_24 C_8of32_31 C_8of32_30 C_8of32_29 C_8of32_28 C_Ack_7 C_Ack_6 C_Ack_5 C_Ack_4 Csel D_8of32_19 D_8of32_18 D_8of32_17 D_8of32_16 D_8of32_23 D_8of32_22 D_8of32_21 D_8of32_20 D_8of32_27 D_8of32_26 D_8of32_25 D_8of32_24 D_8of32_31 D_8of32_30 D_8of32_29 D_8of32_28 D_Ack_7 D_Ack_6 D_Ack_5 D_Ack_4 Dsel I5_1of4_3 I5_1of4_2 I5_1of4_1 I5_1of4_0 I6_1of4_3 I6_1of4_2 I6_1of4_1 I6_1of4_0 I7_1of4_3 I7_1of4_2 I7_1of4_1 I7_1of4_0 I8_1of4_3 I8_1of4_2 I8_1of4_1 I8_1of4_0) _sub187
    I0 (A_8of32_3 A_8of32_2 A_8of32_1 A_8of32_0 A_8of32_7 A_8of32_6 A_8of32_5 A_8of32_4 A_8of32_11 A_8of32_10 A_8of32_9 A_8of32_8 A_8of32_15 A_8of32_14 A_8of32_13 A_8of32_12 A_Ack_3 A_Ack_2 A_Ack_1 A_Ack_0 Ack_3 Ack_2 Ack_1 Ack_0 Asel B_8of32_3 B_8of32_2 B_8of32_1 B_8of32_0 B_8of32_7 B_8of32_6 B_8of32_5 B_8of32_4 B_8of32_11 B_8of32_10 B_8of32_9 B_8of32_8 B_8of32_15 B_8of32_14 B_8of32_13 B_8of32_12 B_Ack_3 B_Ack_2 B_Ack_1 B_Ack_0 Bsel C_8of32_3 C_8of32_2 C_8of32_1 C_8of32_0 C_8of32_7 C_8of32_6 C_8of32_5 C_8of32_4 C_8of32_11 C_8of32_10 C_8of32_9 C_8of32_8 C_8of32_15 C_8of32_14 C_8of32_13 C_8of32_12 C_Ack_3 C_Ack_2 C_Ack_1 C_Ack_0 Csel D_8of32_3 D_8of32_2 D_8of32_1 D_8of32_0 D_8of32_7 D_8of32_6 D_8of32_5 D_8of32_4 D_8of32_11 D_8of32_10 D_8of32_9 D_8of32_8 D_8of32_15 D_8of32_14 D_8of32_13 D_8of32_12 D_Ack_3 D_Ack_2 D_Ack_1 D_Ack_0 Dsel I1_1of4_3 I1_1of4_2 I1_1of4_1 I1_1of4_0 I2_1of4_3 I2_1of4_2 I2_1of4_1 I2_1of4_0 I3_1of4_3 I3_1of4_2 I3_1of4_1 I3_1of4_0 I4_1of4_3 I4_1of4_2 I4_1of4_1 I4_1of4_0) _sub187
ends _sub190

// 16nm/6T_1of4Merge4/schematic
//system verilogNetlist schematic cmos.sch cmos_sch veriloga ahdl
subckt _sub191 a_3 a_2 a_1 a_0 a_ack ack asel b_3 b_2 b_1 b_0 b_ack bsel c_3 c_2 c_1 c_0 c_ack csel d_3 d_2 d_1 d_0 d_ack dsel out_3 out_2 out_1 out_0
    I31 (net039 net035 net031 net027 d_ack) nand4_1x
    I26 (net030 net034 net038 net042 a_ack) nand4_1x
    I27 (net030 net26 net31 net039 net42) nand4_1x
    I28 (net034 net28 net29 net035 net41) nand4_1x
    I29 (net038 net30 net27 net031 net40) nand4_1x
    I30 (net042 net32 net25 net027 net39) nand4_1x
    I13 (net31 net29 net27 net25 c_ack) nand4_1x
    I12 (net26 net28 net30 net32 b_ack) nand4_1x
    I11 (net42 ack out_0) TH22
    I10 (net41 ack out_1) TH22
    I9 (net40 ack out_2) TH22
    I8 (net39 ack out_3) TH22
    I35 (d_0 dsel net21 net039) _sub180
    I34 (d_1 dsel net22 net035) _sub180
    I33 (d_2 dsel net23 net031) _sub180
    I32 (d_3 dsel net24 net027) _sub180
    I25 (a_0 asel net21 net030) _sub180
    I24 (a_1 asel net22 net034) _sub180
    I23 (a_2 asel net23 net038) _sub180
    I22 (a_3 asel net24 net042) _sub180
    I7 (c_0 csel net21 net31) _sub180
    I6 (c_1 csel net22 net29) _sub180
    I5 (c_2 csel net23 net27) _sub180
    I4 (c_3 csel net24 net25) _sub180
    I3 (b_3 bsel net24 net32) _sub180
    I2 (b_2 bsel net23 net30) _sub180
    I1 (b_1 bsel net22 net28) _sub180
    I0 (b_0 bsel net21 net26) _sub180
    I21 (out_0 net21) inv_1x
    I20 (out_1 net22) inv_1x
    I19 (out_2 net23) inv_1x
    I18 (out_3 net24) inv_1x
ends _sub191

// 16nm/6T_4of16Merge4/schematic
//system verilogNetlist schematic cmos.sch cmos_sch veriloga ahdl
subckt _sub192 A1_1of4_3 A1_1of4_2 A1_1of4_1 A1_1of4_0 A2_1of4_3 A2_1of4_2 A2_1of4_1 A2_1of4_0 A3_1of4_3 A3_1of4_2 A3_1of4_1 A3_1of4_0 A4_1of4_3 A4_1of4_2 A4_1of4_1 A4_1of4_0 A_Ack_3 A_Ack_2 A_Ack_1 A_Ack_0 Asel B1_1of4_3 B1_1of4_2 B1_1of4_1 B1_1of4_0 B2_1of4_3 B2_1of4_2 B2_1of4_1 B2_1of4_0 B3_1of4_3 B3_1of4_2 B3_1of4_1 B3_1of4_0 B4_1of4_3 B4_1of4_2 B4_1of4_1 B4_1of4_0 B_Ack_3 B_Ack_2 B_Ack_1 B_Ack_0 Bsel C1_1of4_3 C1_1of4_2 C1_1of4_1 C1_1of4_0 C2_1of4_3 C2_1of4_2 C2_1of4_1 C2_1of4_0 C3_1of4_3 C3_1of4_2 C3_1of4_1 C3_1of4_0 C4_1of4_3 C4_1of4_2 C4_1of4_1 C4_1of4_0 C_Ack_3 C_Ack_2 C_Ack_1 C_Ack_0 Ack_3 Ack_2 Ack_1 Ack_0 Csel D1_1of4_3 D1_1of4_2 D1_1of4_1 D1_1of4_0 D2_1of4_3 D2_1of4_2 D2_1of4_1 D2_1of4_0 D3_1of4_3 D3_1of4_2 D3_1of4_1 D3_1of4_0 D4_1of4_3 D4_1of4_2 D4_1of4_1 D4_1of4_0 D_Ack_3 D_Ack_2 D_Ack_1 D_Ack_0 Dsel Out1_1of4_3 Out1_1of4_2 Out1_1of4_1 Out1_1of4_0 Out2_1of4_3 Out2_1of4_2 Out2_1of4_1 Out2_1of4_0 Out3_1of4_3 Out3_1of4_2 Out3_1of4_1 Out3_1of4_0 Out4_1of4_3 Out4_1of4_2 Out4_1of4_1 Out4_1of4_0
    I25 (A4_1of4_3 A4_1of4_2 A4_1of4_1 A4_1of4_0 A_Ack_3 Ack_3 Asel B4_1of4_3 B4_1of4_2 B4_1of4_1 B4_1of4_0 B_Ack_3 Bsel C4_1of4_3 C4_1of4_2 C4_1of4_1 C4_1of4_0 C_Ack_3 Csel D4_1of4_3 D4_1of4_2 D4_1of4_1 D4_1of4_0 D_Ack_3 Dsel Out4_1of4_3 Out4_1of4_2 Out4_1of4_1 Out4_1of4_0) _sub191
    I24 (A3_1of4_3 A3_1of4_2 A3_1of4_1 A3_1of4_0 A_Ack_2 Ack_2 Asel B3_1of4_3 B3_1of4_2 B3_1of4_1 B3_1of4_0 B_Ack_2 Bsel C3_1of4_3 C3_1of4_2 C3_1of4_1 C3_1of4_0 C_Ack_2 Csel D3_1of4_3 D3_1of4_2 D3_1of4_1 D3_1of4_0 D_Ack_2 Dsel Out3_1of4_3 Out3_1of4_2 Out3_1of4_1 Out3_1of4_0) _sub191
    I23 (A2_1of4_3 A2_1of4_2 A2_1of4_1 A2_1of4_0 A_Ack_1 Ack_1 Asel B2_1of4_3 B2_1of4_2 B2_1of4_1 B2_1of4_0 B_Ack_1 Bsel C2_1of4_3 C2_1of4_2 C2_1of4_1 C2_1of4_0 C_Ack_1 Csel D2_1of4_3 D2_1of4_2 D2_1of4_1 D2_1of4_0 D_Ack_1 Dsel Out2_1of4_3 Out2_1of4_2 Out2_1of4_1 Out2_1of4_0) _sub191
    I22 (A1_1of4_3 A1_1of4_2 A1_1of4_1 A1_1of4_0 A_Ack_0 Ack_0 Asel B1_1of4_3 B1_1of4_2 B1_1of4_1 B1_1of4_0 B_Ack_0 Bsel C1_1of4_3 C1_1of4_2 C1_1of4_1 C1_1of4_0 C_Ack_0 Csel D1_1of4_3 D1_1of4_2 D1_1of4_1 D1_1of4_0 D_Ack_0 Dsel Out1_1of4_3 Out1_1of4_2 Out1_1of4_1 Out1_1of4_0) _sub191
ends _sub192

// 16nm/6T_8of32Merge4/schematic
//system verilogNetlist schematic cmos.sch cmos_sch veriloga ahdl
subckt _sub193 A_31 A_30 A_29 A_28 A_27 A_26 A_25 A_24 A_23 A_22 A_21 A_20 A_19 A_18 A_17 A_16 A_15 A_14 A_13 A_12 A_11 A_10 A_9 A_8 A_7 A_6 A_5 A_4 A_3 A_2 A_1 A_0 A_Ack_7 A_Ack_6 A_Ack_5 A_Ack_4 A_Ack_3 A_Ack_2 A_Ack_1 A_Ack_0 Ack_7 Ack_6 Ack_5 Ack_4 Ack_3 Ack_2 Ack_1 Ack_0 Asel B_31 B_30 B_29 B_28 B_27 B_26 B_25 B_24 B_23 B_22 B_21 B_20 B_19 B_18 B_17 B_16 B_15 B_14 B_13 B_12 B_11 B_10 B_9 B_8 B_7 B_6 B_5 B_4 B_3 B_2 B_1 B_0 B_Ack_7 B_Ack_6 B_Ack_5 B_Ack_4 B_Ack_3 B_Ack_2 B_Ack_1 B_Ack_0 Bsel C_31 C_30 C_29 C_28 C_27 C_26 C_25 C_24 C_23 C_22 C_21 C_20 C_19 C_18 C_17 C_16 C_15 C_14 C_13 C_12 C_11 C_10 C_9 C_8 C_7 C_6 C_5 C_4 C_3 C_2 C_1 C_0 C_Ack_7 C_Ack_6 C_Ack_5 C_Ack_4 C_Ack_3 C_Ack_2 C_Ack_1 C_Ack_0 Csel D_31 D_30 D_29 D_28 D_27 D_26 D_25 D_24 D_23 D_22 D_21 D_20 D_19 D_18 D_17 D_16 D_15 D_14 D_13 D_12 D_11 D_10 D_9 D_8 D_7 D_6 D_5 D_4 D_3 D_2 D_1 D_0 D_Ack_7 D_Ack_6 D_Ack_5 D_Ack_4 D_Ack_3 D_Ack_2 D_Ack_1 D_Ack_0 Dsel Out1_1of4_3 Out1_1of4_2 Out1_1of4_1 Out1_1of4_0 Out2_1of4_3 Out2_1of4_2 Out2_1of4_1 Out2_1of4_0 Out3_1of4_3 Out3_1of4_2 Out3_1of4_1 Out3_1of4_0 Out4_1of4_3 Out4_1of4_2 Out4_1of4_1 Out4_1of4_0 Out5_1of4_3 Out5_1of4_2 Out5_1of4_1 Out5_1of4_0 Out6_1of4_3 Out6_1of4_2 Out6_1of4_1 Out6_1of4_0 Out7_1of4_3 Out7_1of4_2 Out7_1of4_1 Out7_1of4_0 Out8_1of4_3 Out8_1of4_2 Out8_1of4_1 Out8_1of4_0
    I1 (A_19 A_18 A_17 A_16 A_23 A_22 A_21 A_20 A_27 A_26 A_25 A_24 A_31 A_30 A_29 A_28 A_Ack_7 A_Ack_6 A_Ack_5 A_Ack_4 Asel B_19 B_18 B_17 B_16 B_23 B_22 B_21 B_20 B_27 B_26 B_25 B_24 B_31 B_30 B_29 B_28 B_Ack_7 B_Ack_6 B_Ack_5 B_Ack_4 Bsel C_19 C_18 C_17 C_16 C_23 C_22 C_21 C_20 C_27 C_26 C_25 C_24 C_31 C_30 C_29 C_28 C_Ack_7 C_Ack_6 C_Ack_5 C_Ack_4 Ack_7 Ack_6 Ack_5 Ack_4 Csel D_19 D_18 D_17 D_16 D_23 D_22 D_21 D_20 D_27 D_26 D_25 D_24 D_31 D_30 D_29 D_28 D_Ack_7 D_Ack_6 D_Ack_5 D_Ack_4 Dsel Out5_1of4_3 Out5_1of4_2 Out5_1of4_1 Out5_1of4_0 Out6_1of4_3 Out6_1of4_2 Out6_1of4_1 Out6_1of4_0 Out7_1of4_3 Out7_1of4_2 Out7_1of4_1 Out7_1of4_0 Out8_1of4_3 Out8_1of4_2 Out8_1of4_1 Out8_1of4_0) _sub192
    I0 (A_3 A_2 A_1 A_0 A_7 A_6 A_5 A_4 A_11 A_10 A_9 A_8 A_15 A_14 A_13 A_12 A_Ack_3 A_Ack_2 A_Ack_1 A_Ack_0 Asel B_3 B_2 B_1 B_0 B_7 B_6 B_5 B_4 B_11 B_10 B_9 B_8 B_15 B_14 B_13 B_12 B_Ack_3 B_Ack_2 B_Ack_1 B_Ack_0 Bsel C_3 C_2 C_1 C_0 C_7 C_6 C_5 C_4 C_11 C_10 C_9 C_8 C_15 C_14 C_13 C_12 C_Ack_3 C_Ack_2 C_Ack_1 C_Ack_0 Ack_3 Ack_2 Ack_1 Ack_0 Csel D_3 D_2 D_1 D_0 D_7 D_6 D_5 D_4 D_11 D_10 D_9 D_8 D_15 D_14 D_13 D_12 D_Ack_3 D_Ack_2 D_Ack_1 D_Ack_0 Dsel Out1_1of4_3 Out1_1of4_2 Out1_1of4_1 Out1_1of4_0 Out2_1of4_3 Out2_1of4_2 Out2_1of4_1 Out2_1of4_0 Out3_1of4_3 Out3_1of4_2 Out3_1of4_1 Out3_1of4_0 Out4_1of4_3 Out4_1of4_2 Out4_1of4_1 Out4_1of4_0) _sub192
ends _sub193

// 16nm/6T_1of4Latch/schematic
//system verilogNetlist schematic cmos.sch cmos_sch veriloga ahdl
subckt _sub194 ack in_3 in_2 in_1 in_0 nina out_3 out_2 out_1 out_0
    I7 (nx_0 ack xo_0) TH22
    I6 (nx_1 ack xo_1) TH22
    I5 (nx_2 ack xo_2) TH22
    I4 (nx_3 ack xo_3) TH22
    I3 (in_3 nxa n_3) TH22
    I2 (in_2 nxa n_2) TH22
    I1 (in_1 nxa n_1) TH22
    I0 (in_0 nxa n_0) TH22
    I18 (xa nxa) inv_1x
    I17 (xo_0 out_0) inv_1x
    I16 (xo_1 out_1) inv_1x
    I15 (xo_2 out_2) inv_1x
    I14 (xo_3 out_3) inv_1x
    I11 (n_3 nx_3) inv_1x
    I10 (n_2 nx_2) inv_1x
    I9 (n_1 nx_1) inv_1x
    I8 (n_0 nx_0) inv_1x
    I12 (n_0 n_1 n_2 n_3 nina) nor4_1x
    I13 (xo_3 xo_2 xo_1 xo_0 xa) nand4_1x
ends _sub194

// 16nm/6T_4of16Latch/schematic
//system verilogNetlist schematic cmos.sch cmos_sch veriloga ahdl
subckt _sub195 Ack_3 Ack_2 Ack_1 Ack_0 In_4of16_15 In_4of16_14 In_4of16_13 In_4of16_12 In_4of16_11 In_4of16_10 In_4of16_9 In_4of16_8 In_4of16_7 In_4of16_6 In_4of16_5 In_4of16_4 In_4of16_3 In_4of16_2 In_4of16_1 In_4of16_0 In_Ack_3 In_Ack_2 In_Ack_1 In_Ack_0 Out_4of16_15 Out_4of16_14 Out_4of16_13 Out_4of16_12 Out_4of16_11 Out_4of16_10 Out_4of16_9 Out_4of16_8 Out_4of16_7 Out_4of16_6 Out_4of16_5 Out_4of16_4 Out_4of16_3 Out_4of16_2 Out_4of16_1 Out_4of16_0
    I3 (Ack_3 In_4of16_15 In_4of16_14 In_4of16_13 In_4of16_12 In_Ack_3 Out_4of16_15 Out_4of16_14 Out_4of16_13 Out_4of16_12) _sub194
    I2 (Ack_2 In_4of16_11 In_4of16_10 In_4of16_9 In_4of16_8 In_Ack_2 Out_4of16_11 Out_4of16_10 Out_4of16_9 Out_4of16_8) _sub194
    I1 (Ack_1 In_4of16_7 In_4of16_6 In_4of16_5 In_4of16_4 In_Ack_1 Out_4of16_7 Out_4of16_6 Out_4of16_5 Out_4of16_4) _sub194
    I0 (Ack_0 In_4of16_3 In_4of16_2 In_4of16_1 In_4of16_0 In_Ack_0 Out_4of16_3 Out_4of16_2 Out_4of16_1 Out_4of16_0) _sub194
ends _sub195

// 16nm/6T_8of32Latch/schematic
//system verilogNetlist schematic cmos.sch cmos_sch veriloga ahdl
subckt _sub196 Ack_7 Ack_6 Ack_5 Ack_4 Ack_3 Ack_2 Ack_1 Ack_0 In_4of16_3 In_4of16_2 In_4of16_1 In_4of16_0 In_4of16_7 In_4of16_6 In_4of16_5 In_4of16_4 In_4of16_11 In_4of16_10 In_4of16_9 In_4of16_8 In_4of16_15 In_4of16_14 In_4of16_13 In_4of16_12 In2_4of16_3 In2_4of16_2 In2_4of16_1 In2_4of16_0 In2_4of16_7 In2_4of16_6 In2_4of16_5 In2_4of16_4 In2_4of16_11 In2_4of16_10 In2_4of16_9 In2_4of16_8 In2_4of16_15 In2_4of16_14 In2_4of16_13 In2_4of16_12 In_Ack_7 In_Ack_6 In_Ack_5 In_Ack_4 In_Ack_3 In_Ack_2 In_Ack_1 In_Ack_0 Out1_1of4_3 Out1_1of4_2 Out1_1of4_1 Out1_1of4_0 Out1_1of4_7 Out1_1of4_6 Out1_1of4_5 Out1_1of4_4 Out1_1of4_11 Out1_1of4_10 Out1_1of4_9 Out1_1of4_8 Out1_1of4_15 Out1_1of4_14 Out1_1of4_13 Out1_1of4_12 Out2_1of4_3 Out2_1of4_2 Out2_1of4_1 Out2_1of4_0 Out2_1of4_7 Out2_1of4_6 Out2_1of4_5 Out2_1of4_4 Out2_1of4_11 Out2_1of4_10 Out2_1of4_9 Out2_1of4_8 Out2_1of4_15 Out2_1of4_14 Out2_1of4_13 Out2_1of4_12
    I1 (Ack_7 Ack_6 Ack_5 Ack_4 In2_4of16_15 In2_4of16_14 In2_4of16_13 In2_4of16_12 In2_4of16_11 In2_4of16_10 In2_4of16_9 In2_4of16_8 In2_4of16_7 In2_4of16_6 In2_4of16_5 In2_4of16_4 In2_4of16_3 In2_4of16_2 In2_4of16_1 In2_4of16_0 In_Ack_7 In_Ack_6 In_Ack_5 In_Ack_4 Out2_1of4_15 Out2_1of4_14 Out2_1of4_13 Out2_1of4_12 Out2_1of4_11 Out2_1of4_10 Out2_1of4_9 Out2_1of4_8 Out2_1of4_7 Out2_1of4_6 Out2_1of4_5 Out2_1of4_4 Out2_1of4_3 Out2_1of4_2 Out2_1of4_1 Out2_1of4_0) _sub195
    I0 (Ack_3 Ack_2 Ack_1 Ack_0 In_4of16_15 In_4of16_14 In_4of16_13 In_4of16_12 In_4of16_11 In_4of16_10 In_4of16_9 In_4of16_8 In_4of16_7 In_4of16_6 In_4of16_5 In_4of16_4 In_4of16_3 In_4of16_2 In_4of16_1 In_4of16_0 In_Ack_3 In_Ack_2 In_Ack_1 In_Ack_0 Out1_1of4_15 Out1_1of4_14 Out1_1of4_13 Out1_1of4_12 Out1_1of4_11 Out1_1of4_10 Out1_1of4_9 Out1_1of4_8 Out1_1of4_7 Out1_1of4_6 Out1_1of4_5 Out1_1of4_4 Out1_1of4_3 Out1_1of4_2 Out1_1of4_1 Out1_1of4_0) _sub195
ends _sub196

// 16nm/6T_1of2Latch/schematic
//system verilogNetlist schematic cmos.sch cmos_sch veriloga ahdl
subckt _sub197 ack in_1 in_0 nina out_1 out_0
    I7 (nx_0 ack xo_0) TH22
    I6 (nx_1 ack xo_1) TH22
    I1 (in_1 nxa n_1) TH22
    I0 (in_0 nxa n_0) TH22
    I18 (xa nxa) inv_1x
    I17 (xo_0 out_0) inv_1x
    I16 (xo_1 out_1) inv_1x
    I9 (n_1 nx_1) inv_1x
    I8 (n_0 nx_0) inv_1x
    I13 (xo_1 xo_0 xa) nand_1x
    I12 (n_0 n_1 nina) nor_1x
ends _sub197

// 16nm/6T_AddressLatch/schematic
//system verilogNetlist schematic cmos.sch cmos_sch veriloga ahdl
subckt _sub198 A_19 A_18 A_17 A_16 A_15 A_14 A_13 A_12 A_11 A_10 A_9 A_8 A_7 A_6 A_5 A_4 A_3 A_2 A_1 A_0 Ack_4 Ack_3 Ack_2 Ack_1 Ack_0 Banks_0 Banks_1 Banks_2 Banks_3 En In_6of24_23 In_6of24_22 In_6of24_21 In_6of24_20 In_6of24_19 In_6of24_18 In_6of24_17 In_6of24_16 In_6of24_15 In_6of24_14 In_6of24_13 In_6of24_12 In_6of24_11 In_6of24_10 In_6of24_9 In_6of24_8 In_6of24_7 In_6of24_6 In_6of24_5 In_6of24_4 In_6of24_3 In_6of24_2 In_6of24_1 In_6of24_0 In_Ack_5 In_Ack_4 In_Ack_3 In_Ack_2 In_Ack_1 In_Ack_0 RW_1 RW_0 RWAck RW_Ack RW_in_1 RW_in_0
    I0 (Ack_3 Ack_2 Ack_1 Ack_0 In_6of24_15 In_6of24_14 In_6of24_13 In_6of24_12 In_6of24_11 In_6of24_10 In_6of24_9 In_6of24_8 In_6of24_7 In_6of24_6 In_6of24_5 In_6of24_4 In_6of24_3 In_6of24_2 In_6of24_1 In_6of24_0 In_Ack_3 In_Ack_2 In_Ack_1 In_Ack_0 A_15 A_14 A_13 A_12 A_11 A_10 A_9 A_8 A_7 A_6 A_5 A_4 A_3 A_2 A_1 A_0) _sub195
    I3 (RWAck RW_in_1 RW_in_0 RW_Ack RW_1 RW_0) _sub197
    I4 (En In_6of24_23 In_6of24_22 In_6of24_21 In_6of24_20 In_Ack_5 Banks_3 Banks_2 Banks_1 Banks_0) _sub194
    I2 (Ack_4 In_6of24_19 In_6of24_18 In_6of24_17 In_6of24_16 In_Ack_4 A_19 A_18 A_17 A_16) _sub194
ends _sub198

// 16nm/Encode_4to2/schematic
//system verilogNetlist schematic cmos.sch cmos_sch veriloga ahdl
subckt Encode_4to2 En I_3 I_2 I_1 I_0 O_1 O_0
    I9 (En net5) inv_1x
    I14 (net5 net010 O_0) nor_1x
    I12 (net5 net011 O_1) nor_1x
    I11 (I_3 I_2 net011) nor_1x
    I13 (I_3 I_1 net010) nor_1x
ends Encode_4to2

// 16nm/6T_8K_MultiBank/schematic
//system verilogNetlist schematic cmos.sch cmos_sch veriloga ahdl
subckt _sub199 RData_15 RData_14 RData_13 RData_12 RData_11 RData_10 RData_9 RData_8 RData_7 RData_6 RData_5 RData_4 RData_3 RData_2 RData_1 RData_0 R_Address_11 R_Address_10 R_Address_9 R_Address_8 R_Address_7 R_Address_6 R_Address_5 R_Address_4 R_Address_3 R_Address_2 R_Address_1 R_Address_0 ReadAck Read_1 WData_15 WData_14 WData_13 WData_12 WData_11 WData_10 WData_9 WData_8 WData_7 WData_6 WData_5 WData_4 WData_3 WData_2 WData_1 WData_0 WDataAck_7 WDataAck_6 WDataAck_5 WDataAck_4 WDataAck_3 WDataAck_2 WDataAck_1 WDataAck_0 W_Address_11 W_Address_10 W_Address_9 W_Address_8 W_Address_7 W_Address_6 W_Address_5 W_Address_4 W_Address_3 W_Address_2 W_Address_1 W_Address_0 WriteAck Write_0
    I3 (net49_0 net49_1 net49_2 net49_3 net49_4 net45_0 net45_1 RdBank3Ack_7 RdBank3Ack_6 RdBank3Ack_5 RdBank3Ack_4 RdBank3Ack_3 RdBank3Ack_2 RdBank3Ack_1 RdBank3Ack_0 RdBank3_31 RdBank3_30 RdBank3_29 RdBank3_28 RdBank3_27 RdBank3_26 RdBank3_25 RdBank3_24 RdBank3_23 RdBank3_22 RdBank3_21 RdBank3_20 RdBank3_19 RdBank3_18 RdBank3_17 RdBank3_16 RdBank3_15 RdBank3_14 RdBank3_13 RdBank3_12 RdBank3_11 RdBank3_10 RdBank3_9 RdBank3_8 RdBank3_7 RdBank3_6 RdBank3_5 RdBank3_4 RdBank3_3 RdBank3_2 RdBank3_1 RdBank3_0 net17 net53_0 net53_1 net53_2 net53_3 net53_4 net53_5 net53_6 net53_7 net53_8 net53_9 net53_10 net53_11 net53_12 net53_13 net53_14 net53_15 net53_16 net53_17 net53_18 net53_19 net43_0 net43_1 net43_2 net43_3 net43_4 net44_0 net44_1 Bank3WAck_7 Bank3WAck_6 Bank3WAck_5 Bank3WAck_4 Bank3WAck_3 Bank3WAck_2 Bank3WAck_1 Bank3WAck_0 WdBank3_31 WdBank3_30 WdBank3_29 WdBank3_28 WdBank3_27 WdBank3_26 WdBank3_25 WdBank3_24 WdBank3_23 WdBank3_22 WdBank3_21 WdBank3_20 WdBank3_19 WdBank3_18 WdBank3_17 WdBank3_16 WdBank3_15 WdBank3_14 WdBank3_13 WdBank3_12 WdBank3_11 WdBank3_10 WdBank3_9 WdBank3_8 WdBank3_7 WdBank3_6 WdBank3_5 WdBank3_4 WdBank3_3 WdBank3_2 WdBank3_1 WdBank3_0 net16 net42_0 net42_1 net42_2 net42_3 net42_4 net42_5 net42_6 net42_7 net42_8 net42_9 net42_10 net42_11 net42_12 net42_13 net42_14 net42_15 net42_16 net42_17 net42_18 net42_19) _sub185
    I2 (net50_0 net50_1 net50_2 net50_3 net50_4 net46_0 net46_1 RdBank2Ack_7 RdBank2Ack_6 RdBank2Ack_5 RdBank2Ack_4 RdBank2Ack_3 RdBank2Ack_2 RdBank2Ack_1 RdBank2Ack_0 RdBank2_31 RdBank2_30 RdBank2_29 RdBank2_28 RdBank2_27 RdBank2_26 RdBank2_25 RdBank2_24 RdBank2_23 RdBank2_22 RdBank2_21 RdBank2_20 RdBank2_19 RdBank2_18 RdBank2_17 RdBank2_16 RdBank2_15 RdBank2_14 RdBank2_13 RdBank2_12 RdBank2_11 RdBank2_10 RdBank2_9 RdBank2_8 RdBank2_7 RdBank2_6 RdBank2_5 RdBank2_4 RdBank2_3 RdBank2_2 RdBank2_1 RdBank2_0 net18 net54_0 net54_1 net54_2 net54_3 net54_4 net54_5 net54_6 net54_7 net54_8 net54_9 net54_10 net54_11 net54_12 net54_13 net54_14 net54_15 net54_16 net54_17 net54_18 net54_19 net40_0 net40_1 net40_2 net40_3 net40_4 net41_0 net41_1 Bank2WAck_7 Bank2WAck_6 Bank2WAck_5 Bank2WAck_4 Bank2WAck_3 Bank2WAck_2 Bank2WAck_1 Bank2WAck_0 WdBank2_31 WdBank2_30 WdBank2_29 WdBank2_28 WdBank2_27 WdBank2_26 WdBank2_25 WdBank2_24 WdBank2_23 WdBank2_22 WdBank2_21 WdBank2_20 WdBank2_19 WdBank2_18 WdBank2_17 WdBank2_16 WdBank2_15 WdBank2_14 WdBank2_13 WdBank2_12 WdBank2_11 WdBank2_10 WdBank2_9 WdBank2_8 WdBank2_7 WdBank2_6 WdBank2_5 WdBank2_4 WdBank2_3 WdBank2_2 WdBank2_1 WdBank2_0 net12 net39_0 net39_1 net39_2 net39_3 net39_4 net39_5 net39_6 net39_7 net39_8 net39_9 net39_10 net39_11 net39_12 net39_13 net39_14 net39_15 net39_16 net39_17 net39_18 net39_19) _sub185
    I1 (net51_0 net51_1 net51_2 net51_3 net51_4 net47_0 net47_1 RdBank1Ack_7 RdBank1Ack_6 RdBank1Ack_5 RdBank1Ack_4 RdBank1Ack_3 RdBank1Ack_2 RdBank1Ack_1 RdBank1Ack_0 RdBank1_31 RdBank1_30 RdBank1_29 RdBank1_28 RdBank1_27 RdBank1_26 RdBank1_25 RdBank1_24 RdBank1_23 RdBank1_22 RdBank1_21 RdBank1_20 RdBank1_19 RdBank1_18 RdBank1_17 RdBank1_16 RdBank1_15 RdBank1_14 RdBank1_13 RdBank1_12 RdBank1_11 RdBank1_10 RdBank1_9 RdBank1_8 RdBank1_7 RdBank1_6 RdBank1_5 RdBank1_4 RdBank1_3 RdBank1_2 RdBank1_1 RdBank1_0 net19 net55_0 net55_1 net55_2 net55_3 net55_4 net55_5 net55_6 net55_7 net55_8 net55_9 net55_10 net55_11 net55_12 net55_13 net55_14 net55_15 net55_16 net55_17 net55_18 net55_19 net37_0 net37_1 net37_2 net37_3 net37_4 net38_0 net38_1 Bank1WAck_7 Bank1WAck_6 Bank1WAck_5 Bank1WAck_4 Bank1WAck_3 Bank1WAck_2 Bank1WAck_1 Bank1WAck_0 WdBank1_31 WdBank1_30 WdBank1_29 WdBank1_28 WdBank1_27 WdBank1_26 WdBank1_25 WdBank1_24 WdBank1_23 WdBank1_22 WdBank1_21 WdBank1_20 WdBank1_19 WdBank1_18 WdBank1_17 WdBank1_16 WdBank1_15 WdBank1_14 WdBank1_13 WdBank1_12 WdBank1_11 WdBank1_10 WdBank1_9 WdBank1_8 WdBank1_7 WdBank1_6 WdBank1_5 WdBank1_4 WdBank1_3 WdBank1_2 WdBank1_1 WdBank1_0 net8 net36_0 net36_1 net36_2 net36_3 net36_4 net36_5 net36_6 net36_7 net36_8 net36_9 net36_10 net36_11 net36_12 net36_13 net36_14 net36_15 net36_16 net36_17 net36_18 net36_19) _sub185
    I0 (net52_0 net52_1 net52_2 net52_3 net52_4 net48_0 net48_1 RdBank0Ack_7 RdBank0Ack_6 RdBank0Ack_5 RdBank0Ack_4 RdBank0Ack_3 RdBank0Ack_2 RdBank0Ack_1 RdBank0Ack_0 RdBank0_31 RdBank0_30 RdBank0_29 RdBank0_28 RdBank0_27 RdBank0_26 RdBank0_25 RdBank0_24 RdBank0_23 RdBank0_22 RdBank0_21 RdBank0_20 RdBank0_19 RdBank0_18 RdBank0_17 RdBank0_16 RdBank0_15 RdBank0_14 RdBank0_13 RdBank0_12 RdBank0_11 RdBank0_10 RdBank0_9 RdBank0_8 RdBank0_7 RdBank0_6 RdBank0_5 RdBank0_4 RdBank0_3 RdBank0_2 RdBank0_1 RdBank0_0 net20 net56_0 net56_1 net56_2 net56_3 net56_4 net56_5 net56_6 net56_7 net56_8 net56_9 net56_10 net56_11 net56_12 net56_13 net56_14 net56_15 net56_16 net56_17 net56_18 net56_19 net34_0 net34_1 net34_2 net34_3 net34_4 net35_0 net35_1 Bank0WAck_7 Bank0WAck_6 Bank0WAck_5 Bank0WAck_4 Bank0WAck_3 Bank0WAck_2 Bank0WAck_1 Bank0WAck_0 WdBank0_31 WdBank0_30 WdBank0_29 WdBank0_28 WdBank0_27 WdBank0_26 WdBank0_25 WdBank0_24 WdBank0_23 WdBank0_22 WdBank0_21 WdBank0_20 WdBank0_19 WdBank0_18 WdBank0_17 WdBank0_16 WdBank0_15 WdBank0_14 WdBank0_13 WdBank0_12 WdBank0_11 WdBank0_10 WdBank0_9 WdBank0_8 WdBank0_7 WdBank0_6 WdBank0_5 WdBank0_4 WdBank0_3 WdBank0_2 WdBank0_1 WdBank0_0 net4 net33_0 net33_1 net33_2 net33_3 net33_4 net33_5 net33_6 net33_7 net33_8 net33_9 net33_10 net33_11 net33_12 net33_13 net33_14 net33_15 net33_16 net33_17 net33_18 net33_19) _sub185
    I4 (net0135_0 net0135_1 net0135_2 net0135_3 net0135_4 net0135_5 net0135_6 net0135_7 net0135_8 net0135_9 net0135_10 net0135_11 net0135_12 net0135_13 net0135_14 net0135_15 net0135_16 net0135_17 net0135_18 net0135_19 net0137_0 net0137_1 net0137_2 net0137_3 net0137_4 net017 net34_0 net34_1 net34_2 net34_3 net34_4 net33_0 net33_1 net33_2 net33_3 net33_4 net33_5 net33_6 net33_7 net33_8 net33_9 net33_10 net33_11 net33_12 net33_13 net33_14 net33_15 net33_16 net33_17 net33_18 net33_19 net35_0 net35_1 net4 net37_0 net37_1 net37_2 net37_3 net37_4 net36_0 net36_1 net36_2 net36_3 net36_4 net36_5 net36_6 net36_7 net36_8 net36_9 net36_10 net36_11 net36_12 net36_13 net36_14 net36_15 net36_16 net36_17 net36_18 net36_19 net38_0 net38_1 net8 net40_0 net40_1 net40_2 net40_3 net40_4 net39_0 net39_1 net39_2 net39_3 net39_4 net39_5 net39_6 net39_7 net39_8 net39_9 net39_10 net39_11 net39_12 net39_13 net39_14 net39_15 net39_16 net39_17 net39_18 net39_19 net41_0 net41_1 net12 net43_0 net43_1 net43_2 net43_3 net43_4 net42_0 net42_1 net42_2 net42_3 net42_4 net42_5 net42_6 net42_7 net42_8 net42_9 net42_10 net42_11 net42_12 net42_13 net42_14 net42_15 net42_16 net42_17 net42_18 net42_19 net44_0 net44_1 net16 net018 net0205 net0201 net0136_0 net0136_1 net064) _sub189
    I5 (net0200_0 net0200_1 net0200_2 net0200_3 net0200_4 net0200_5 net0200_6 net0200_7 net0200_8 net0200_9 net0200_10 net0200_11 net0200_12 net0200_13 net0200_14 net0200_15 net0200_16 net0200_17 net0200_18 net0200_19 net0204_0 net0204_1 net0204_2 net0204_3 net0204_4 net019 net52_0 net52_1 net52_2 net52_3 net52_4 net56_0 net56_1 net56_2 net56_3 net56_4 net56_5 net56_6 net56_7 net56_8 net56_9 net56_10 net56_11 net56_12 net56_13 net56_14 net56_15 net56_16 net56_17 net56_18 net56_19 net48_0 net48_1 net20 net51_0 net51_1 net51_2 net51_3 net51_4 net55_0 net55_1 net55_2 net55_3 net55_4 net55_5 net55_6 net55_7 net55_8 net55_9 net55_10 net55_11 net55_12 net55_13 net55_14 net55_15 net55_16 net55_17 net55_18 net55_19 net47_0 net47_1 net19 net50_0 net50_1 net50_2 net50_3 net50_4 net54_0 net54_1 net54_2 net54_3 net54_4 net54_5 net54_6 net54_7 net54_8 net54_9 net54_10 net54_11 net54_12 net54_13 net54_14 net54_15 net54_16 net54_17 net54_18 net54_19 net46_0 net46_1 net18 net49_0 net49_1 net49_2 net49_3 net49_4 net53_0 net53_1 net53_2 net53_3 net53_4 net53_5 net53_6 net53_7 net53_8 net53_9 net53_10 net53_11 net53_12 net53_13 net53_14 net53_15 net53_16 net53_17 net53_18 net53_19 net45_0 net45_1 net17 net020 net021 net022 net0196_0 net0196_1 net060) _sub189
    I6 (WdBank0_31 WdBank0_30 WdBank0_29 WdBank0_28 WdBank0_27 WdBank0_26 WdBank0_25 WdBank0_24 WdBank0_23 WdBank0_22 WdBank0_21 WdBank0_20 WdBank0_19 WdBank0_18 WdBank0_17 WdBank0_16 WdBank0_15 WdBank0_14 WdBank0_13 WdBank0_12 WdBank0_11 WdBank0_10 WdBank0_9 WdBank0_8 WdBank0_7 WdBank0_6 WdBank0_5 WdBank0_4 WdBank0_3 WdBank0_2 WdBank0_1 WdBank0_0 Bank0WAck_7 Bank0WAck_6 Bank0WAck_5 Bank0WAck_4 Bank0WAck_3 Bank0WAck_2 Bank0WAck_1 Bank0WAck_0 WdAck_7 WdAck_6 WdAck_5 WdAck_4 WdAck_3 WdAck_2 WdAck_1 WdAck_0 net017 WdBank1_31 WdBank1_30 WdBank1_29 WdBank1_28 WdBank1_27 WdBank1_26 WdBank1_25 WdBank1_24 WdBank1_23 WdBank1_22 WdBank1_21 WdBank1_20 WdBank1_19 WdBank1_18 WdBank1_17 WdBank1_16 WdBank1_15 WdBank1_14 WdBank1_13 WdBank1_12 WdBank1_11 WdBank1_10 WdBank1_9 WdBank1_8 WdBank1_7 WdBank1_6 WdBank1_5 WdBank1_4 WdBank1_3 WdBank1_2 WdBank1_1 WdBank1_0 Bank1WAck_7 Bank1WAck_6 Bank1WAck_5 Bank1WAck_4 Bank1WAck_3 Bank1WAck_2 Bank1WAck_1 Bank1WAck_0 net018 WdBank2_31 WdBank2_30 WdBank2_29 WdBank2_28 WdBank2_27 WdBank2_26 WdBank2_25 WdBank2_24 WdBank2_23 WdBank2_22 WdBank2_21 WdBank2_20 WdBank2_19 WdBank2_18 WdBank2_17 WdBank2_16 WdBank2_15 WdBank2_14 WdBank2_13 WdBank2_12 WdBank2_11 WdBank2_10 WdBank2_9 WdBank2_8 WdBank2_7 WdBank2_6 WdBank2_5 WdBank2_4 WdBank2_3 WdBank2_2 WdBank2_1 WdBank2_0 Bank2WAck_7 Bank2WAck_6 Bank2WAck_5 Bank2WAck_4 Bank2WAck_3 Bank2WAck_2 Bank2WAck_1 Bank2WAck_0 net0205 WdBank3_31 WdBank3_30 WdBank3_29 WdBank3_28 WdBank3_27 WdBank3_26 WdBank3_25 WdBank3_24 WdBank3_23 WdBank3_22 WdBank3_21 WdBank3_20 WdBank3_19 WdBank3_18 WdBank3_17 WdBank3_16 WdBank3_15 WdBank3_14 WdBank3_13 WdBank3_12 WdBank3_11 WdBank3_10 WdBank3_9 WdBank3_8 WdBank3_7 WdBank3_6 WdBank3_5 WdBank3_4 WdBank3_3 WdBank3_2 WdBank3_1 WdBank3_0 Bank3WAck_7 Bank3WAck_6 Bank3WAck_5 Bank3WAck_4 Bank3WAck_3 Bank3WAck_2 Bank3WAck_1 Bank3WAck_0 net0201 Wd_3 Wd_2 Wd_1 Wd_0 Wd_7 Wd_6 Wd_5 Wd_4 Wd_11 Wd_10 Wd_9 Wd_8 Wd_15 Wd_14 Wd_13 Wd_12 Wd_19 Wd_18 Wd_17 Wd_16 Wd_23 Wd_22 Wd_21 Wd_20 Wd_27 Wd_26 Wd_25 Wd_24 Wd_31 Wd_30 Wd_29 Wd_28) _sub190
    I7 (RdBank0_31 RdBank0_30 RdBank0_29 RdBank0_28 RdBank0_27 RdBank0_26 RdBank0_25 RdBank0_24 RdBank0_23 RdBank0_22 RdBank0_21 RdBank0_20 RdBank0_19 RdBank0_18 RdBank0_17 RdBank0_16 RdBank0_15 RdBank0_14 RdBank0_13 RdBank0_12 RdBank0_11 RdBank0_10 RdBank0_9 RdBank0_8 RdBank0_7 RdBank0_6 RdBank0_5 RdBank0_4 RdBank0_3 RdBank0_2 RdBank0_1 RdBank0_0 RdBank0Ack_7 RdBank0Ack_6 RdBank0Ack_5 RdBank0Ack_4 RdBank0Ack_3 RdBank0Ack_2 RdBank0Ack_1 RdBank0Ack_0 RdAck_7 RdAck_6 RdAck_5 RdAck_4 RdAck_3 RdAck_2 RdAck_1 RdAck_0 net019 RdBank1_31 RdBank1_30 RdBank1_29 RdBank1_28 RdBank1_27 RdBank1_26 RdBank1_25 RdBank1_24 RdBank1_23 RdBank1_22 RdBank1_21 RdBank1_20 RdBank1_19 RdBank1_18 RdBank1_17 RdBank1_16 RdBank1_15 RdBank1_14 RdBank1_13 RdBank1_12 RdBank1_11 RdBank1_10 RdBank1_9 RdBank1_8 RdBank1_7 RdBank1_6 RdBank1_5 RdBank1_4 RdBank1_3 RdBank1_2 RdBank1_1 RdBank1_0 RdBank1Ack_7 RdBank1Ack_6 RdBank1Ack_5 RdBank1Ack_4 RdBank1Ack_3 RdBank1Ack_2 RdBank1Ack_1 RdBank1Ack_0 net020 RdBank2_31 RdBank2_30 RdBank2_29 RdBank2_28 RdBank2_27 RdBank2_26 RdBank2_25 RdBank2_24 RdBank2_23 RdBank2_22 RdBank2_21 RdBank2_20 RdBank2_19 RdBank2_18 RdBank2_17 RdBank2_16 RdBank2_15 RdBank2_14 RdBank2_13 RdBank2_12 RdBank2_11 RdBank2_10 RdBank2_9 RdBank2_8 RdBank2_7 RdBank2_6 RdBank2_5 RdBank2_4 RdBank2_3 RdBank2_2 RdBank2_1 RdBank2_0 RdBank2Ack_7 RdBank2Ack_6 RdBank2Ack_5 RdBank2Ack_4 RdBank2Ack_3 RdBank2Ack_2 RdBank2Ack_1 RdBank2Ack_0 net021 RdBank3_31 RdBank3_30 RdBank3_29 RdBank3_28 RdBank3_27 RdBank3_26 RdBank3_25 RdBank3_24 RdBank3_23 RdBank3_22 RdBank3_21 RdBank3_20 RdBank3_19 RdBank3_18 RdBank3_17 RdBank3_16 RdBank3_15 RdBank3_14 RdBank3_13 RdBank3_12 RdBank3_11 RdBank3_10 RdBank3_9 RdBank3_8 RdBank3_7 RdBank3_6 RdBank3_5 RdBank3_4 RdBank3_3 RdBank3_2 RdBank3_1 RdBank3_0 RdBank3Ack_7 RdBank3Ack_6 RdBank3Ack_5 RdBank3Ack_4 RdBank3Ack_3 RdBank3Ack_2 RdBank3Ack_1 RdBank3Ack_0 net022 Rd_3 Rd_2 Rd_1 Rd_0 Rd_7 Rd_6 Rd_5 Rd_4 Rd_11 Rd_10 Rd_9 Rd_8 Rd_15 Rd_14 Rd_13 Rd_12 Rd_19 Rd_18 Rd_17 Rd_16 Rd_23 Rd_22 Rd_21 Rd_20 Rd_27 Rd_26 Rd_25 Rd_24 Rd_31 Rd_30 Rd_29 Rd_28) _sub193
    I16 (Read_1 Read_1 Read_1 Read_1 Read_1 Read_1 Read_1 Read_1 Rd_3 Rd_2 Rd_1 Rd_0 Rd_7 Rd_6 Rd_5 Rd_4 Rd_11 Rd_10 Rd_9 Rd_8 Rd_15 Rd_14 Rd_13 Rd_12 Rd_19 Rd_18 Rd_17 Rd_16 Rd_23 Rd_22 Rd_21 Rd_20 Rd_27 Rd_26 Rd_25 Rd_24 Rd_31 Rd_30 Rd_29 Rd_28 RdAck_7 RdAck_6 RdAck_5 RdAck_4 RdAck_3 RdAck_2 RdAck_1 RdAck_0 Rdata_3 Rdata_2 Rdata_1 Rdata_0 Rdata_7 Rdata_6 Rdata_5 Rdata_4 Rdata_11 Rdata_10 Rdata_9 Rdata_8 Rdata_15 Rdata_14 Rdata_13 Rdata_12 Rdata_19 Rdata_18 Rdata_17 Rdata_16 Rdata_23 Rdata_22 Rdata_21 Rdata_20 Rdata_27 Rdata_26 Rdata_25 Rdata_24 Rdata_31 Rdata_30 Rdata_29 Rdata_28) _sub196
    I8 (WdAck_7 WdAck_6 WdAck_5 WdAck_4 WdAck_3 WdAck_2 WdAck_1 WdAck_0 Wdata_3 Wdata_2 Wdata_1 Wdata_0 Wdata_7 Wdata_6 Wdata_5 Wdata_4 Wdata_11 Wdata_10 Wdata_9 Wdata_8 Wdata_15 Wdata_14 Wdata_13 Wdata_12 Wdata_19 Wdata_18 Wdata_17 Wdata_16 Wdata_23 Wdata_22 Wdata_21 Wdata_20 Wdata_27 Wdata_26 Wdata_25 Wdata_24 Wdata_31 Wdata_30 Wdata_29 Wdata_28 WDataAck_7 WDataAck_6 WDataAck_5 WDataAck_4 WDataAck_3 WDataAck_2 WDataAck_1 WDataAck_0 Wd_3 Wd_2 Wd_1 Wd_0 Wd_7 Wd_6 Wd_5 Wd_4 Wd_11 Wd_10 Wd_9 Wd_8 Wd_15 Wd_14 Wd_13 Wd_12 Wd_19 Wd_18 Wd_17 Wd_16 Wd_23 Wd_22 Wd_21 Wd_20 Wd_27 Wd_26 Wd_25 Wd_24 Wd_31 Wd_30 Wd_29 Wd_28) _sub196
    I20_5 (net0188_0 W_Address_11 W_Address_10 net0212_0 net0212_1 net0212_2 net0212_3) Decode_2to4
    I20_4 (net0188_1 W_Address_9 W_Address_8 net0212_4 net0212_5 net0212_6 net0212_7) Decode_2to4
    I20_3 (net0188_2 W_Address_7 W_Address_6 net0212_8 net0212_9 net0212_10 net0212_11) Decode_2to4
    I20_2 (net0188_3 W_Address_5 W_Address_4 net0212_12 net0212_13 net0212_14 net0212_15) Decode_2to4
    I20_1 (net0188_4 W_Address_3 W_Address_2 net0212_16 net0212_17 net0212_18 net0212_19) Decode_2to4
    I20_0 (net0188_5 W_Address_1 W_Address_0 net0212_20 net0212_21 net0212_22 net0212_23) Decode_2to4
    I12_7 (net0143_0 WData_15 WData_14 Wdata_31 Wdata_30 Wdata_29 Wdata_28) Decode_2to4
    I12_6 (net0143_1 WData_13 WData_12 Wdata_27 Wdata_26 Wdata_25 Wdata_24) Decode_2to4
    I12_5 (net0143_2 WData_11 WData_10 Wdata_23 Wdata_22 Wdata_21 Wdata_20) Decode_2to4
    I12_4 (net0143_3 WData_9 WData_8 Wdata_19 Wdata_18 Wdata_17 Wdata_16) Decode_2to4
    I12_3 (net0143_4 WData_7 WData_6 Wdata_15 Wdata_14 Wdata_13 Wdata_12) Decode_2to4
    I12_2 (net0143_5 WData_5 WData_4 Wdata_11 Wdata_10 Wdata_9 Wdata_8) Decode_2to4
    I12_1 (net0143_6 WData_3 WData_2 Wdata_7 Wdata_6 Wdata_5 Wdata_4) Decode_2to4
    I12_0 (net0143_7 WData_1 WData_0 Wdata_3 Wdata_2 Wdata_1 Wdata_0) Decode_2to4
    I25_5 (net0168_0 R_Address_11 R_Address_10 net0172_0 net0172_1 net0172_2 net0172_3) Decode_2to4
    I25_4 (net0168_1 R_Address_9 R_Address_8 net0172_4 net0172_5 net0172_6 net0172_7) Decode_2to4
    I25_3 (net0168_2 R_Address_7 R_Address_6 net0172_8 net0172_9 net0172_10 net0172_11) Decode_2to4
    I25_2 (net0168_3 R_Address_5 R_Address_4 net0172_12 net0172_13 net0172_14 net0172_15) Decode_2to4
    I25_1 (net0168_4 R_Address_3 R_Address_2 net0172_16 net0172_17 net0172_18 net0172_19) Decode_2to4
    I25_0 (net0168_5 R_Address_1 R_Address_0 net0172_20 net0172_21 net0172_22 net0172_23) Decode_2to4
    I26_5 (Read_1 net0190_0 net0168_0) TH22
    I26_4 (Read_1 net0190_1 net0168_1) TH22
    I26_3 (Read_1 net0190_2 net0168_2) TH22
    I26_2 (Read_1 net0190_3 net0168_3) TH22
    I26_1 (Read_1 net0190_4 net0168_4) TH22
    I26_0 (Read_1 net0190_5 net0168_5) TH22
    I13_7 (Write_0 WDataAck_7 net0143_0) TH22
    I13_6 (Write_0 WDataAck_6 net0143_1) TH22
    I13_5 (Write_0 WDataAck_5 net0143_2) TH22
    I13_4 (Write_0 WDataAck_4 net0143_3) TH22
    I13_3 (Write_0 WDataAck_3 net0143_4) TH22
    I13_2 (Write_0 WDataAck_2 net0143_5) TH22
    I13_1 (Write_0 WDataAck_1 net0143_6) TH22
    I13_0 (Write_0 WDataAck_0 net0143_7) TH22
    I24_5 (Write_0 net0189_0 net0188_0) TH22
    I24_4 (Write_0 net0189_1 net0188_1) TH22
    I24_3 (Write_0 net0189_2 net0188_2) TH22
    I24_2 (Write_0 net0189_3 net0188_3) TH22
    I24_1 (Write_0 net0189_4 net0188_4) TH22
    I24_0 (Write_0 net0189_5 net0188_5) TH22
    I18 (net0135_0 net0135_1 net0135_2 net0135_3 net0135_4 net0135_5 net0135_6 net0135_7 net0135_8 net0135_9 net0135_10 net0135_11 net0135_12 net0135_13 net0135_14 net0135_15 net0135_16 net0135_17 net0135_18 net0135_19 net0137_0 net0137_1 net0137_2 net0137_3 net0137_4 net017 net018 net0205 net0201 Write_0 net0212_0 net0212_1 net0212_2 net0212_3 net0212_4 net0212_5 net0212_6 net0212_7 net0212_8 net0212_9 net0212_10 net0212_11 net0212_12 net0212_13 net0212_14 net0212_15 net0212_16 net0212_17 net0212_18 net0212_19 net0212_20 net0212_21 net0212_22 net0212_23 net0189_0 net0189_1 net0189_2 net0189_3 net0189_4 net0189_5 net0136_0 net0136_1 net064 WriteAck Write_1 Write_0) _sub198
    I27 (Read_0 0) iprobe
    I23 (Write_1 0) iprobe
    I19 (net0200_0 net0200_1 net0200_2 net0200_3 net0200_4 net0200_5 net0200_6 net0200_7 net0200_8 net0200_9 net0200_10 net0200_11 net0200_12 net0200_13 net0200_14 net0200_15 net0200_16 net0200_17 net0200_18 net0200_19 net0204_0 net0204_1 net0204_2 net0204_3 net0204_4 net019 net020 net021 net022 Read_1 net0172_0 net0172_1 net0172_2 net0172_3 net0172_4 net0172_5 net0172_6 net0172_7 net0172_8 net0172_9 net0172_10 net0172_11 net0172_12 net0172_13 net0172_14 net0172_15 net0172_16 net0172_17 net0172_18 net0172_19 net0172_20 net0172_21 net0172_22 net0172_23 net0190_0 net0190_1 net0190_2 net0190_3 net0190_4 net0190_5 net0196_0 net0196_1 net060 ReadAck Read_1 Read_0) _sub198
    I17_7 (Read_1 Rdata_31 Rdata_30 Rdata_29 Rdata_28 RData_15 RData_14) Encode_4to2
    I17_6 (Read_1 Rdata_27 Rdata_26 Rdata_25 Rdata_24 RData_13 RData_12) Encode_4to2
    I17_5 (Read_1 Rdata_23 Rdata_22 Rdata_21 Rdata_20 RData_11 RData_10) Encode_4to2
    I17_4 (Read_1 Rdata_19 Rdata_18 Rdata_17 Rdata_16 RData_9 RData_8) Encode_4to2
    I17_3 (Read_1 Rdata_15 Rdata_14 Rdata_13 Rdata_12 RData_7 RData_6) Encode_4to2
    I17_2 (Read_1 Rdata_11 Rdata_10 Rdata_9 Rdata_8 RData_5 RData_4) Encode_4to2
    I17_1 (Read_1 Rdata_7 Rdata_6 Rdata_5 Rdata_4 RData_3 RData_2) Encode_4to2
    I17_0 (Read_1 Rdata_3 Rdata_2 Rdata_1 Rdata_0 RData_1 RData_0) Encode_4to2
ends _sub199

// ATSim/nand9_1x/schematic
//system verilogNetlist schematic cmos.sch cmos_sch veriloga ahdl
subckt nand9_1x A B C D E F G H I Y
    M17 (Y I vdd! vdd!) pfet w=80n l=16n m=1 region=sat
    M15 (Y H vdd! vdd!) pfet w=80n l=16n m=1 region=sat
    M12 (Y G vdd! vdd!) pfet w=80n l=16n m=1 region=sat
    M10 (Y F vdd! vdd!) pfet w=80n l=16n m=1 region=sat
    M8 (Y E vdd! vdd!) pfet w=80n l=16n m=1 region=sat
    M5 (Y D vdd! vdd!) pfet w=80n l=16n m=1 region=sat
    M4 (Y C vdd! vdd!) pfet w=80n l=16n m=1 region=sat
    M1 (Y B vdd! vdd!) pfet w=80n l=16n m=1 region=sat
    M0 (Y A vdd! vdd!) pfet w=80n l=16n m=1 region=sat
    M16 (net046 I 0 0) nfet w=160n l=16n m=1 region=sat
    M14 (net042 H net046 0) nfet w=160n l=16n m=1 region=sat
    M13 (net025 G net042 0) nfet w=160n l=16n m=1 region=sat
    M11 (net031 F net025 0) nfet w=160n l=16n m=1 region=sat
    M9 (net027 E net031 0) nfet w=160n l=16n m=1 region=sat
    M7 (net23 D net027 0) nfet w=160n l=16n m=1 region=sat
    M6 (net25 C net23 0) nfet w=160n l=16n m=1 region=sat
    M3 (net24 B net25 0) nfet w=160n l=16n m=1 region=sat
    M2 (Y A net24 0) nfet w=160n l=16n m=1 region=sat
ends nand9_1x

// ATSim/nand14_1x/schematic
//system verilogNetlist schematic cmos.sch cmos_sch veriloga ahdl
subckt nand14_1x A B C D E F G H I J K L M N Y
    M27 (Y N vdd! vdd!) pfet w=80n l=16n m=1 region=sat
    M26 (Y M vdd! vdd!) pfet w=80n l=16n m=1 region=sat
    M25 (Y L vdd! vdd!) pfet w=80n l=16n m=1 region=sat
    M24 (Y K vdd! vdd!) pfet w=80n l=16n m=1 region=sat
    M23 (Y J vdd! vdd!) pfet w=80n l=16n m=1 region=sat
    M22 (Y I vdd! vdd!) pfet w=80n l=16n m=1 region=sat
    M21 (Y H vdd! vdd!) pfet w=80n l=16n m=1 region=sat
    M20 (Y G vdd! vdd!) pfet w=80n l=16n m=1 region=sat
    M10 (Y F vdd! vdd!) pfet w=80n l=16n m=1 region=sat
    M8 (Y E vdd! vdd!) pfet w=80n l=16n m=1 region=sat
    M5 (Y D vdd! vdd!) pfet w=80n l=16n m=1 region=sat
    M4 (Y C vdd! vdd!) pfet w=80n l=16n m=1 region=sat
    M1 (Y B vdd! vdd!) pfet w=80n l=16n m=1 region=sat
    M0 (Y A vdd! vdd!) pfet w=80n l=16n m=1 region=sat
    M19 (net058 M net072 0) nfet w=160n l=16n m=1 region=sat
    M18 (net072 N 0 0) nfet w=160n l=16n m=1 region=sat
    M17 (net051 G net074 0) nfet w=160n l=16n m=1 region=sat
    M16 (net074 H H 0) nfet w=160n l=16n m=1 region=sat
    M15 (H I J 0) nfet w=160n l=16n m=1 region=sat
    M14 (J J net075 0) nfet w=160n l=16n m=1 region=sat
    M13 (net075 K net073 0) nfet w=160n l=16n m=1 region=sat
    M12 (net073 L net058 0) nfet w=160n l=16n m=1 region=sat
    M11 (net031 F net051 0) nfet w=160n l=16n m=1 region=sat
    M9 (net027 E net031 0) nfet w=160n l=16n m=1 region=sat
    M7 (net23 D net027 0) nfet w=160n l=16n m=1 region=sat
    M6 (net25 C net23 0) nfet w=160n l=16n m=1 region=sat
    M3 (net24 B net25 0) nfet w=160n l=16n m=1 region=sat
    M2 (Y A net24 0) nfet w=160n l=16n m=1 region=sat
ends nand14_1x

// ATSim/nand5_1x/schematic
//system verilogNetlist schematic cmos.sch cmos_sch veriloga ahdl
subckt nand5_1x A B C D E Y
    M8 (Y E vdd! vdd!) pfet w=80n l=16n m=1 region=sat
    M5 (Y D vdd! vdd!) pfet w=80n l=16n m=1 region=sat
    M4 (Y C vdd! vdd!) pfet w=80n l=16n m=1 region=sat
    M1 (Y B vdd! vdd!) pfet w=80n l=16n m=1 region=sat
    M0 (Y A vdd! vdd!) pfet w=80n l=16n m=1 region=sat
    M9 (net027 E 0 0) nfet w=160n l=16n m=1 region=sat
    M7 (net23 D net027 0) nfet w=160n l=16n m=1 region=sat
    M6 (net25 C net23 0) nfet w=160n l=16n m=1 region=sat
    M3 (net24 B net25 0) nfet w=160n l=16n m=1 region=sat
    M2 (Y A net24 0) nfet w=160n l=16n m=1 region=sat
ends nand5_1x

// ATSim/nand6_1x/schematic
//system verilogNetlist schematic cmos.sch cmos_sch veriloga ahdl
subckt nand6_1x A B C D E F Y
    M10 (Y F vdd! vdd!) pfet w=80n l=16n m=1 region=sat
    M8 (Y E vdd! vdd!) pfet w=80n l=16n m=1 region=sat
    M5 (Y D vdd! vdd!) pfet w=80n l=16n m=1 region=sat
    M4 (Y C vdd! vdd!) pfet w=80n l=16n m=1 region=sat
    M1 (Y B vdd! vdd!) pfet w=80n l=16n m=1 region=sat
    M0 (Y A vdd! vdd!) pfet w=80n l=16n m=1 region=sat
    M11 (net031 F 0 0) nfet w=160n l=16n m=1 region=sat
    M9 (net027 E net031 0) nfet w=160n l=16n m=1 region=sat
    M7 (net23 D net027 0) nfet w=160n l=16n m=1 region=sat
    M6 (net25 C net23 0) nfet w=160n l=16n m=1 region=sat
    M3 (net24 B net25 0) nfet w=160n l=16n m=1 region=sat
    M2 (Y A net24 0) nfet w=160n l=16n m=1 region=sat
ends nand6_1x

// ATSim/Simple_tag_read_ctrl2/schematic
//system verilogNetlist schematic cmos.sch cmos_sch veriloga ahdl
subckt Simple_tag_read_ctrl2 FIFOAck FIFOReq Read ReadFromL1Ack ReadFromL1Req TagHit TagRAck TagRE TagRdRegAck TagRdRegReq Write WriteToL1Ack WriteToL1Req
    I3 (TagRdRegAck TagRdRegAck_n) inv_1x
    I5 (TagHit TagHit_n) inv_1x
    I7 (TagRAck TagRAck_n) inv_1x
    I6 (Write Write_n) inv_1x
    I8 (FIFOReq FIFOReq_n) inv_1x
    I9 (Read Read_n) inv_1x
    I11 (WriteToL1Ack WriteToL1Ack_n) inv_1x
    I10 (ReadFromL1Ack ReadFromL1Ack_n) inv_1x
    I18 (y0 Y0_n) inv_1x
    I14 (y3 Y3_n) inv_1x
    I16 (y2 Y2_n) inv_1x
    I17 (y1 Y1_n) inv_1x
    I34 (FIFOReq_n y2 p23) nand_1x
    I33 (TagRAck_n y3 p22) nand_1x
    I31 (TagRdRegAck_n ReadFromL1Ack_n p20) nand_1x
    I30 (TagRAck TagRAck p19) nand_1x
    I29 (ReadFromL1Ack ReadFromL1Ack p18) nand_1x
    I28 (FIFOReq FIFOReq p17) nand_1x
    I27 (Write_n Y2_n p16) nand_1x
    I26 (Read_n Y2_n p15) nand_1x
    I21 (Read Y3_n p10) nand_1x
    I19 (TagRAck Y1_n p9) nand_1x
    I15 (TagHit Y1_n p8) nand_1x
    I13 (Write Y3_n p7) nand_1x
    I12 (TagRAck Y0_n p6) nand_1x
    I4 (TagHit Y0_n p5) nand_1x
    I1 (TagRAck_n Y2_n p3) nand_1x
    I0 (TagHit_n Y2_n p2) nand_1x
    I2 (FIFOReq TagRdRegAck p1) nand_1x
    I39 (p18 p19 p21 FIFOAck) nand3_1x
    I20 (Read_n Write_n Y2_n p4) nand3_1x
    I43 (p11 p13 p20 p23 y2) nand4_1x
    I42 (p1 p2 p3 p4 TagRE) nand4_1x
    I32 (TagHit_n Write_n TagRAck_n WriteToL1Ack p21) nand4_1x
    I25 (ReadFromL1Ack_n y0 Y1_n Y3_n p14) nand4_1x
    I24 (FIFOReq_n TagHit Read TagRAck p13) nand4_1x
    I23 (WriteToL1Ack_n Y0_n y1 Y3_n p12) nand4_1x
    I22 (FIFOReq_n TagHit Write TagRAck p11) nand4_1x
    I37 (p1 p2 p3 p5 p6 p7 p11 p12 p15 y1) nand9_1x
    I36 (p1 p2 p3 p8 p9 p10 p13 p14 p16 y0) nand9_1x
    I38 (p5 p6 p7 p8 p9 p10 p11 p12 p13 p14 p15 p16 p17 p17 TagRdRegReq) nand14_1x
    I41 (p5 p6 p7 p11 p12 WriteToL1Req) nand5_1x
    I40 (p8 p9 p10 p13 p14 ReadFromL1Req) nand5_1x
    I44 (p2 p4 p17 p20 p21 p22 y3) nand6_1x
ends Simple_tag_read_ctrl2

// 16nm_Tests/DCache_Test/schematic
// system verilogNetlist schematic cmos.sch cmos_sch veriloga ahdl
V1 (vcc! 0) vsource type=dc dc=vcc
V0 (vdd! 0) vsource type=dc dc=vdd
I44_15 (\~WData_15 WDataT_15) inv_1xt
I44_14 (\~WData_14 WDataT_14) inv_1xt
I44_13 (\~WData_13 WDataT_13) inv_1xt
I44_12 (\~WData_12 WDataT_12) inv_1xt
I44_11 (\~WData_11 WDataT_11) inv_1xt
I44_10 (\~WData_10 WDataT_10) inv_1xt
I44_9 (\~WData_9 WDataT_9) inv_1xt
I44_8 (\~WData_8 WDataT_8) inv_1xt
I44_7 (\~WData_7 WDataT_7) inv_1xt
I44_6 (\~WData_6 WDataT_6) inv_1xt
I44_5 (\~WData_5 WDataT_5) inv_1xt
I44_4 (\~WData_4 WDataT_4) inv_1xt
I44_3 (\~WData_3 WDataT_3) inv_1xt
I44_2 (\~WData_2 WDataT_2) inv_1xt
I44_1 (\~WData_1 WDataT_1) inv_1xt
I44_0 (\~WData_0 WDataT_0) inv_1xt
I43 (\~Req OutFIFOReq) inv_1xt
I41 (OutFIFOAck \~Ack) inv_1xt
I27_7 (net0106_0 net052_0) inv_1xt
I27_6 (net0106_1 net052_1) inv_1xt
I27_5 (net0106_2 net052_2) inv_1xt
I27_4 (net0106_3 net052_3) inv_1xt
I27_3 (net0106_4 net052_4) inv_1xt
I27_2 (net0106_5 net052_5) inv_1xt
I27_1 (net0106_6 net052_6) inv_1xt
I27_0 (net0106_7 net052_7) inv_1xt
I7 (\~Req net016) inv_1xt
I13 (AckT \~Ack) inv_1xt
I16_1 (\~RW_1 RWT_1) inv_1xt
I16_0 (\~RW_0 RWT_0) inv_1xt
I19_32 (\~CPU_Addr_32 CPUT_32) inv_1xt
I19_31 (\~CPU_Addr_31 CPUT_31) inv_1xt
I19_30 (\~CPU_Addr_30 CPUT_30) inv_1xt
I19_29 (\~CPU_Addr_29 CPUT_29) inv_1xt
I19_28 (\~CPU_Addr_28 CPUT_28) inv_1xt
I19_27 (\~CPU_Addr_27 CPUT_27) inv_1xt
I19_26 (\~CPU_Addr_26 CPUT_26) inv_1xt
I19_25 (\~CPU_Addr_25 CPUT_25) inv_1xt
I19_24 (\~CPU_Addr_24 CPUT_24) inv_1xt
I19_23 (\~CPU_Addr_23 CPUT_23) inv_1xt
I19_22 (\~CPU_Addr_22 CPUT_22) inv_1xt
I19_21 (\~CPU_Addr_21 CPUT_21) inv_1xt
I19_20 (\~CPU_Addr_20 CPUT_20) inv_1xt
I19_19 (\~CPU_Addr_19 CPUT_19) inv_1xt
I19_18 (\~CPU_Addr_18 CPUT_18) inv_1xt
I19_17 (\~CPU_Addr_17 CPUT_17) inv_1xt
I19_16 (\~CPU_Addr_16 CPUT_16) inv_1xt
I19_15 (\~CPU_Addr_15 CPUT_15) inv_1xt
I19_14 (\~CPU_Addr_14 CPUT_14) inv_1xt
I19_13 (\~CPU_Addr_13 CPUT_13) inv_1xt
I19_12 (\~CPU_Addr_12 CPUT_12) inv_1xt
I19_11 (\~CPU_Addr_11 CPUT_11) inv_1xt
I19_10 (\~CPU_Addr_10 CPUT_10) inv_1xt
I19_9 (\~CPU_Addr_9 CPUT_9) inv_1xt
I19_8 (\~CPU_Addr_8 CPUT_8) inv_1xt
I19_7 (\~CPU_Addr_7 CPUT_7) inv_1xt
I19_6 (\~CPU_Addr_6 CPUT_6) inv_1xt
I19_5 (\~CPU_Addr_5 CPUT_5) inv_1xt
I19_4 (\~CPU_Addr_4 CPUT_4) inv_1xt
I19_3 (\~CPU_Addr_3 CPUT_3) inv_1xt
I19_2 (\~CPU_Addr_2 CPUT_2) inv_1xt
I19_1 (\~CPU_Addr_1 CPUT_1) inv_1xt
I19_0 (\~CPU_Addr_0 CPUT_0) inv_1xt
I26_15 (\~WData_15 WDataT_15) inv_1xt
I26_14 (\~WData_14 WDataT_14) inv_1xt
I26_13 (\~WData_13 WDataT_13) inv_1xt
I26_12 (\~WData_12 WDataT_12) inv_1xt
I26_11 (\~WData_11 WDataT_11) inv_1xt
I26_10 (\~WData_10 WDataT_10) inv_1xt
I26_9 (\~WData_9 WDataT_9) inv_1xt
I26_8 (\~WData_8 WDataT_8) inv_1xt
I26_7 (\~WData_7 WDataT_7) inv_1xt
I26_6 (\~WData_6 WDataT_6) inv_1xt
I26_5 (\~WData_5 WDataT_5) inv_1xt
I26_4 (\~WData_4 WDataT_4) inv_1xt
I26_3 (\~WData_3 WDataT_3) inv_1xt
I26_2 (\~WData_2 WDataT_2) inv_1xt
I26_1 (\~WData_1 WDataT_1) inv_1xt
I26_0 (\~WData_0 WDataT_0) inv_1xt
I17 (ReadEnable WriteEnable TagReadeAck TagWriteAck R1_31 R1_30 R1_29 R1_28 R1_27 R1_26 R1_25 R1_24 R1_23 R1_22 R1_21 R1_20 R1_19 R1_18 R1_17 R1_16 R1_15 R1_14 R1_13 R1_12 R1_11 R1_10 R1_9 R1_8 R1_7 R1_6 R1_5 R1_4 R1_3 R1_2 R1_1 R1_0 net035_0 net035_1 net035_2 net035_3 net035_4 net035_5 net035_6 net036 net037_0 net037_1 net037_2 net037_3 net037_4 net037_5 net037_6 net037_7 net037_8 net037_9 net037_10 net037_11 net037_12 net037_13 net037_14 net037_15 net037_16 net037_17 net037_18 net037_19 net037_20 net037_21 net037_22 net037_23 net037_24 net037_25 net037_26 net037_27 net037_28 net037_29 net037_30 net037_31 net048_0 net048_1 net048_2 net048_3 net048_4 net048_5 net048_6 net048_7 net048_8 net048_9 net048_10 net048_11 net048_12 net048_13 net048_14 net048_15 net048_16 net048_17 net048_18 net048_19 net048_20 net048_21 net048_22 net048_23 net048_24 net048_25 net048_26 net048_27 net048_28 net048_29 net048_30 net048_31 net044_0 net044_1 net044_2 net044_3 net044_4 net044_5 net044_6 R0_31 R0_30 R0_29 R0_28 R0_27 R0_26 R0_25 R0_24 R0_23 R0_22 R0_21 R0_20 R0_19 R0_18 R0_17 R0_16 R0_15 R0_14 R0_13 R0_12 R0_11 R0_10 R0_9 R0_8 R0_7 R0_6 R0_5 R0_4 R0_3 R0_2 R0_1 R0_0) Dcache_TagMem
I8_6 (net059 CPUT_10 net035_0 net041_0) DFlop
I8_5 (net059 CPUT_9 net035_1 net041_1) DFlop
I8_4 (net059 CPUT_8 net035_2 net041_2) DFlop
I8_3 (net059 CPUT_7 net035_3 net041_3) DFlop
I8_2 (net059 CPUT_6 net035_4 net041_4) DFlop
I8_1 (net059 CPUT_5 net035_5 net041_5) DFlop
I8_0 (net059 CPUT_4 net035_6 net041_6) DFlop
I20_6 (net076 CPUT_10 net044_0 net045_0) DFlop
I20_5 (net076 CPUT_9 net044_1 net045_1) DFlop
I20_4 (net076 CPUT_8 net044_2 net045_2) DFlop
I20_3 (net076 CPUT_7 net044_3 net045_3) DFlop
I20_2 (net076 CPUT_6 net044_4 net045_4) DFlop
I20_1 (net076 CPUT_5 net044_5 net045_5) DFlop
I20_0 (net076 CPUT_4 net044_6 net045_6) DFlop
I22_31 (net076 net051_0 net048_0 net049_0) DFlop
I22_30 (net076 net051_1 net048_1 net049_1) DFlop
I22_29 (net076 net051_2 net048_2 net049_2) DFlop
I22_28 (net076 net051_3 net048_3 net049_3) DFlop
I22_27 (net076 net051_4 net048_4 net049_4) DFlop
I22_26 (net076 net051_5 net048_5 net049_5) DFlop
I22_25 (net076 net051_6 net048_6 net049_6) DFlop
I22_24 (net076 net051_7 net048_7 net049_7) DFlop
I22_23 (net076 net051_8 net048_8 net049_8) DFlop
I22_22 (net076 net051_9 net048_9 net049_9) DFlop
I22_21 (net076 net051_10 net048_10 net049_10) DFlop
I22_20 (net076 net051_11 net048_11 net049_11) DFlop
I22_19 (net076 net051_12 net048_12 net049_12) DFlop
I22_18 (net076 net051_13 net048_13 net049_13) DFlop
I22_17 (net076 net051_14 net048_14 net049_14) DFlop
I22_16 (net076 net051_15 net048_15 net049_15) DFlop
I22_15 (net076 net051_16 net048_16 net049_16) DFlop
I22_14 (net076 net051_17 net048_17 net049_17) DFlop
I22_13 (net076 net051_18 net048_18 net049_18) DFlop
I22_12 (net076 net051_19 net048_19 net049_19) DFlop
I22_11 (net076 net051_20 net048_20 net049_20) DFlop
I22_10 (net076 net051_21 net048_21 net049_21) DFlop
I22_9 (net076 net051_22 net048_22 net049_22) DFlop
I22_8 (net076 net051_23 net048_23 net049_23) DFlop
I22_7 (net076 net051_24 net048_24 net049_24) DFlop
I22_6 (net076 net051_25 net048_25 net049_25) DFlop
I22_5 (net076 net051_26 net048_26 net049_26) DFlop
I22_4 (net076 net051_27 net048_27 net049_27) DFlop
I22_3 (net076 net051_28 net048_28 net049_28) DFlop
I22_2 (net076 net051_29 net048_29 net049_29) DFlop
I22_1 (net076 net051_30 net048_30 net049_30) DFlop
I22_0 (net076 net051_31 net048_31 net049_31) DFlop
I23_31 (net076 net055_0 net037_0 net053_0) DFlop
I23_30 (net076 net055_1 net037_1 net053_1) DFlop
I23_29 (net076 net055_2 net037_2 net053_2) DFlop
I23_28 (net076 net055_3 net037_3 net053_3) DFlop
I23_27 (net076 net055_4 net037_4 net053_4) DFlop
I23_26 (net076 net055_5 net037_5 net053_5) DFlop
I23_25 (net076 net055_6 net037_6 net053_6) DFlop
I23_24 (net076 net055_7 net037_7 net053_7) DFlop
I23_23 (net076 net055_8 net037_8 net053_8) DFlop
I23_22 (net076 net055_9 net037_9 net053_9) DFlop
I23_21 (net076 net055_10 net037_10 net053_10) DFlop
I23_20 (net076 net055_11 net037_11 net053_11) DFlop
I23_19 (net076 net055_12 net037_12 net053_12) DFlop
I23_18 (net076 net055_13 net037_13 net053_13) DFlop
I23_17 (net076 net055_14 net037_14 net053_14) DFlop
I23_16 (net076 net055_15 net037_15 net053_15) DFlop
I23_15 (net076 net055_16 net037_16 net053_16) DFlop
I23_14 (net076 net055_17 net037_17 net053_17) DFlop
I23_13 (net076 net055_18 net037_18 net053_18) DFlop
I23_12 (net076 net055_19 net037_19 net053_19) DFlop
I23_11 (net076 net055_20 net037_20 net053_20) DFlop
I23_10 (net076 net055_21 net037_21 net053_21) DFlop
I23_9 (net076 net055_22 net037_22 net053_22) DFlop
I23_8 (net076 net055_23 net037_23 net053_23) DFlop
I23_7 (net076 net055_24 net037_24 net053_24) DFlop
I23_6 (net076 net055_25 net037_25 net053_25) DFlop
I23_5 (net076 net055_26 net037_26 net053_26) DFlop
I23_4 (net076 net055_27 net037_27 net053_27) DFlop
I23_3 (net076 net055_28 net037_28 net053_28) DFlop
I23_2 (net076 net055_29 net037_29 net053_29) DFlop
I23_1 (net076 net055_30 net037_30 net053_30) DFlop
I23_0 (net076 net055_31 net037_31 net053_31) DFlop
I38_11 (net019 net0127_0 net0104_0 net0128_0) DFlop
I38_10 (net019 net0127_1 net0104_1 net0128_1) DFlop
I38_9 (net019 net0127_2 net0104_2 net0128_2) DFlop
I38_8 (net019 net0127_3 net0104_3 net0128_3) DFlop
I38_7 (net019 net0127_4 net0104_4 net0128_4) DFlop
I38_6 (net019 net0127_5 net0104_5 net0128_5) DFlop
I38_5 (net019 net0127_6 net0104_6 net0128_6) DFlop
I38_4 (net019 net0127_7 net0104_7 net0128_7) DFlop
I38_3 (net019 net0127_8 net0104_8 net0128_8) DFlop
I38_2 (net019 net0127_9 net0104_9 net0128_9) DFlop
I38_1 (net019 net0127_10 net0104_10 net0128_10) DFlop
I38_0 (net019 net0127_11 net0104_11 net0128_11) DFlop
I35_11 (net089 net0124_0 net087_0 net0123_0) DFlop
I35_10 (net089 net0124_1 net087_1 net0123_1) DFlop
I35_9 (net089 net0124_2 net087_2 net0123_2) DFlop
I35_8 (net089 net0124_3 net087_3 net0123_3) DFlop
I35_7 (net089 net0124_4 net087_4 net0123_4) DFlop
I35_6 (net089 net0124_5 net087_5 net0123_5) DFlop
I35_5 (net089 net0124_6 net087_6 net0123_6) DFlop
I35_4 (net089 net0124_7 net087_7 net0123_7) DFlop
I35_3 (net089 net0124_8 net087_8 net0123_8) DFlop
I35_2 (net089 net0124_9 net087_9 net0123_9) DFlop
I35_1 (net089 net0124_10 net087_10 net0123_10) DFlop
I35_0 (net089 net0124_11 net087_11 net0123_11) DFlop
I2 (net059 net057 net058 net057) HS_Cordic
I10 (net076 net061 net062 net061) HS_Cordic
I37 (net019 net0121 net047 net0121) HS_Cordic
I36 (net089 net050 net090 net050) HS_Cordic
I24_21 (CPUT_32 net088_0 net065_0 ReadEnable) DR_encoder
I24_20 (CPUT_31 net088_1 net065_1 ReadEnable) DR_encoder
I24_19 (CPUT_30 net088_2 net065_2 ReadEnable) DR_encoder
I24_18 (CPUT_29 net088_3 net065_3 ReadEnable) DR_encoder
I24_17 (CPUT_28 net088_4 net065_4 ReadEnable) DR_encoder
I24_16 (CPUT_27 net088_5 net065_5 ReadEnable) DR_encoder
I24_15 (CPUT_26 net088_6 net065_6 ReadEnable) DR_encoder
I24_14 (CPUT_25 net088_7 net065_7 ReadEnable) DR_encoder
I24_13 (CPUT_24 net088_8 net065_8 ReadEnable) DR_encoder
I24_12 (CPUT_23 net088_9 net065_9 ReadEnable) DR_encoder
I24_11 (CPUT_22 net088_10 net065_10 ReadEnable) DR_encoder
I24_10 (CPUT_21 net088_11 net065_11 ReadEnable) DR_encoder
I24_9 (CPUT_20 net088_12 net065_12 ReadEnable) DR_encoder
I24_8 (CPUT_19 net088_13 net065_13 ReadEnable) DR_encoder
I24_7 (CPUT_18 net088_14 net065_14 ReadEnable) DR_encoder
I24_6 (CPUT_17 net088_15 net065_15 ReadEnable) DR_encoder
I24_5 (CPUT_16 net088_16 net065_16 ReadEnable) DR_encoder
I24_4 (CPUT_15 net088_17 net065_17 ReadEnable) DR_encoder
I24_3 (CPUT_14 net088_18 net065_18 ReadEnable) DR_encoder
I24_2 (CPUT_13 net088_19 net065_19 ReadEnable) DR_encoder
I24_1 (CPUT_12 net088_20 net065_20 ReadEnable) DR_encoder
I24_0 (CPUT_11 net088_21 net065_21 ReadEnable) DR_encoder
I9 (Hit Miss CAck R0_21 R0_20 R0_19 R0_18 R0_17 R0_16 R0_15 R0_14 R0_13 R0_12 R0_11 R0_10 R0_9 R0_8 R0_7 R0_6 R0_5 R0_4 R0_3 R0_2 R0_1 R0_0 R1_21 R1_20 R1_19 R1_18 R1_17 R1_16 R1_15 R1_14 R1_13 R1_12 R1_11 R1_10 R1_9 R1_8 R1_7 R1_6 R1_5 R1_4 R1_3 R1_2 R1_1 R1_0 net088_0 net088_1 net088_2 net088_3 net088_4 net088_5 net088_6 net088_7 net088_8 net088_9 net088_10 net088_11 net088_12 net088_13 net088_14 net088_15 net088_16 net088_17 net088_18 net088_19 net088_20 net088_21 net065_0 net065_1 net065_2 net065_3 net065_4 net065_5 net065_6 net065_7 net065_8 net065_9 net065_10 net065_11 net065_12 net065_13 net065_14 net065_15 net065_16 net065_17 net065_18 net065_19 net065_20 net065_21) Compare22_DR
I14 (Miss R0_31 MissInvalid) nor_1x
I21 (net084_0 net084_1 net084_2 net084_3 net084_4 net084_5 net084_6 net084_7 net084_8 net084_9 net084_10 net084_11 net084_12 net084_13 net084_14 net084_15 net087_0 net087_1 net087_2 net087_3 net087_4 net087_5 net087_6 net087_7 net087_8 net087_9 net087_10 net087_11 net097 L1RE WDataT_15 WDataT_14 WDataT_13 WDataT_12 WDataT_11 WDataT_10 WDataT_9 WDataT_8 WDataT_7 WDataT_6 WDataT_5 WDataT_4 WDataT_3 WDataT_2 WDataT_1 WDataT_0 net0106_0 net0106_1 net0106_2 net0106_3 net0106_4 net0106_5 net0106_6 net0106_7 net0104_0 net0104_1 net0104_2 net0104_3 net0104_4 net0104_5 net0104_6 net0104_7 net0104_8 net0104_9 net0104_10 net0104_11 net0102 net0105) _sub199
I5 (R1_31 Hit HitValid) and_1x
I30 (RWT_0 WriteEnable net070) and_1x
I29 (ReadEnable RWT_1 net074) and_1x
I11 (CAck TagReadeAck TagRAck) _sub160
I31 (AckT net016 net074 net095 net068 MissInvalid TagRAck ReadEnable net059 net058 net070 net071 net069) Simple_tag_read_ctrl2
I32 (WriteEnable net079 net075 net073 net062 net093 net076 net072 net082) Tag_write_ctrl_rev3
I34 (net0133 net095 net0114 net097 L1RE net089 net090 net091 net092 net056 net068 net098) L1_read_ctrl_rev3
I39 (net0105 net071 net0125 net0122 net047 net069 net019 net0109 net0102) L1_write_ctrl_rev3
// BEGIN Hierarchical Interface Elements
_ie99937 (\~WData_5 0) d2a src="99937" val0=0.0 val1=vdd valx=vdd/2 rise=2p fall=2p
_ie99938 (\~RW_1 0) d2a src="99938" val0=0.0 val1=vdd valx=vdd/2 rise=2p fall=2p
_ie99939 (\~WData_6 0) d2a src="99939" val0=0.0 val1=vdd valx=vdd/2 rise=2p fall=2p
_ie99940 (\~WData_7 0) d2a src="99940" val0=0.0 val1=vdd valx=vdd/2 rise=2p fall=2p
_ie99941 (net052_5 0) a2d dest="99941" vl=0.3*vdd vh=0.7*vdd timex=20n
_ie99942 (\~WData_8 0) d2a src="99942" val0=0.0 val1=vdd valx=vdd/2 rise=2p fall=2p
_ie99943 (\~WData_9 0) d2a src="99943" val0=0.0 val1=vdd valx=vdd/2 rise=2p fall=2p
_ie99944 (net052_4 0) a2d dest="99944" vl=0.3*vdd vh=0.7*vdd timex=20n
_ie99945 (net052_3 0) a2d dest="99945" vl=0.3*vdd vh=0.7*vdd timex=20n
_ie99946 (\~WData_10 0) d2a src="99946" val0=0.0 val1=vdd valx=vdd/2 rise=2p fall=2p
_ie99947 (\~WData_11 0) d2a src="99947" val0=0.0 val1=vdd valx=vdd/2 rise=2p fall=2p
_ie99948 (\~WData_12 0) d2a src="99948" val0=0.0 val1=vdd valx=vdd/2 rise=2p fall=2p
_ie99949 (\~CPU_Addr_8 0) d2a src="99949" val0=0.0 val1=vdd valx=vdd/2 rise=2p fall=2p
_ie99950 (net052_2 0) a2d dest="99950" vl=0.3*vdd vh=0.7*vdd timex=20n
_ie99951 (\~CPU_Addr_30 0) d2a src="99951" val0=0.0 val1=vdd valx=vdd/2 rise=2p fall=2p
_ie99952 (\~CPU_Addr_21 0) d2a src="99952" val0=0.0 val1=vdd valx=vdd/2 rise=2p fall=2p
_ie99953 (\~CPU_Addr_7 0) d2a src="99953" val0=0.0 val1=vdd valx=vdd/2 rise=2p fall=2p
_ie99954 (\~CPU_Addr_22 0) d2a src="99954" val0=0.0 val1=vdd valx=vdd/2 rise=2p fall=2p
_ie99955 (net052_1 0) a2d dest="99955" vl=0.3*vdd vh=0.7*vdd timex=20n
_ie99956 (net052_0 0) a2d dest="99956" vl=0.3*vdd vh=0.7*vdd timex=20n
_ie99957 (\~CPU_Addr_15 0) d2a src="99957" val0=0.0 val1=vdd valx=vdd/2 rise=2p fall=2p
_ie99958 (\~WData_13 0) d2a src="99958" val0=0.0 val1=vdd valx=vdd/2 rise=2p fall=2p
_ie99959 (\~WData_3 0) d2a src="99959" val0=0.0 val1=vdd valx=vdd/2 rise=2p fall=2p
_ie99960 (\~WData_14 0) d2a src="99960" val0=0.0 val1=vdd valx=vdd/2 rise=2p fall=2p
_ie99961 (\~CPU_Addr_11 0) d2a src="99961" val0=0.0 val1=vdd valx=vdd/2 rise=2p fall=2p
_ie99962 (\~WData_1 0) d2a src="99962" val0=0.0 val1=vdd valx=vdd/2 rise=2p fall=2p
_ie99963 (\~CPU_Addr_4 0) d2a src="99963" val0=0.0 val1=vdd valx=vdd/2 rise=2p fall=2p
_ie99964 (\~CPU_Addr_3 0) d2a src="99964" val0=0.0 val1=vdd valx=vdd/2 rise=2p fall=2p
_ie99965 (net052_7 0) a2d dest="99965" vl=0.3*vdd vh=0.7*vdd timex=20n
_ie99966 (\~WData_4 0) d2a src="99966" val0=0.0 val1=vdd valx=vdd/2 rise=2p fall=2p
_ie99967 (\~CPU_Addr_6 0) d2a src="99967" val0=0.0 val1=vdd valx=vdd/2 rise=2p fall=2p
_ie99968 (\~CPU_Addr_20 0) d2a src="99968" val0=0.0 val1=vdd valx=vdd/2 rise=2p fall=2p
_ie99969 (\~WData_2 0) d2a src="99969" val0=0.0 val1=vdd valx=vdd/2 rise=2p fall=2p
_ie99970 (net056 0) d2a src="99970" val0=0.0 val1=vdd valx=vdd/2 rise=2p fall=2p
_ie99971 (net0133 0) a2d dest="99971" vl=0.3*vdd vh=0.7*vdd timex=20n
_ie99972 (\~CPU_Addr_17 0) d2a src="99972" val0=0.0 val1=vdd valx=vdd/2 rise=2p fall=2p
_ie99973 (\~CPU_Addr_18 0) d2a src="99973" val0=0.0 val1=vdd valx=vdd/2 rise=2p fall=2p
_ie99974 (\~CPU_Addr_2 0) d2a src="99974" val0=0.0 val1=vdd valx=vdd/2 rise=2p fall=2p
_ie99975 (\~CPU_Addr_16 0) d2a src="99975" val0=0.0 val1=vdd valx=vdd/2 rise=2p fall=2p
_ie99976 (\~CPU_Addr_23 0) d2a src="99976" val0=0.0 val1=vdd valx=vdd/2 rise=2p fall=2p
_ie99977 (\~WData_15 0) d2a src="99977" val0=0.0 val1=vdd valx=vdd/2 rise=2p fall=2p
_ie99978 (\~RW_0 0) d2a src="99978" val0=0.0 val1=vdd valx=vdd/2 rise=2p fall=2p
_ie99979 (\~CPU_Addr_28 0) d2a src="99979" val0=0.0 val1=vdd valx=vdd/2 rise=2p fall=2p
_ie99980 (\~CPU_Addr_12 0) d2a src="99980" val0=0.0 val1=vdd valx=vdd/2 rise=2p fall=2p
_ie99981 (\~CPU_Addr_29 0) d2a src="99981" val0=0.0 val1=vdd valx=vdd/2 rise=2p fall=2p
_ie99982 (\~CPU_Addr_13 0) d2a src="99982" val0=0.0 val1=vdd valx=vdd/2 rise=2p fall=2p
_ie99983 (\~CPU_Addr_14 0) d2a src="99983" val0=0.0 val1=vdd valx=vdd/2 rise=2p fall=2p
_ie99984 (\~CPU_Addr_5 0) d2a src="99984" val0=0.0 val1=vdd valx=vdd/2 rise=2p fall=2p
_ie99985 (\~CPU_Addr_0 0) d2a src="99985" val0=0.0 val1=vdd valx=vdd/2 rise=2p fall=2p
_ie99986 (\~CPU_Addr_31 0) d2a src="99986" val0=0.0 val1=vdd valx=vdd/2 rise=2p fall=2p
_ie99987 (\~CPU_Addr_1 0) d2a src="99987" val0=0.0 val1=vdd valx=vdd/2 rise=2p fall=2p
_ie99988 (\~CPU_Addr_9 0) d2a src="99988" val0=0.0 val1=vdd valx=vdd/2 rise=2p fall=2p
_ie99989 (\~CPU_Addr_24 0) d2a src="99989" val0=0.0 val1=vdd valx=vdd/2 rise=2p fall=2p
_ie99990 (\~CPU_Addr_10 0) d2a src="99990" val0=0.0 val1=vdd valx=vdd/2 rise=2p fall=2p
_ie99991 (\~CPU_Addr_25 0) d2a src="99991" val0=0.0 val1=vdd valx=vdd/2 rise=2p fall=2p
_ie99992 (\~CPU_Addr_32 0) d2a src="99992" val0=0.0 val1=vdd valx=vdd/2 rise=2p fall=2p
_ie99993 (net052_6 0) a2d dest="99993" vl=0.3*vdd vh=0.7*vdd timex=20n
_ie99994 (\~CPU_Addr_26 0) d2a src="99994" val0=0.0 val1=vdd valx=vdd/2 rise=2p fall=2p
_ie99995 (\~CPU_Addr_27 0) d2a src="99995" val0=0.0 val1=vdd valx=vdd/2 rise=2p fall=2p
_ie99996 (\~WData_0 0) d2a src="99996" val0=0.0 val1=vdd valx=vdd/2 rise=2p fall=2p
_ie99997 (\~Ack 0) a2d dest="99997" vl=0.3*vdd vh=0.7*vdd timex=20n
_ie99998 (\~CPU_Addr_19 0) d2a src="99998" val0=0.0 val1=vdd valx=vdd/2 rise=2p fall=2p
_ie99999 (\~Req 0) d2a src="99999" val0=0.0 val1=vdd valx=vdd/2 rise=2p fall=2p
// END Hierarchical Interface Elements
ic I17.I0.I1.I7.I0.Qb=0 I17.I0.I1.I7.I0.Q=vdd I21.I0.I0.I0.I0.I0.I1.I0.Q0=vdd I21.I0.I0.I0.I0.I0.I1.I0.Q1=0 WriteEnable=0 ReadEnable=0 net074=0 net016=0 AckT=0 net070=0 net071=0 net0105=0 net019=0 net047=0 net069=0 net0102=0 net0133=0 net056=0 net068=0 net095=0 net097=0 net090=0 net089=0 L1RE=0
simulatorOptions options temp=27
tran tran stop=10n errpreset=conservative
save I34L1RAck I34L1RE I34L1RdRegAck I34L1RdRegReq I34L1WBRegAck I34L1WBRegReq I34OutFIFOAck I34OutFIFOReq I34ReadFromL1Ack I34ReadFromL1Req I34ReadWBFromL1Ack I34ReadWBFromL1Req I32L2DataOutReq I32L2DataOutTagAck I32TagWAck I32TagWDataSel I32TagWE I32TagWrRegAck I32TagWrRegReq I32WriteToL1MissReq I32WriteToL1MissTagAck
