ADE simulation setup
Run mode: Single Run, Sweeps and Corners
Tests:
  16nm_Tests:6T_8K_MultiBank_Test:1: 16nm_Tests/6T_8K_MultiBank_Test/config, simulator spectreVerilog
  16nm_Tests:6T_8K_MultiBank_Test:2: 16nm_Tests/6T_8K_MultiBank_Test/config, simulator spectreVerilog
Global variables:
  vdd = .675
  vcc = vdd
