// Design: 16nm_Tests/6T_SNMrwh_Test
simulator lang=spectre
global 0 vdd!
parameters timeB=200n timeA=100n vdd=500m
include "/home/cadence/ncsu-FreePDK15/hspice_16nm_hp.include"

// 16nm_Tests/6T_SNMrwh_Test/schematic
V0 (nvtc 0) vsource type=pwl wave=[ 0 0 timeA vdd ]
V1 (vdd! 0) vsource type=dc dc=vdd
N4 (SNMw0 vdd! 0 0) nfet w=120n l=20n nfin=1 m=1 degradation=no
N3 (SNMr vdd! vdd! 0) nfet w=120n l=20n nfin=1 m=1 degradation=no
N2 (SNMr nvtc 0 0) nfet w=120n l=20n nfin=1 m=1 degradation=no
N1 (SNMw0 nvtc 0 0) nfet w=120n l=20n nfin=1 m=1 degradation=no
N0 (SNMh nvtc 0 0) nfet w=120n l=20n nfin=1 m=1 degradation=no
P2 (SNMr nvtc vdd! vdd!) pfet w=100n l=20n nfin=1 pd=2 m=1 degradation=yes
P1 (SNMw0 nvtc vdd! vdd!) pfet w=100n l=20n nfin=1 pd=2 m=1 degradation=yes
P0 (SNMh nvtc vdd! vdd!) pfet w=100n l=20n nfin=1 pd=2 m=1 degradation=yes
simulatorOptions options temp=30.0
mc1 montecarlo numruns=200 seed=1 variations=mismatch sampling=standard donominal=yes scalarfile="../monteCarlo/mcdata" paramfile="../monteCarlo/mcparam" savemismatchparams=no dut=[ N4 N3 N2 N1 N0 P2 P1 P0 ] paramdumpmode=yes savefamilyplots=yes savedatainseparatedir=yes wfseparation=yes {
tran tran stop=100n errpreset=conservative
}
save V0:p V0:p
