simulator( 'spectre )
design(	 "/net/kafka/nfs/rstdenis/Cadence/simulation/MCsetup_Test/spectre/schematic/netlist/netlist")
resultsDir( "/net/kafka/nfs/rstdenis/Cadence/simulation/MCsetup_Test/spectre/schematic" )
modelFile(
    '("/root/Desktop/Cadence/ncsu-FreePDK15/hspice_16nm_hp.include" "")
)
analysis('tran ?stop "10n"  ?errpreset "conservative"  )
desVar(	  "vdd" .850	)
desVar(	  "time2" 20n	)
envOption(
	'analysisOrder  list("tran")
)
option(	'multithread  "on"
)
save( 'i "/V0/MINUS" )
converge( 'ic "/in" "0" )
temp( 27 )
run()
selectResult( 'tran )
plot(getData("/in") getData("/Y") getData("/V0/MINUS") )
modelFile(
    '("/root/Desktop/Cadence/ncsu-FreePDK15/hspice_16nm_hp.include" "")
)
run()
selectResult( 'tran )
plot(getData("/in") getData("/Y") getData("/V0/MINUS") )
modelFile(
    '("/root/Desktop/Cadence/ncsu-FreePDK15/hspice_16nm_hp.include" "")
)
run()
selectResult( 'tran )
plot(getData("/in") getData("/Y") getData("/V0/MINUS") )
modelFile(
    '("/root/Desktop/Cadence/ncsu-FreePDK15/hspice_16nm_hp.include" "")
)
run()
selectResult( 'tran )
plot(getData("/in") getData("/Y") getData("/V0/MINUS") )
modelFile(
    '("/root/Desktop/Cadence/ncsu-FreePDK15/hspice_16nm_hp.include" "")
)
run()
selectResult( 'tran )
plot(getData("/in") getData("/Y") getData("/V0/MINUS") )
modelFile(
    '("/root/Desktop/Cadence/ncsu-FreePDK15/hspice_16nm_hp.include" "")
)
desVar(	  "time2" 5n	)
run()
selectResult( 'tran )
plot(getData("/in") getData("/Y") getData("/V0/MINUS") )
modelFile(
    '("/root/Desktop/Cadence/ncsu-FreePDK15/hspice_16nm_hp.include" "")
)
saveSubckt( "/I0" ?voltage t ?current t ?power t )
saveOpPoint( "/I0/M1" ?operatingPoints "vth" )
saveOpPoint( "/I0/M0" ?operatingPoints "vth" )
run()
selectResult( 'tran )
plot(getData("/in") getData("/Y") getData("/V0/MINUS") )
modelFile(
    '("/root/Desktop/Cadence/ncsu-FreePDK15/hspice_16nm_hp.include" "")
)
run()
selectResult( 'tran )
plot(getData("/in") getData("/Y") getData("/V0/MINUS") )
modelFile(
    '("/root/Desktop/Cadence/ncsu-FreePDK15/hspice_16nm_hp.include" "")
)
desVar(	  "vdd" .500	)
saveSubckt( "/I0" ?voltage t ?current t ?power t )
run()
selectResult( 'tran )
plot(getData("/in") getData("/Y") getData("/V0/MINUS") )
modelFile(
    '("/root/Desktop/Cadence/ncsu-FreePDK15/hspice_16nm_hp.include" "")
)
desVar(	  "vddp" "-vdd"	)
run()
selectResult( 'tran )
plot(getData("/in") getData("/Y") getData("/V0/MINUS") )
modelFile(
    '("/root/Desktop/Cadence/ncsu-FreePDK15/hspice_16nm_hp.include" "")
)
delete( 'desVar "vddp" )
run()
selectResult( 'tran )
plot(getData("/in") getData("/Y") getData("/V0/MINUS") )
modelFile(
    '("/root/Desktop/Cadence/ncsu-FreePDK15/hspice_16nm_hp.include" "")
)
desVar(	  "vdd" .850	)
run()
selectResult( 'tran )
plot(getData("/in") getData("/Y") getData("/V0/MINUS") )
modelFile(
    '("/root/Desktop/Cadence/ncsu-FreePDK15/hspice_16nm_hp.include" "")
)
run()
selectResult( 'tran )
plot(getData("/in") getData("/Y") getData("/V0/MINUS") )
modelFile(
    '("/root/Desktop/Cadence/ncsu-FreePDK15/hspice_16nm_hp.include" "")
)
desVar(	  "vdd" .500	)
run()
selectResult( 'tran )
plot(getData("/in") getData("/Y") getData("/V0/MINUS") )
modelFile(
    '("/root/Desktop/Cadence/ncsu-FreePDK15/hspice_16nm_hp.include" "")
)
run()
selectResult( 'tran )
plot(getData("/in") getData("/Y") getData("/V0/MINUS") )
modelFile(
    '("/root/Desktop/Cadence/ncsu-FreePDK15/hspice_16nm_hp.include" "")
)
run()
selectResult( 'tran )
plot(getData("/in") getData("/Y") getData("/V0/MINUS") )
modelFile(
    '("/root/Desktop/Cadence/ncsu-FreePDK15/hspice_16nm_hp.include" "")
)
run()
selectResult( 'tran )
plot(getData("/in") getData("/Y") getData("/V0/MINUS") )
modelFile(
    '("/root/Desktop/Cadence/ncsu-FreePDK15/hspice_16nm_hp.include" "")
)
run()
selectResult( 'tran )
plot(getData("/in") getData("/Y") getData("/V0/MINUS") )
modelFile(
    '("/root/Desktop/Cadence/ncsu-FreePDK15/hspice_16nm_hp.include" "")
)
run()
selectResult( 'tran )
plot(getData("/in") getData("/Y") getData("/V0/MINUS") )
modelFile(
    '("/root/Desktop/Cadence/ncsu-FreePDK15/hspice_16nm_hp.include" "")
)
run()
selectResult( 'tran )
plot(getData("/in") getData("/Y") getData("/V0/MINUS") )
modelFile(
    '("/root/Desktop/Cadence/ncsu-FreePDK15/hspice_16nm_hp.include" "")
)
run()
selectResult( 'tran )
plot(getData("/in") getData("/Y") getData("/V0/MINUS") )
modelFile(
    '("/root/Desktop/Cadence/ncsu-FreePDK15/hspice_16nm_hp.include" "")
)
run()
selectResult( 'tran )
plot(getData("/in") getData("/Y") getData("/V0/MINUS") )
modelFile(
    '("/root/Desktop/Cadence/ncsu-FreePDK15/hspice_16nm_hp.include" "")
)
run()
selectResult( 'tran )
plot(getData("/in") getData("/Y") getData("/V0/MINUS") )
modelFile(
    '("/root/Desktop/Cadence/ncsu-FreePDK15/hspice_16nm_hp.include" "")
)
run()
selectResult( 'tran )
plot(getData("/in") getData("/Y") getData("/V0/MINUS") )
modelFile(
    '("/root/Desktop/Cadence/ncsu-FreePDK15/hspice_16nm_hp.include" "")
)
run()
selectResult( 'tran )
plot(getData("/in") getData("/Y") getData("/V0/MINUS") )
modelFile(
    '("/root/Desktop/Cadence/ncsu-FreePDK15/hspice_16nm_hp.include" "")
)
run()
selectResult( 'tran )
plot(getData("/in") getData("/Y") getData("/V0/MINUS") )
modelFile(
    '("/root/Desktop/Cadence/ncsu-FreePDK15/hspice_16nm_hp.include" "")
)
run()
selectResult( 'tran )
plot(getData("/in") getData("/Y") getData("/V0/MINUS") )
modelFile(
    '("/root/Desktop/Cadence/ncsu-FreePDK15/hspice_16nm_hp.include" "")
)
run()
selectResult( 'tran )
plot(getData("/in") getData("/Y") getData("/V0/MINUS") )
modelFile(
    '("/root/Desktop/Cadence/ncsu-FreePDK15/hspice_16nm_hp.include" "")
)
run()
selectResult( 'tran )
plot(getData("/in") getData("/Y") getData("/V0/MINUS") )
modelFile(
    '("/root/Desktop/Cadence/ncsu-FreePDK15/hspice_16nm_hp.include" "")
)
run()
selectResult( 'tran )
plot(getData("/in") getData("/Y") getData("/V0/MINUS") )
modelFile(
    '("/root/Desktop/Cadence/ncsu-FreePDK15/hspice_16nm_hp.include" "")
)
run()
selectResult( 'tran )
plot(getData("/in") getData("/Y") getData("/V0/MINUS") )
modelFile(
    '("/root/Desktop/Cadence/ncsu-FreePDK15/hspice_16nm_hp.include" "")
)
run()
selectResult( 'tran )
plot(getData("/in") getData("/Y") getData("/V0/MINUS") )
modelFile(
    '("/root/Desktop/Cadence/ncsu-FreePDK15/hspice_16nm_hp.include" "")
)
run()
selectResult( 'tran )
plot(getData("/in") getData("/Y") getData("/V0/MINUS") )
modelFile(
    '("/root/Desktop/Cadence/ncsu-FreePDK15/hspice_16nm_hp.include" "")
)
run()
selectResult( 'tran )
plot(getData("/in") getData("/Y") getData("/V0/MINUS") )
modelFile(
    '("/root/Desktop/Cadence/ncsu-FreePDK15/hspice_16nm_hp.include" "")
)
run()
selectResult( 'tran )
plot(getData("/in") getData("/Y") getData("/V0/MINUS") )
modelFile(
    '("/root/Desktop/Cadence/ncsu-FreePDK15/hspice_16nm_hp.include" "")
)
run()
selectResult( 'tran )
plot(getData("/in") getData("/Y") getData("/V0/MINUS") )
modelFile(
    '("/root/Desktop/Cadence/ncsu-FreePDK15/hspice_16nm_hp.include" "")
)
run()
selectResult( 'tran )
plot(getData("/in") getData("/Y") getData("/V0/MINUS") )
modelFile(
    '("/root/Desktop/Cadence/ncsu-FreePDK15/hspice_16nm_hp.include" "")
)
run()
selectResult( 'tran )
plot(getData("/in") getData("/Y") getData("/V0/MINUS") )
modelFile(
    '("/root/Desktop/Cadence/ncsu-FreePDK15/hspice_16nm_hp.include" "")
)
run()
selectResult( 'tran )
plot(getData("/in") getData("/Y") getData("/V0/MINUS") )
modelFile(
    '("/root/Desktop/Cadence/ncsu-FreePDK15/hspice_16nm_hp.include" "")
)
run()
selectResult( 'tran )
plot(getData("/in") getData("/Y") getData("/V0/MINUS") )
modelFile(
    '("/root/Desktop/Cadence/ncsu-FreePDK15/hspice_16nm_hp.include" "")
)
run()
selectResult( 'tran )
plot(getData("/in") getData("/Y") getData("/V0/MINUS") )
modelFile(
    '("/root/Desktop/Cadence/ncsu-FreePDK15/hspice_16nm_hp.include" "")
)
run()
selectResult( 'tran )
plot(getData("/in") getData("/Y") getData("/V0/MINUS") )
modelFile(
    '("/root/Desktop/Cadence/ncsu-FreePDK15/hspice_16nm_hp.include" "")
)
run()
selectResult( 'tran )
plot(getData("/in") getData("/Y") getData("/V0/MINUS") )
modelFile(
    '("/root/Desktop/Cadence/ncsu-FreePDK15/hspice_16nm_hp.include" "")
)
desVar(	  "pvtMC" 0	)
desVar(	  "nvtMC" 0	)
saveSubckt( "/I0" ?voltage t ?current t ?power t )
run()
selectResult( 'tran )
plot(getData("/in") getData("/Y") getData("/V0/MINUS") )
modelFile(
    '("/root/Desktop/Cadence/ncsu-FreePDK15/hspice_16nm_hp.include" "")
)
desVar(	  "pvtMC" .5	)
desVar(	  "nvtMC" .5	)
run()
selectResult( 'tran )
plot(getData("/in") getData("/Y") getData("/V0/MINUS") )
modelFile(
    '("/root/Desktop/Cadence/ncsu-FreePDK15/hspice_16nm_hp.include" "")
)
run()
selectResult( 'tran )
plot(getData("/in") getData("/Y") getData("/V0/MINUS") )
modelFile(
    '("/root/Desktop/Cadence/ncsu-FreePDK15/hspice_16nm_hp.include" "")
)
delete( 'desVar "pvtMC" )
delete( 'desVar "nvtMC" )
saveSubckt( "/I0" ?voltage t ?current t ?power t )
run()
selectResult( 'tran )
plot(getData("/in") getData("/Y") getData("/V0/MINUS") )
