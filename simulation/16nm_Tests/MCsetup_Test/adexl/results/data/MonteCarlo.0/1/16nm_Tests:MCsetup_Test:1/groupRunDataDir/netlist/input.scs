// Design: 16nm_Tests/MCsetup_Test
simulator lang=spectre
global 0 vdd!
parameters ndvtshift=0 pdvtshift=0 time2=5n vdd=.500
include "/root/Desktop/Cadence/ncsu-FreePDK15/PTM-MG/smodels.scs"

// 16nm/inv_1x/schematic
subckt inv_1x A Y
    M0 (Y A 0 0) nfet w=60n l=20n nfin=1 nf=1 dvtshift=ndvtshift m=1
    M1 (Y A vdd! vdd!) pfet w=100n l=20n nfin=1 nf=1 dvtshift=pdvtshift m=1
ends inv_1x

// 16nm_Tests/MCsetup_Test/schematic
I0 (in Y) inv_1x
V1 (in 0) vsource type=pwl mag=0 phase=0 wave=[ 0 0 time2 vdd ]
V0 (vdd! 0) vsource type=dc dc=vdd
simulatorOptions options temp=30.0
mc1 montecarlo numruns=200 seed=1 variations=all sampling=lhs numbins=200 donominal=yes scalarfile="../monteCarlo/mcdata" paramfile="../monteCarlo/mcparam" saveprocessparams=yes processparamfile="../monteCarlo/processParam" processscalarfile="../monteCarlo/processData" savemismatchparams=yes dependencymapfile="../monteCarlo/mismatchdependency" dumpdependency=mismatch dependencyscalarfile="../monteCarlo/compactmismatchdata" dependencyparamfile="../monteCarlo/compactmismatchparam" dut=[ I0.M0 I0.M1 ] paramdumpmode=yes savefamilyplots=yes savedatainseparatedir=yes wfseparation=yes {
tran tran stop=12n errpreset=conservative
}
mcOptions options genmcdep=yes
save V0:p Y
