simulator( 'spectre )
design(	 "/net/kafka/nfs/rstdenis/Cadence/simulation/16nm_Tests/MCsetup_Test/adexl/results/data/MonteCarlo.2/1/16nm_Tests:MCsetup_Test:1/groupRunDataDir/netlist/netlist")
resultsDir( "/net/kafka/nfs/rstdenis/Cadence/simulation/16nm_Tests/MCsetup_Test/adexl/results/data/MonteCarlo.2/1/16nm_Tests:MCsetup_Test:1/groupRunDataDir" )
modelFile(
    '("/root/Desktop/Cadence/ncsu-FreePDK15/PTM-MG/Spectre/FinFETS.scs" "NN")
    '("/root/Desktop/Cadence/ncsu-FreePDK15/PTM-MG/Spectre/FinFETS.scs" "MCStats")
)
analysis('tran ?stop "12n"  ?errpreset "conservative"  )
desVar(	  "vdd" .500	)
desVar(	  "time2" 5n	)
desVar(	  "ndvtshift" 0	)
desVar(	  "pdvtshift" 0	)
envOption(
	'firstRun  t
	'cmd64bit  t
	'autoDisplay  nil
	'userCmdLineOption  " +spice -ahdloutdir /net/kafka/nfs/rstdenis/Cadence/simulation/16nm_Tests/MCsetup_Test/adexl/results/data/MonteCarlo.2/sharedData/Job3/ahdl/input.ahdlSimDB"
	'analysisOrder  list("tran" "pz" "dcmatch" "stb" "envlp" "ac" "dc" "lf" "noise" "xf" "sp" "pss" "pac" "pstb" "pnoise" "pxf" "psp" "qpss" "qpac" "qpnoise" "qpxf" "qpsp" "hb" "hbac" "hbnoise" "sens")
)
option(	'multithread  "on"
	'temp  "30.0"
)
save( 'v "/Y" )
save( 'i "/V0/MINUS" )
temp( 30.0 )
run()
selectResult( 'tran )
plot(getData("/V0/MINUS") getData("/Y") )
plot( OP("/I0/M1" "vth") )
plot( OP("/I0/M0" "vth") )
