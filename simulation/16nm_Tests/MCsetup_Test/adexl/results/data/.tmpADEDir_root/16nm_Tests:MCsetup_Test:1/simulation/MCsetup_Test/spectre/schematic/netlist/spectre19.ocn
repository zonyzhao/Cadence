simulator( 'spectre )
design(	 "/net/kafka/nfs/rstdenis/Cadence/simulation/16nm_Tests/MCsetup_Test/adexl/results/data/.tmpADEDir_root/16nm_Tests:MCsetup_Test:1/16nm_Tests_MCsetup_Test_schematic_spectre/netlist/netlist")
resultsDir( "/net/kafka/nfs/rstdenis/Cadence/simulation/16nm_Tests/MCsetup_Test/adexl/results/data/.tmpADEDir_root/16nm_Tests:MCsetup_Test:1/simulation/MCsetup_Test/spectre/schematic" )
modelFile(
    '("/root/Desktop/Cadence/ncsu-FreePDK15/PTM-MG/smodels.scs" "")
)
analysis('tran ?stop "12n"  ?errpreset "conservative"  )
desVar(	  "vdd" .500	)
desVar(	  "time2" 5n	)
desVar(	  "pdvtshift" 0	)
desVar(	  "ndvtshift" 0	)
envOption(
	'cmd64bit  t
	'userCmdLineOption  "+spice"
	'analysisOrder  list("tran")
)
option(	'multithread  "on"
	'temp  "30.0"
)
save( 'v "/Y" )
save( 'i "/V0/MINUS" )
temp( 30.0 )
run()
selectResult( 'tran )
plot(getData("/V0/MINUS") getData("/Y") )
plot( pv("I0.M0.mnfet" "vth" ?result "tranOp") )
modelFile(
    '("/root/Desktop/Cadence/ncsu-FreePDK15/PTM-MG/smodels.scs" "")
)
run()
selectResult( 'tran )
plot(getData("/V0/MINUS") getData("/Y") )
plot( pv("I0.M0.mnfet" "vth" ?result "tranOp") )
modelFile(
    '("/root/Desktop/Cadence/ncsu-FreePDK15/PTM-MG/smodels.scs" "")
)
run()
selectResult( 'tran )
plot(getData("/V0/MINUS") getData("/Y") )
plot( pv("I0.M0.mnfet" "vth" ?result "tranOp") )
modelFile(
    '("/root/Desktop/Cadence/ncsu-FreePDK15/PTM-MG/smodels.scs" "")
)
run()
selectResult( 'tran )
plot(getData("/V0/MINUS") getData("/Y") )
plot( pv("I0.M0.mnfet" "vth" ?result "tranOp") )
modelFile(
    '("/root/Desktop/Cadence/ncsu-FreePDK15/PTM-MG/smodels.scs" "")
)
run()
selectResult( 'tran )
plot(getData("/V0/MINUS") getData("/Y") )
plot( pv("I0.M0.mnfet" "vth" ?result "tranOp") )
modelFile(
    '("/root/Desktop/Cadence/ncsu-FreePDK15/hspice_16nm_hp.include" "")
)
run()
selectResult( 'tran )
plot(getData("/V0/MINUS") getData("/Y") )
plot( pv("I0.M0.mnfet" "vth" ?result "tranOp") )
modelFile(
    '("/root/Desktop/Cadence/ncsu-FreePDK15/hspice_16nm_hp.include" "")
)
run()
selectResult( 'tran )
plot(getData("/V0/MINUS") getData("/Y") )
plot( pv("I0.M0.mnfet" "vth" ?result "tranOp") )
modelFile(
    '("/root/Desktop/Cadence/ncsu-FreePDK15/PTM-MG/smodels.scs" "")
)
run()
selectResult( 'tran )
plot(getData("/V0/MINUS") getData("/Y") )
plot( pv("I0.M0.mnfet" "vth" ?result "tranOp") )
modelFile(
    '("/root/Desktop/Cadence/ncsu-FreePDK15/PTM-MG/smodels.scs" "")
)
run()
selectResult( 'tran )
plot(getData("/V0/MINUS") getData("/Y") )
plot( pv("I0.M0.mnfet" "vth" ?result "tranOp") )
modelFile(
    '("/root/Desktop/Cadence/ncsu-FreePDK15/PTM-MG/smodels.scs" "")
)
run()
selectResult( 'tran )
plot(getData("/V0/MINUS") getData("/Y") )
plot( pv("I0.M0.mnfet" "vth" ?result "tranOp") )
modelFile(
    '("/root/Desktop/Cadence/ncsu-FreePDK15/PTM-MG/smodels.scs" "")
)
run()
selectResult( 'tran )
plot(getData("/V0/MINUS") getData("/Y") )
plot( pv("I0.M0.mnfet" "vth" ?result "tranOp") )
modelFile(
    '("/root/Desktop/Cadence/ncsu-FreePDK15/PTM-MG/smodels.scs" "")
)
run()
selectResult( 'tran )
plot(getData("/V0/MINUS") getData("/Y") )
plot( pv("I0.M0.mnfet" "vth" ?result "tranOp") )
modelFile(
    '("/root/Desktop/Cadence/ncsu-FreePDK15/PTM-MG/smodels.scs" "")
)
run()
selectResult( 'tran )
plot(getData("/V0/MINUS") getData("/Y") )
plot( pv("I0.M0.mnfet" "vth" ?result "tranOp") )
modelFile(
    '("/root/Desktop/Cadence/ncsu-FreePDK15/PTM-MG/smodels.scs" "")
)
run()
selectResult( 'tran )
plot(getData("/V0/MINUS") getData("/Y") )
plot( pv("I0.M0.mnfet" "vth" ?result "tranOp") )
modelFile(
    '("/root/Desktop/Cadence/ncsu-FreePDK15/PTM-MG/smodels.scs" "")
)
run()
selectResult( 'tran )
plot(getData("/V0/MINUS") getData("/Y") )
plot( pv("I0.M0.mnfet" "vth" ?result "tranOp") )
modelFile(
    '("/root/Desktop/Cadence/ncsu-FreePDK15/PTM-MG/smodels.scs" "")
)
run()
selectResult( 'tran )
plot(getData("/V0/MINUS") getData("/Y") )
plot( pv("I0.M0.mnfet" "vth" ?result "tranOp") )
modelFile(
    '("/root/Desktop/Cadence/ncsu-FreePDK15/PTM-MG/smodels.scs" "")
)
run()
selectResult( 'tran )
plot(getData("/V0/MINUS") getData("/Y") )
plot( pv("I0.M0.mnfet" "vth" ?result "tranOp") )
modelFile(
    '("/root/Desktop/Cadence/ncsu-FreePDK15/PTM-MG/smodels.scs" "")
)
run()
selectResult( 'tran )
plot(getData("/V0/MINUS") getData("/Y") )
plot( pv("I0.M0.mnfet" "vth" ?result "tranOp") )
modelFile(
    '("/root/Desktop/Cadence/ncsu-FreePDK15/PTM-MG/smodels.scs" "")
)
run()
selectResult( 'tran )
plot(getData("/V0/MINUS") getData("/Y") )
plot( pv("I0.M0.mnfet" "vth" ?result "tranOp") )
modelFile(
    '("/root/Desktop/Cadence/ncsu-FreePDK15/PTM-MG/smodels.scs" "")
)
run()
selectResult( 'tran )
plot(getData("/V0/MINUS") getData("/Y") )
plot( pv("I0.M0.mnfet" "vth" ?result "tranOp") )
modelFile(
    '("/root/Desktop/Cadence/ncsu-FreePDK15/PTM-MG/smodels.scs" "")
)
run()
selectResult( 'tran )
plot(getData("/V0/MINUS") getData("/Y") )
plot( pv("I0.M0.mnfet" "vth" ?result "tranOp") )
modelFile(
    '("/root/Desktop/Cadence/ncsu-FreePDK15/PTM-MG/smodels.scs" "")
)
run()
selectResult( 'tran )
plot(getData("/V0/MINUS") getData("/Y") )
plot( pv("I0.M0.mnfet" "vth" ?result "tranOp") )
resultsDir( "/net/kafka/nfs/rstdenis/Cadence/simulation/16nm_Tests/MCsetup_Test/adexl/results/data/MonteCarlo.4/psf/16nm_Tests:MCsetup_Test:1" )
modelFile(
    '("/root/Desktop/Cadence/ncsu-FreePDK15/PTM-MG/smodels.scs" "")
)
run()
selectResult( 'tran )
plot(getData("/V0/MINUS") getData("/Y") )
plot( OP("/I0/M1" "vth") )
modelFile(
    '("/root/Desktop/Cadence/ncsu-FreePDK15/PTM-MG/smodels.scs" "")
)
run()
selectResult( 'tran )
plot(getData("/V0/MINUS") getData("/Y") )
plot( OP("/I0/M1" "vth") )
plot( OP("/I0/M0" "vth") )
modelFile(
    '("/root/Desktop/Cadence/ncsu-FreePDK15/PTM-MG/smodels.scs" "")
)
delete( 'desVar "pdvtshift" )
delete( 'desVar "ndvtshift" )
run()
selectResult( 'tran )
plot(getData("/V0/MINUS") getData("/Y") )
plot( OP("/I0/M1" "vth") )
plot( OP("/I0/M0" "vth") )
