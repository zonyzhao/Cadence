simulator( 'spectre )
design(	 "/net/kafka/nfs/rstdenis/Cadence/simulation/16nm_Tests/MCsetup_Test/adexl/results/data/.tmpADEDir_root/16nm_Tests:MCsetup_Test:1/16nm_Tests_MCsetup_Test_schematic_spectre/netlist/netlist")
resultsDir( "/net/kafka/nfs/rstdenis/Cadence/simulation/16nm_Tests/MCsetup_Test/adexl/results/data/.tmpADEDir_root/16nm_Tests:MCsetup_Test:1/simulation/MCsetup_Test/spectre/schematic" )
modelFile(
    '("/root/Desktop/Cadence/ncsu-FreePDK15/PTM-MG/Spectre/FinFETS.scs" "NN")
    '("/root/Desktop/Cadence/ncsu-FreePDK15/PTM-MG/Spectre/FinFETS.scs" "MCStats")
)
analysis('tran ?stop "12n"  ?errpreset "conservative"  )
desVar(	  "vdd" .500	)
desVar(	  "time2" 5n	)
envOption(
	'cmd64bit  t
	'userCmdLineOption  "+spice"
	'analysisOrder  list("tran")
)
option(	'multithread  "on"
	'temp  "30.0"
)
save( 'v "/Y" )
save( 'i "/V0/MINUS" )
temp( 30.0 )
run()
selectResult( 'tran )
plot(getData("/V0/MINUS") getData("/Y") )
plot( OP("/I0/M1" "vth") )
plot( OP("/I0/M0" "vth") )
modelFile(
    '("/root/Desktop/Cadence/ncsu-FreePDK15/PTM-MG/Spectre/FinFETS.scs" "NN")
    '("/root/Desktop/Cadence/ncsu-FreePDK15/PTM-MG/Spectre/FinFETS.scs" "MCStats")
)
run()
selectResult( 'tran )
plot(getData("/V0/MINUS") getData("/Y") )
plot( OP("/I0/M1" "vth") )
plot( OP("/I0/M0" "vth") )
resultsDir( "/net/kafka/nfs/rstdenis/Cadence/simulation/16nm_Tests/MCsetup_Test/adexl/results/data/MonteCarlo.1/psf/16nm_Tests:MCsetup_Test:1" )
modelFile(
    '("/root/Desktop/Cadence/ncsu-FreePDK15/PTM-MG/Spectre/FinFETS.scs" "NN")
    '("/root/Desktop/Cadence/ncsu-FreePDK15/PTM-MG/Spectre/FinFETS.scs" "MCStats")
)
run()
selectResult( 'tran )
plot(getData("/V0/MINUS") getData("/Y") )
plot( OP("/I0/M1" "vth") )
plot( OP("/I0/M0" "vth") )
resultsDir( "/net/kafka/nfs/rstdenis/Cadence/simulation/16nm_Tests/MCsetup_Test/adexl/results/data/MonteCarlo.3/psf/16nm_Tests:MCsetup_Test:1" )
modelFile(
    '("/root/Desktop/Cadence/ncsu-FreePDK15/PTM-MG/Spectre/FinFETS.scs" "")
)
run()
selectResult( 'tran )
plot(getData("/V0/MINUS") getData("/Y") )
plot( OP("/I0/M1" "vth") )
plot( OP("/I0/M0" "vth") )
