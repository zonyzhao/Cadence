simulator( 'spectre )
design(	 "/net/kafka/nfs/rstdenis/Cadence/simulation/16nm_Tests/MCsetup_Test/adexl/results/data/.tmpADEDir_root/16nm_Tests:MCsetup_Test:1/16nm_Tests_MCsetup_Test_schematic_spectre/netlist/netlist")
resultsDir( "/net/kafka/nfs/rstdenis/Cadence/simulation/16nm_Tests/MCsetup_Test/adexl/results/data/.tmpADEDir_root/16nm_Tests:MCsetup_Test:1/simulation/MCsetup_Test/spectre/schematic" )
modelFile(
    '("./ncsu-FreePDK15/hspice_16nm_hp.include" "")
    '("/root/Desktop/Cadence/ncsu-FreePDK15/PTM-MG/stats.scs" "")
)
analysis('tran ?stop "12n"  ?errpreset "conservative"  )
desVar(	  "vdd" .500	)
desVar(	  "time2" 5n	)
envOption(
	'analysisOrder  list("tran")
)
option(	'multithread  "on"
)
save( 'i "/V0/MINUS" )
run()
selectResult( 'tran )
plot(getData("/in") getData("/Y") getData("/V0/MINUS") )
modelFile(
    '("./ncsu-FreePDK15/hspice_16nm_hp.include" "")
    '("/root/Desktop/Cadence/ncsu-FreePDK15/PTM-MG/stats.scs" "")
)
run()
selectResult( 'tran )
plot(getData("/in") getData("/Y") getData("/V0/MINUS") )
modelFile(
    '("./ncsu-FreePDK15/hspice_16nm_hp.include" "")
    '("/root/Desktop/Cadence/ncsu-FreePDK15/PTM-MG/stats.scs" "")
)
run()
selectResult( 'tran )
plot(getData("/in") getData("/Y") getData("/V0/MINUS") )
modelFile(
    '("./ncsu-FreePDK15/hspice_16nm_hp.include" "")
    '("/root/Desktop/Cadence/ncsu-FreePDK15/PTM-MG/stats.scs" "")
)
run()
selectResult( 'tran )
plot(getData("/in") getData("/Y") getData("/V0/MINUS") )
modelFile(
    '("/root/Desktop/Cadence/ncsu-FreePDK15/hspice_16nm_hp.include" "")
    '("/root/Desktop/Cadence/ncsu-FreePDK15/PTM-MG/stats.scs" "")
)
run()
selectResult( 'tran )
plot(getData("/in") getData("/Y") getData("/V0/MINUS") )
modelFile(
    '("/root/Desktop/Cadence/ncsu-FreePDK15/hspice_16nm_hp.include" "")
    '("/root/Desktop/Cadence/ncsu-FreePDK15/PTM-MG/stats.scs" "")
)
run()
selectResult( 'tran )
plot(getData("/in") getData("/Y") getData("/V0/MINUS") )
modelFile(
    '("/root/Desktop/Cadence/ncsu-FreePDK15/hspice_16nm_hp.include" "")
    '("/root/Desktop/Cadence/ncsu-FreePDK15/PTM-MG/stats.scs" "")
)
run()
selectResult( 'tran )
plot(getData("/in") getData("/Y") getData("/V0/MINUS") )
modelFile(
    '("/root/Desktop/Cadence/ncsu-FreePDK15/hspice_16nm_hp.include" "")
    '("/root/Desktop/Cadence/ncsu-FreePDK15/PTM-MG/stats.scs" "")
)
run()
selectResult( 'tran )
plot(getData("/in") getData("/Y") getData("/V0/MINUS") )
modelFile(
    '("/root/Desktop/Cadence/ncsu-FreePDK15/hspice_16nm_hp.include" "")
    '("/root/Desktop/Cadence/ncsu-FreePDK15/PTM-MG/stats.scs" "")
)
run()
selectResult( 'tran )
plot(getData("/in") getData("/Y") getData("/V0/MINUS") )
modelFile(
    '("/root/Desktop/Cadence/ncsu-FreePDK15/hspice_16nm_hp.include" "")
    '("/root/Desktop/Cadence/ncsu-FreePDK15/PTM-MG/stats.scs" "")
)
run()
selectResult( 'tran )
plot(getData("/in") getData("/Y") getData("/V0/MINUS") )
modelFile(
    '("/root/Desktop/Cadence/ncsu-FreePDK15/hspice_16nm_hp.include" "")
    '("/root/Desktop/Cadence/ncsu-FreePDK15/PTM-MG/stats.scs" "")
)
run()
selectResult( 'tran )
plot(getData("/in") getData("/Y") getData("/V0/MINUS") )
modelFile(
    '("/root/Desktop/Cadence/ncsu-FreePDK15/hspice_16nm_hp.include" "")
    '("/root/Desktop/Cadence/ncsu-FreePDK15/PTM-MG/stats.scs" "")
)
run()
selectResult( 'tran )
plot(getData("/in") getData("/Y") getData("/V0/MINUS") )
modelFile(
    '("/root/Desktop/Cadence/ncsu-FreePDK15/hspice_16nm_hp.include" "")
    '("/root/Desktop/Cadence/ncsu-FreePDK15/PTM-MG/stats.scs" "")
)
run()
selectResult( 'tran )
plot(getData("/in") getData("/Y") getData("/V0/MINUS") )
resultsDir( "/net/kafka/nfs/rstdenis/Cadence/simulation/16nm_Tests/MCsetup_Test/adexl/results/data/MonteCarlo.0/psf/16nm_Tests:MCsetup_Test:1" )
modelFile(
    '("/root/Desktop/Cadence/ncsu-FreePDK15/hspice_16nm_hp.include" "")
    '("/root/Desktop/Cadence/ncsu-FreePDK15/PTM-MG/stats.scs" "")
)
saveSubckt( "/I0" ?voltage t ?current t ?power t )
saveOpPoint( "/I0/M1" )
saveOpPoint( "/I0/M0" )
run()
selectResult( 'tran )
plot(getData("/Y") getData("/V0/MINUS") )
modelFile(
    '("/root/Desktop/Cadence/ncsu-FreePDK15/hspice_16nm_hp.include" "")
    '("/root/Desktop/Cadence/ncsu-FreePDK15/PTM-MG/stats.scs" "")
)
saveSubckt( "/I0" ?voltage t ?current t ?power t )
saveOpPoint( "/I0/M1" ?operatingPoints "vth" )
saveOpPoint( "/I0/M0" ?operatingPoints "vth" )
run()
selectResult( 'tran )
plot(getData("/Y") getData("/V0/MINUS") )
modelFile(
    '("/root/Desktop/Cadence/ncsu-FreePDK15/hspice_16nm_hp.include" "")
    '("/root/Desktop/Cadence/ncsu-FreePDK15/PTM-MG/stats.scs" "")
)
run()
selectResult( 'tran )
plot(getData("/Y") getData("/V0/MINUS") )
modelFile(
    '("/root/Desktop/Cadence/ncsu-FreePDK15/hspice_16nm_hp.include" "")
    '("/root/Desktop/Cadence/ncsu-FreePDK15/PTM-MG/stats.scs" "")
)
run()
selectResult( 'tran )
plot(getData("/Y") getData("/V0/MINUS") )
plot( OPT("/I0/M1" "vth") )
modelFile(
    '("/root/Desktop/Cadence/ncsu-FreePDK15/hspice_16nm_hp.include" "")
    '("/root/Desktop/Cadence/ncsu-FreePDK15/PTM-MG/stats.scs" "")
)
run()
selectResult( 'tran )
plot(getData("/Y") getData("/V0/MINUS") )
plot( pv("I0.M0.mnfet" "vth" ?result "tranOp") )
