// This is the Cadence AMS Designer(R) analog simulation control file.
// It specifies the options and analyses for the UltraSim analog solver.

simulator lang=spectre

global 0 vdd! vcc!

ic MC_6TWrite_Test.B1\[3\]=0 MC_6TWrite_Test.B1\[2\]=0 \
MC_6TWrite_Test.B1\[1\]=0 MC_6TWrite_Test.B1\[0\]=0 \
MC_6TWrite_Test.B0\[3\]=0 MC_6TWrite_Test.B0\[2\]=0 \
MC_6TWrite_Test.B0\[1\]=0 MC_6TWrite_Test.B0\[0\]=0 \
MC_6TWrite_Test.W1\[3\]=0 MC_6TWrite_Test.W1\[2\]=0 \
MC_6TWrite_Test.W1\[1\]=0 MC_6TWrite_Test.W1\[0\]=0 \
MC_6TWrite_Test.W0\[3\]=0 MC_6TWrite_Test.W0\[2\]=0 \
MC_6TWrite_Test.W0\[1\]=0 MC_6TWrite_Test.W0\[0\]=0 MC_6TWrite_Test.Go=0 \
MC_6TWrite_Test.A\[16\]=0 MC_6TWrite_Test.A\[15\]=0 \
MC_6TWrite_Test.A\[14\]=0 MC_6TWrite_Test.A\[13\]=0 \
MC_6TWrite_Test.A\[12\]=0 MC_6TWrite_Test.A\[11\]=0 \
MC_6TWrite_Test.A\[10\]=0 MC_6TWrite_Test.A\[9\]=0 \
MC_6TWrite_Test.A\[8\]=0 MC_6TWrite_Test.A\[7\]=0 MC_6TWrite_Test.A\[6\]=0 \
MC_6TWrite_Test.A\[5\]=0 MC_6TWrite_Test.A\[4\]=0 MC_6TWrite_Test.A\[3\]=0 \
MC_6TWrite_Test.A\[2\]=0 MC_6TWrite_Test.A\[1\]=0 MC_6TWrite_Test.A\[0\]=0 \
MC_6TWrite_Test.Aline\[63\]=0 MC_6TWrite_Test.Aline\[62\]=0 \
MC_6TWrite_Test.Aline\[61\]=0 MC_6TWrite_Test.Aline\[60\]=0 \
MC_6TWrite_Test.Aline\[59\]=0 MC_6TWrite_Test.Aline\[58\]=0 \
MC_6TWrite_Test.Aline\[57\]=0 MC_6TWrite_Test.Aline\[56\]=0 \
MC_6TWrite_Test.Aline\[55\]=0 MC_6TWrite_Test.Aline\[54\]=0 \
MC_6TWrite_Test.Aline\[53\]=0 MC_6TWrite_Test.Aline\[52\]=0 \
MC_6TWrite_Test.Aline\[51\]=0 MC_6TWrite_Test.Aline\[50\]=0 \
MC_6TWrite_Test.Aline\[49\]=0 MC_6TWrite_Test.Aline\[48\]=0 \
MC_6TWrite_Test.Aline\[47\]=0 MC_6TWrite_Test.Aline\[46\]=0 \
MC_6TWrite_Test.Aline\[45\]=0 MC_6TWrite_Test.Aline\[44\]=0 \
MC_6TWrite_Test.Aline\[43\]=0 MC_6TWrite_Test.Aline\[42\]=0 \
MC_6TWrite_Test.Aline\[41\]=0 MC_6TWrite_Test.Aline\[40\]=0 \
MC_6TWrite_Test.Aline\[39\]=0 MC_6TWrite_Test.Aline\[38\]=0 \
MC_6TWrite_Test.Aline\[37\]=0 MC_6TWrite_Test.Aline\[36\]=0 \
MC_6TWrite_Test.Aline\[35\]=0 MC_6TWrite_Test.Aline\[34\]=0 \
MC_6TWrite_Test.Aline\[33\]=0 MC_6TWrite_Test.Aline\[32\]=0 \
MC_6TWrite_Test.Aline\[31\]=0 MC_6TWrite_Test.Aline\[30\]=0 \
MC_6TWrite_Test.Aline\[29\]=0 MC_6TWrite_Test.Aline\[28\]=0 \
MC_6TWrite_Test.Aline\[27\]=0 MC_6TWrite_Test.Aline\[26\]=0 \
MC_6TWrite_Test.Aline\[25\]=0 MC_6TWrite_Test.Aline\[24\]=0 \
MC_6TWrite_Test.Aline\[23\]=0 MC_6TWrite_Test.Aline\[22\]=0 \
MC_6TWrite_Test.Aline\[21\]=0 MC_6TWrite_Test.Aline\[20\]=0 \
MC_6TWrite_Test.Aline\[19\]=0 MC_6TWrite_Test.Aline\[18\]=0 \
MC_6TWrite_Test.Aline\[17\]=0 MC_6TWrite_Test.Aline\[16\]=0 \
MC_6TWrite_Test.Aline\[15\]=0 MC_6TWrite_Test.Aline\[14\]=0 \
MC_6TWrite_Test.Aline\[13\]=0 MC_6TWrite_Test.Aline\[12\]=0 \
MC_6TWrite_Test.Aline\[11\]=0 MC_6TWrite_Test.Aline\[10\]=0 \
MC_6TWrite_Test.Aline\[9\]=0 MC_6TWrite_Test.Aline\[8\]=0 \
MC_6TWrite_Test.Aline\[7\]=0 MC_6TWrite_Test.Aline\[6\]=0 \
MC_6TWrite_Test.Aline\[5\]=0 MC_6TWrite_Test.Aline\[4\]=0 \
MC_6TWrite_Test.Aline\[3\]=0 MC_6TWrite_Test.Aline\[2\]=0 \
MC_6TWrite_Test.Aline\[1\]=0 MC_6TWrite_Test.Aline\[0\]=0 \
MC_6TWrite_Test.ValAddr=0 MC_6TWrite_Test.Ack=0 MC_6TWrite_Test.RW\[1\]=0 \
MC_6TWrite_Test.RW\[0\]=0 MC_6TWrite_Test.S\[7\]=0 \
MC_6TWrite_Test.S\[6\]=0 MC_6TWrite_Test.S\[5\]=0 MC_6TWrite_Test.S\[4\]=0 \
MC_6TWrite_Test.S\[3\]=0 MC_6TWrite_Test.S\[2\]=0 MC_6TWrite_Test.S\[1\]=0 \
MC_6TWrite_Test.S\[0\]=0 MC_6TWrite_Test.WD1\[3\]=0 \
MC_6TWrite_Test.WD1\[2\]=0 MC_6TWrite_Test.WD1\[1\]=0 \
MC_6TWrite_Test.WD1\[0\]=0 MC_6TWrite_Test.WD2\[3\]=0 \
MC_6TWrite_Test.WD2\[2\]=0 MC_6TWrite_Test.WD2\[1\]=0 \
MC_6TWrite_Test.WD2\[0\]=0 MC_6TWrite_Test.WdataAck\[1\]=0 \
MC_6TWrite_Test.WdataAck\[0\]=0 MC_6TWrite_Test.RDataAck\[1\]=0 \
MC_6TWrite_Test.RDataAck\[0\]=0 MC_6TWrite_Test.R2\[3\]=0 \
MC_6TWrite_Test.R2\[2\]=0 MC_6TWrite_Test.R2\[1\]=0 \
MC_6TWrite_Test.R2\[0\]=0 MC_6TWrite_Test.R1\[3\]=0 \
MC_6TWrite_Test.R1\[2\]=0 MC_6TWrite_Test.R1\[1\]=0 \
MC_6TWrite_Test.R1\[0\]=0 MC_6TWrite_Test.ICHUNK.IARRAY0.B1P1=vdd \
MC_6TWrite_Test.ICHUNK.IARRAY0.B0P1=vdd \
MC_6TWrite_Test.ICHUNK.IARRAY0.ISRAM0.I7.I3.Q0=vdd \
MC_6TWrite_Test.ICHUNK.IARRAY0.ISRAM0.I7.I3.Q1=0
simulatorOptions options temp=30.0 tnom=27 scale=1.0 scalem=1.0

// UltraSim Solver Options
usim_opt output_upper=0 ade=1 wf_spectre_syntax=1
mc1 montecarlo numruns=1000 seed=1 variations=all sampling=lhs \
numbins=1000 donominal=yes scalarfile="../monteCarlo/mcdata" \
paramfile="../monteCarlo/mcparam" saveprocessparams=yes \
processparamfile="../monteCarlo/processParam" \
processscalarfile="../monteCarlo/processData" savemismatchparams=yes \
mismatchparamfile="../monteCarlo/mismatchparam" \
mismatchscalarfile="../monteCarlo/mismatchdata" dumpdependency=mismatch \
dependencymapfile="../monteCarlo/mismatchdependency" dut=[ \
MC_6TWrite_Test.ICHUNK.IARRAY0.ISRAM0.I7.I3.M0 \
MC_6TWrite_Test.ICHUNK.IARRAY0.ISRAM0.I7.I3.M3 \
MC_6TWrite_Test.ICHUNK.IARRAY0.ISRAM0.I7.I3.M5 \
MC_6TWrite_Test.ICHUNK.IARRAY0.ISRAM0.I7.I3.M4 \
MC_6TWrite_Test.ICHUNK.IARRAY0.ISRAM0.I7.I3.M2 \
MC_6TWrite_Test.ICHUNK.IARRAY0.ISRAM0.I7.I3.M1 ]  paramdumpmode=yes \
savefamilyplots=yes savedatainseparatedir=yes wfseparation=yes {

tran tran stop=4n \
readic="/net/kafka/nfs/rstdenis/Cadence/simulation/ADEXL/16nm_Tests/MC_6TWrite_Test/adexl/results/data/.tmpADEDir_root/16nm_Tests:MC_6TWrite_Test:1/16nm_Tests_MC_6TWrite_Test_config_ams/netlist/spectre.ic" \
write="spectre.ic" writefinal="spectre.fc"

finalTimeOP info what=oppoint where=rawfile

modelParameter info what=models where=rawfile
element info what=inst where=rawfile
outputParameter info what=output where=rawfile
designParamVals info what=parameters where=rawfile
export noExprs=oceanEval("0")
}
mcOptions options genmcdep=yes
