// Design: 16nm_Tests/MC_6TWrite_Test
simulator lang=spectre
global 0 vdd! vcc!
parameters time2=2n time3=2.22n time4=2.85n time5=3n vdd=.500
include "/root/Desktop/Cadence/ncsu-FreePDK15/PTM-MG/smodels.scs"

// 16nm/6T/schematic
//system verilogNetlist schematic cmos_sch veriloga ahdl
subckt _sub21 A B0 B1
    M5 (Q0 Q1 0 0) nfet w=60n l=20n nfin=1 nf=1 m=1
    M4 (Q1 Q0 0 0) nfet w=60n l=20n nfin=1 nf=1 m=1
    M1 (Q1 A B1 0) nfet w=120n l=20n nfin=2 nf=1 m=1
    M0 (Q0 A B0 0) nfet w=120n l=20n nfin=2 nf=1 m=1
    M3 (Q0 Q1 vdd! vdd!) pfet w=100n l=20n nfin=1 nf=1 m=1
    M2 (Q1 Q0 vdd! vdd!) pfet w=100n l=20n nfin=1 nf=1 m=1
ends _sub21

// 16nm/6T_4x/schematic
//system verilogNetlist schematic cmos_sch veriloga ahdl
subckt _sub22 A\<3\> A\<2\> A\<1\> A\<0\> B0 B1
    I3 (A\<0\> B0 B1) _sub21
    I2 (A\<1\> B0 B1) _sub21
    I1 (A\<2\> B0 B1) _sub21
    I0 (A\<3\> B0 B1) _sub21
ends _sub22

// 16nm/6T_32x/schematic
//system verilogNetlist schematic cmos_sch veriloga ahdl
subckt _sub23 B0 B1 A\<31\> A\<30\> A\<29\> A\<28\> A\<27\> A\<26\> A\<25\> A\<24\> A\<23\> A\<22\> A\<21\> A\<20\> A\<19\> A\<18\> A\<17\> A\<16\> A\<15\> A\<14\> A\<13\> A\<12\> A\<11\> A\<10\> A\<9\> A\<8\> A\<7\> A\<6\> A\<5\> A\<4\> A\<3\> A\<2\> A\<1\> A\<0\>
    I7 (A\<3\> A\<2\> A\<1\> A\<0\> B0 B1) _sub22
    I6 (A\<7\> A\<6\> A\<5\> A\<4\> B0 B1) _sub22
    I5 (A\<11\> A\<10\> A\<9\> A\<8\> B0 B1) _sub22
    I4 (A\<15\> A\<14\> A\<13\> A\<12\> B0 B1) _sub22
    I3 (A\<19\> A\<18\> A\<17\> A\<16\> B0 B1) _sub22
    I2 (A\<23\> A\<22\> A\<21\> A\<20\> B0 B1) _sub22
    I1 (A\<27\> A\<26\> A\<25\> A\<24\> B0 B1) _sub22
    I0 (A\<31\> A\<30\> A\<29\> A\<28\> B0 B1) _sub22
ends _sub23

// 16nm/6T_32x_CTRL/schematic
//system verilogNetlist schematic cmos_sch veriloga ahdl
subckt _sub24 B0 B1 S W0 W1
    M10 (B1 B0 net22 vdd!) pfet w=100n l=20n nfin=1 nf=1 m=1
    M9 (net22 W1 vdd! vdd!) pfet w=100n l=20n nfin=1 nf=1 m=1
    M8 (B0 B1 net23 vdd!) pfet w=100n l=20n nfin=1 nf=1 m=1
    M7 (net23 W0 vdd! vdd!) pfet w=100n l=20n nfin=1 nf=1 m=1
    M2 (B1 S vdd! vdd!) pfet w=100n l=20n nfin=1 nf=1 m=1
    M0 (B0 S vdd! vdd!) pfet w=100n l=20n nfin=1 nf=1 m=1
    M6 (B1 W1 net24 0) nfet w=60n l=20n nfin=1 nf=1 m=1
    M5 (net24 S 0 0) nfet w=60n l=20n nfin=1 nf=1 m=1
    M4 (net25 S 0 0) nfet w=60n l=20n nfin=1 nf=1 m=1
    M3 (B0 W0 net25 0) nfet w=60n l=20n nfin=1 nf=1 m=1
ends _sub24

// 16nm/nand4_1x/schematic
//system verilogNetlist schematic cmos_sch veriloga ahdl
subckt nand4_1x A B C D Y
    M5 (Y D vdd! vdd!) pfet w=100n l=20n nfin=1 nf=1 m=1
    M4 (Y C vdd! vdd!) pfet w=100n l=20n nfin=1 nf=1 m=1
    M1 (Y B vdd! vdd!) pfet w=100n l=20n nfin=1 nf=1 m=1
    M0 (Y A vdd! vdd!) pfet w=100n l=20n nfin=1 nf=1 m=1
    M7 (net23 D 0 0) nfet w=240n l=20n nfin=1 nf=1 m=1
    M6 (net25 C net23 0) nfet w=240n l=20n nfin=1 nf=1 m=1
    M3 (net24 B net25 0) nfet w=240n l=20n nfin=1 nf=1 m=1
    M2 (Y A net24 0) nfet w=240n l=20n nfin=1 nf=1 m=1
ends nand4_1x

// 16nm/6T_32x4/schematic
//system verilogNetlist schematic cmos_sch veriloga ahdl
subckt _sub25 A\<31\> A\<30\> A\<29\> A\<28\> A\<27\> A\<26\> A\<25\> A\<24\> A\<23\> A\<22\> A\<21\> A\<20\> A\<19\> A\<18\> A\<17\> A\<16\> A\<15\> A\<14\> A\<13\> A\<12\> A\<11\> A\<10\> A\<9\> A\<8\> A\<7\> A\<6\> A\<5\> A\<4\> A\<3\> A\<2\> A\<1\> A\<0\> B0 B1 S\<3\> S\<2\> S\<1\> S\<0\> W0 W1 SM1 SM0
    ISRAM3 (B0P4 B1P4 A\<31\> A\<30\> A\<29\> A\<28\> A\<27\> A\<26\> A\<25\> A\<24\> A\<23\> A\<22\> A\<21\> A\<20\> A\<19\> A\<18\> A\<17\> A\<16\> A\<15\> A\<14\> A\<13\> A\<12\> A\<11\> A\<10\> A\<9\> A\<8\> A\<7\> A\<6\> A\<5\> A\<4\> A\<3\> A\<2\> A\<1\> A\<0\>) _sub23
    ISRAM1 (B0P2 B1P2 A\<31\> A\<30\> A\<29\> A\<28\> A\<27\> A\<26\> A\<25\> A\<24\> A\<23\> A\<22\> A\<21\> A\<20\> A\<19\> A\<18\> A\<17\> A\<16\> A\<15\> A\<14\> A\<13\> A\<12\> A\<11\> A\<10\> A\<9\> A\<8\> A\<7\> A\<6\> A\<5\> A\<4\> A\<3\> A\<2\> A\<1\> A\<0\>) _sub23
    ISRAM2 (B0P3 B1P3 A\<31\> A\<30\> A\<29\> A\<28\> A\<27\> A\<26\> A\<25\> A\<24\> A\<23\> A\<22\> A\<21\> A\<20\> A\<19\> A\<18\> A\<17\> A\<16\> A\<15\> A\<14\> A\<13\> A\<12\> A\<11\> A\<10\> A\<9\> A\<8\> A\<7\> A\<6\> A\<5\> A\<4\> A\<3\> A\<2\> A\<1\> A\<0\>) _sub23
    ISRAM0 (B0P1 B1P1 A\<31\> A\<30\> A\<29\> A\<28\> A\<27\> A\<26\> A\<25\> A\<24\> A\<23\> A\<22\> A\<21\> A\<20\> A\<19\> A\<18\> A\<17\> A\<16\> A\<15\> A\<14\> A\<13\> A\<12\> A\<11\> A\<10\> A\<9\> A\<8\> A\<7\> A\<6\> A\<5\> A\<4\> A\<3\> A\<2\> A\<1\> A\<0\>) _sub23
    M1 (B0P1 B0 net67 0) nfet w=60n l=20n nfin=1 nf=1 m=1
    M0 (net67 S\<0\> 0 0) nfet w=60n l=20n nfin=1 nf=1 m=1
    M3 (net66 S\<0\> 0 0) nfet w=60n l=20n nfin=1 nf=1 m=1
    M10 (B1P2 B1 net65 0) nfet w=60n l=20n nfin=1 nf=1 m=1
    M9 (net65 S\<1\> 0 0) nfet w=60n l=20n nfin=1 nf=1 m=1
    M6 (net64 S\<1\> 0 0) nfet w=60n l=20n nfin=1 nf=1 m=1
    M7 (B0P2 B0 net64 0) nfet w=60n l=20n nfin=1 nf=1 m=1
    M13 (B0P3 B0 net63 0) nfet w=60n l=20n nfin=1 nf=1 m=1
    M12 (net63 S\<2\> 0 0) nfet w=60n l=20n nfin=1 nf=1 m=1
    M15 (net62 S\<2\> 0 0) nfet w=60n l=20n nfin=1 nf=1 m=1
    M16 (B1P3 B1 net62 0) nfet w=60n l=20n nfin=1 nf=1 m=1
    M22 (B1P4 B1 net61 0) nfet w=60n l=20n nfin=1 nf=1 m=1
    M21 (net61 S\<3\> 0 0) nfet w=60n l=20n nfin=1 nf=1 m=1
    M18 (net60 S\<3\> 0 0) nfet w=60n l=20n nfin=1 nf=1 m=1
    M19 (B0P4 B0 net60 0) nfet w=60n l=20n nfin=1 nf=1 m=1
    M4 (B1P1 B1 net66 0) nfet w=60n l=20n nfin=1 nf=1 m=1
    I4 (B0P1 B1P1 S\<0\> W0 W1) _sub24
    I11 (B0P2 B1P2 S\<1\> W0 W1) _sub24
    I20 (B0P3 B1P3 S\<2\> W0 W1) _sub24
    I27 (B0P4 B1P4 S\<3\> W0 W1) _sub24
    I16 (B1P1 B1P2 B1P3 B1P4 SM1) nand4_1x
    I13 (B0P1 B0P2 B0P3 B0P4 SM0) nand4_1x
    C7 (B1P4 0) capacitor c=1.2822f m=1
    C3 (B1P2 0) capacitor c=1.2822f m=1
    C5 (B1P3 0) capacitor c=1.2822f m=1
    C6 (B0P4 0) capacitor c=1.2822f m=1
    C4 (B0P3 0) capacitor c=1.2822f m=1
    C2 (B0P2 0) capacitor c=1.2822f m=1
    C1 (B1P1 0) capacitor c=1.2822f m=1
    C0 (B0P1 0) capacitor c=1.2822f m=1
    M5 (B1P1 S\<0\> vdd! vdd!) pfet w=100n l=20n nfin=1 nf=1 m=1
    M2 (B0P1 S\<0\> vdd! vdd!) pfet w=100n l=20n nfin=1 nf=1 m=1
    M11 (B1P2 S\<1\> vdd! vdd!) pfet w=100n l=20n nfin=1 nf=1 m=1
    M8 (B0P2 S\<1\> vdd! vdd!) pfet w=100n l=20n nfin=1 nf=1 m=1
    M17 (B1P3 S\<2\> vdd! vdd!) pfet w=100n l=20n nfin=1 nf=1 m=1
    M14 (B0P3 S\<2\> vdd! vdd!) pfet w=100n l=20n nfin=1 nf=1 m=1
    M20 (B0P4 S\<3\> vdd! vdd!) pfet w=100n l=20n nfin=1 nf=1 m=1
    M23 (B1P4 S\<3\> vdd! vdd!) pfet w=100n l=20n nfin=1 nf=1 m=1
ends _sub25

// 16nm/6T_SetRead/schematic
//system verilogNetlist schematic cmos_sch veriloga ahdl
subckt _sub26 \~R0 \~R1 Go SM0\<0\> SM0\<1\> SM1\<0\> SM1\<1\>
    M6 (net18 Go 0 0) nfet w=40n l=16n nfin=1 nf=1 m=1
    M5 (\~R0 SM0\<0\> net18 0) nfet w=40n l=16n nfin=1 nf=1 m=1
    M3 (\~R0 SM0\<1\> net18 0) nfet w=40n l=16n nfin=1 nf=1 m=1
    M2 (net12 Go 0 0) nfet w=40n l=16n nfin=1 nf=1 m=1
    M1 (\~R1 SM1\<1\> net12 0) nfet w=40n l=16n nfin=1 nf=1 m=1
    M0 (\~R1 SM1\<0\> net12 0) nfet w=40n l=16n nfin=1 nf=1 m=1
ends _sub26

// 16nm/6T_CHUNK/schematic
//system verilogNetlist schematic cmos_sch veriloga ahdl
subckt _sub27 \~R0\<3\> \~R0\<2\> \~R0\<1\> \~R0\<0\> \~R1\<3\> \~R1\<2\> \~R1\<1\> \~R1\<0\> A\<63\> A\<62\> A\<61\> A\<60\> A\<59\> A\<58\> A\<57\> A\<56\> A\<55\> A\<54\> A\<53\> A\<52\> A\<51\> A\<50\> A\<49\> A\<48\> A\<47\> A\<46\> A\<45\> A\<44\> A\<43\> A\<42\> A\<41\> A\<40\> A\<39\> A\<38\> A\<37\> A\<36\> A\<35\> A\<34\> A\<33\> A\<32\> A\<31\> A\<30\> A\<29\> A\<28\> A\<27\> A\<26\> A\<25\> A\<24\> A\<23\> A\<22\> A\<21\> A\<20\> A\<19\> A\<18\> A\<17\> A\<16\> A\<15\> A\<14\> A\<13\> A\<12\> A\<11\> A\<10\> A\<9\> A\<8\> A\<7\> A\<6\> A\<5\> A\<4\> A\<3\> A\<2\> A\<1\> A\<0\> B0\<3\> B0\<2\> B0\<1\> B0\<0\> B1\<3\> B1\<2\> B1\<1\> B1\<0\> S\<7\> S\<6\> S\<5\> S\<4\> S\<3\> S\<2\> S\<1\> S\<0\> W0\<3\> W0\<2\> W0\<1\> W0\<0\> W1\<3\> W1\<2\> W1\<1\> W1\<0\> Go
    IARRAY7 (A\<63\> A\<62\> A\<61\> A\<60\> A\<59\> A\<58\> A\<57\> A\<56\> A\<55\> A\<54\> A\<53\> A\<52\> A\<51\> A\<50\> A\<49\> A\<48\> A\<47\> A\<46\> A\<45\> A\<44\> A\<43\> A\<42\> A\<41\> A\<40\> A\<39\> A\<38\> A\<37\> A\<36\> A\<35\> A\<34\> A\<33\> A\<32\> B0\<3\> B1\<3\> S\<7\> S\<6\> S\<5\> S\<4\> W0\<3\> W1\<3\> SM1_1_bit3 SM0_1_bit3) _sub25
    IARRAY6 (A\<63\> A\<62\> A\<61\> A\<60\> A\<59\> A\<58\> A\<57\> A\<56\> A\<55\> A\<54\> A\<53\> A\<52\> A\<51\> A\<50\> A\<49\> A\<48\> A\<47\> A\<46\> A\<45\> A\<44\> A\<43\> A\<42\> A\<41\> A\<40\> A\<39\> A\<38\> A\<37\> A\<36\> A\<35\> A\<34\> A\<33\> A\<32\> B0\<2\> B1\<2\> S\<7\> S\<6\> S\<5\> S\<4\> W0\<2\> W1\<2\> SM1_1_bit2 SM0_1_bit2) _sub25
    IARRAY5 (A\<63\> A\<62\> A\<61\> A\<60\> A\<59\> A\<58\> A\<57\> A\<56\> A\<55\> A\<54\> A\<53\> A\<52\> A\<51\> A\<50\> A\<49\> A\<48\> A\<47\> A\<46\> A\<45\> A\<44\> A\<43\> A\<42\> A\<41\> A\<40\> A\<39\> A\<38\> A\<37\> A\<36\> A\<35\> A\<34\> A\<33\> A\<32\> B0\<1\> B1\<1\> S\<7\> S\<6\> S\<5\> S\<4\> W0\<1\> W1\<1\> SM1_1_bit1 SM0_1_bit1) _sub25
    IARRAY4 (A\<63\> A\<62\> A\<61\> A\<60\> A\<59\> A\<58\> A\<57\> A\<56\> A\<55\> A\<54\> A\<53\> A\<52\> A\<51\> A\<50\> A\<49\> A\<48\> A\<47\> A\<46\> A\<45\> A\<44\> A\<43\> A\<42\> A\<41\> A\<40\> A\<39\> A\<38\> A\<37\> A\<36\> A\<35\> A\<34\> A\<33\> A\<32\> B0\<0\> B1\<0\> S\<7\> S\<6\> S\<5\> S\<4\> W0\<0\> W1\<0\> SM1_1_bit0 SM0_1_bit0) _sub25
    IARRAY3 (A\<31\> A\<30\> A\<29\> A\<28\> A\<27\> A\<26\> A\<25\> A\<24\> A\<23\> A\<22\> A\<21\> A\<20\> A\<19\> A\<18\> A\<17\> A\<16\> A\<15\> A\<14\> A\<13\> A\<12\> A\<11\> A\<10\> A\<9\> A\<8\> A\<7\> A\<6\> A\<5\> A\<4\> A\<3\> A\<2\> A\<1\> A\<0\> B0\<3\> B1\<3\> S\<3\> S\<2\> S\<1\> S\<0\> W0\<3\> W1\<3\> SM1_0_bit3 SM0_0_bit3) _sub25
    IARRAY2 (A\<31\> A\<30\> A\<29\> A\<28\> A\<27\> A\<26\> A\<25\> A\<24\> A\<23\> A\<22\> A\<21\> A\<20\> A\<19\> A\<18\> A\<17\> A\<16\> A\<15\> A\<14\> A\<13\> A\<12\> A\<11\> A\<10\> A\<9\> A\<8\> A\<7\> A\<6\> A\<5\> A\<4\> A\<3\> A\<2\> A\<1\> A\<0\> B0\<2\> B1\<2\> S\<3\> S\<2\> S\<1\> S\<0\> W0\<2\> W1\<2\> SM1_0_bit2 SM0_0_bit2) _sub25
    IARRAY1 (A\<31\> A\<30\> A\<29\> A\<28\> A\<27\> A\<26\> A\<25\> A\<24\> A\<23\> A\<22\> A\<21\> A\<20\> A\<19\> A\<18\> A\<17\> A\<16\> A\<15\> A\<14\> A\<13\> A\<12\> A\<11\> A\<10\> A\<9\> A\<8\> A\<7\> A\<6\> A\<5\> A\<4\> A\<3\> A\<2\> A\<1\> A\<0\> B0\<1\> B1\<1\> S\<3\> S\<2\> S\<1\> S\<0\> W0\<1\> W1\<1\> SM1_0_bit1 SM0_0_bit1) _sub25
    IARRAY0 (A\<31\> A\<30\> A\<29\> A\<28\> A\<27\> A\<26\> A\<25\> A\<24\> A\<23\> A\<22\> A\<21\> A\<20\> A\<19\> A\<18\> A\<17\> A\<16\> A\<15\> A\<14\> A\<13\> A\<12\> A\<11\> A\<10\> A\<9\> A\<8\> A\<7\> A\<6\> A\<5\> A\<4\> A\<3\> A\<2\> A\<1\> A\<0\> B0\<0\> B1\<0\> S\<3\> S\<2\> S\<1\> S\<0\> W0\<0\> W1\<0\> SM1_0_bit0 SM0_0_bit0) _sub25
    I7 (\~R0\<3\> \~R1\<3\> Go SM0_0_bit3 SM0_1_bit3 SM1_0_bit3 SM1_1_bit3) _sub26
    I6 (\~R0\<2\> \~R1\<2\> Go SM0_0_bit2 SM0_1_bit2 SM1_0_bit2 SM1_1_bit2) _sub26
    I5 (\~R0\<1\> \~R1\<1\> Go SM0_0_bit1 SM0_1_bit1 SM1_0_bit1 SM1_1_bit1) _sub26
    I4 (\~R0\<0\> \~R1\<0\> Go SM0_0_bit0 SM0_1_bit0 SM1_0_bit0 SM1_1_bit0) _sub26
ends _sub27

// 16nm/inv_1x/schematic
//system verilogNetlist schematic cmos_sch veriloga ahdl
subckt inv_1x A Y
    M0 (Y A 0 0) nfet w=60n l=20n nfin=1 nf=1 m=1
    M1 (Y A vdd! vdd!) pfet w=100n l=20n nfin=1 nf=1 m=1
ends inv_1x

// 16nm_Tests/MC_6TWrite_Test/schematic
// system verilogNetlist schematic cmos_sch veriloga ahdl
ICHUNK (\~R0_1\<3\> \~R0_1\<2\> \~R0_1\<1\> \~R0_1\<0\> \~R1_1\<3\> \~R1_1\<2\> \~R1_1\<1\> \~R1_1\<0\> Aline\<63\> Aline\<62\> Aline\<61\> Aline\<60\> Aline\<59\> Aline\<58\> Aline\<57\> Aline\<56\> Aline\<55\> Aline\<54\> Aline\<53\> Aline\<52\> Aline\<51\> Aline\<50\> Aline\<49\> Aline\<48\> Aline\<47\> Aline\<46\> Aline\<45\> Aline\<44\> Aline\<43\> Aline\<42\> Aline\<41\> Aline\<40\> Aline\<39\> Aline\<38\> Aline\<37\> Aline\<36\> Aline\<35\> Aline\<34\> Aline\<33\> Aline\<32\> Aline\<31\> Aline\<30\> Aline\<29\> Aline\<28\> Aline\<27\> Aline\<26\> Aline\<25\> Aline\<24\> Aline\<23\> Aline\<22\> Aline\<21\> Aline\<20\> Aline\<19\> Aline\<18\> Aline\<17\> Aline\<16\> Aline\<15\> Aline\<14\> Aline\<13\> Aline\<12\> Aline\<11\> Aline\<10\> Aline\<9\> Aline\<8\> Aline\<7\> Aline\<6\> Aline\<5\> Aline\<4\> Aline\<3\> Aline\<2\> Aline\<1\> Aline\<0\> 0 0 0 0 B1_1\<3\> B1_1\<2\> B1_1\<1\> B1_1\<0\> S\<7\> S\<6\> S\<5\> S\<4\> S\<3\> S\<2\> S\<1\> S\<0\> 0 0 0 0 W1_1\<3\> W1_1\<2\> W1_1\<1\> W1_1\<0\> 0) _sub27
V7\<3\> (B1_1\<3\> 0) vsource type=pwl mag=0 phase=0 wave=[ 0 0 time2 0 time3 vdd time4 vdd time5 0 ]
V7\<2\> (B1_1\<2\> 0) vsource type=pwl mag=0 phase=0 wave=[ 0 0 time2 0 time3 vdd time4 vdd time5 0 ]
V7\<1\> (B1_1\<1\> 0) vsource type=pwl mag=0 phase=0 wave=[ 0 0 time2 0 time3 vdd time4 vdd time5 0 ]
V7\<0\> (B1_1\<0\> 0) vsource type=pwl mag=0 phase=0 wave=[ 0 0 time2 0 time3 vdd time4 vdd time5 0 ]
V8\<3\> (W1_1\<3\> 0) vsource type=pwl mag=0 phase=0 wave=[ 0 0 time2 0 time3 vdd time4 vdd time5 0 ]
V8\<2\> (W1_1\<2\> 0) vsource type=pwl mag=0 phase=0 wave=[ 0 0 time2 0 time3 vdd time4 vdd time5 0 ]
V8\<1\> (W1_1\<1\> 0) vsource type=pwl mag=0 phase=0 wave=[ 0 0 time2 0 time3 vdd time4 vdd time5 0 ]
V8\<0\> (W1_1\<0\> 0) vsource type=pwl mag=0 phase=0 wave=[ 0 0 time2 0 time3 vdd time4 vdd time5 0 ]
V6 (S\<0\> 0) vsource type=pwl mag=0 phase=0 wave=[ 0 0 time2 0 time3 vdd time4 vdd time5 0 ]
V2 (Aline\<0\> 0) vsource type=pwl mag=0 phase=0 wave=[ 0 0 time2 0 time3 vdd time4 vdd time5 0 ]
M0\<3\> (\~R1_1\<3\> net15\<0\> vdd! vdd!) pfet w=100n l=20n nfin=1 nf=1 m=1
M0\<2\> (\~R1_1\<2\> net15\<1\> vdd! vdd!) pfet w=100n l=20n nfin=1 nf=1 m=1
M0\<1\> (\~R1_1\<1\> net15\<2\> vdd! vdd!) pfet w=100n l=20n nfin=1 nf=1 m=1
M0\<0\> (\~R1_1\<0\> net15\<3\> vdd! vdd!) pfet w=100n l=20n nfin=1 nf=1 m=1
M1\<3\> (\~R0_1\<3\> net15\<0\> vdd! vdd!) pfet w=100n l=20n nfin=1 nf=1 m=1
M1\<2\> (\~R0_1\<2\> net15\<1\> vdd! vdd!) pfet w=100n l=20n nfin=1 nf=1 m=1
M1\<1\> (\~R0_1\<1\> net15\<2\> vdd! vdd!) pfet w=100n l=20n nfin=1 nf=1 m=1
M1\<0\> (\~R0_1\<0\> net15\<3\> vdd! vdd!) pfet w=100n l=20n nfin=1 nf=1 m=1
V0 (vcc! 0) vsource type=dc dc=vdd
V1 (vdd! 0) vsource type=dc dc=vdd
I4\<3\> (\~R1_1\<3\> 0) inv_1x
I4\<2\> (\~R1_1\<2\> 0) inv_1x
I4\<1\> (\~R1_1\<1\> 0) inv_1x
I4\<0\> (\~R1_1\<0\> 0) inv_1x
I6\<3\> (\~R0_1\<3\> 0) inv_1x
I6\<2\> (\~R0_1\<2\> 0) inv_1x
I6\<1\> (\~R0_1\<1\> 0) inv_1x
I6\<0\> (\~R0_1\<0\> 0) inv_1x
simulatorOptions options temp=30.0
mc1 montecarlo numruns=100 seed=1 variations=mismatch sampling=standard donominal=yes scalarfile="../monteCarlo/mcdata" paramfile="../monteCarlo/mcparam" savemismatchparams=yes dependencymapfile="../monteCarlo/mismatchdependency" dumpdependency=mismatch dependencyscalarfile="../monteCarlo/compactmismatchdata" dependencyparamfile="../monteCarlo/compactmismatchparam" dut=[ ICHUNK.IARRAY0.ISRAM0.I7.I3.M0 ICHUNK.IARRAY0.ISRAM0.I7.I3.M3 ICHUNK.IARRAY0.ISRAM0.I7.I3.M5 ICHUNK.IARRAY0.ISRAM0.I7.I3.M4 ICHUNK.IARRAY0.ISRAM0.I7.I3.M2 ICHUNK.IARRAY0.ISRAM0.I7.I3.M1 ] paramdumpmode=yes savefamilyplots=yes savedatainseparatedir=yes wfseparation=yes {
tran tran stop=4n errpreset=conservative
}
mcOptions options genmcdep=yes
