simulator lang=spectre
include "/root/Desktop/Cadence/ncsu-FreePDK15/PTM-MG/Spectre/FinFETS.scs" amsd_subckt_bind=yes
