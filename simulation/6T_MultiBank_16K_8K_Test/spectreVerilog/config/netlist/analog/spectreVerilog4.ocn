simulator( 'spectreVerilog )
hostMode( 'distributed )
design(	 "/net/bull/apps/Cadence/simulation/6T_MultiBank_16K_8K_Test/spectreVerilog/config/netlist/analog/netlist")
resultsDir( "/net/bull/apps/Cadence/simulation/6T_MultiBank_16K_8K_Test/spectreVerilog/config/distributed/MBank_16K_r8K_500mV_30C" )
modelFile(
    '("/software/cadence/ncsu-FreePDK15/hspice_16nm_hp.include" "")
)
analysis('tran ?stop "5n"  ?errpreset "conservative"  )
desVar(	  "vcc" "vdd"	)
desVar(	  "vdd" .500	)
envOption(
	'mspSetupNetlistSimPrecisionUnit  "ps"
	'mspSetupNetlistSimTimeUnit  "ps"
	'mspSetupNetlistSwitchRC  t
	'userCmdLineOption  "+multithread"
	'analysisOrder  list("tran")
)
option(	'temp  "30.0"
)
saveOption( ?simOutputFormat "psfxl" )
save( 'i "/V0/MINUS" )
converge( 'ic "/ReadEnT" "0" )
converge( 'ic "/R_AddressT<0>" "0" )
converge( 'ic "/R_AddressT<1>" "0" )
converge( 'ic "/R_AddressT<2>" "0" )
converge( 'ic "/R_AddressT<3>" "0" )
converge( 'ic "/R_AddressT<4>" "0" )
converge( 'ic "/R_AddressT<5>" "0" )
converge( 'ic "/R_AddressT<6>" "0" )
converge( 'ic "/R_AddressT<7>" "0" )
converge( 'ic "/R_AddressT<8>" "0" )
converge( 'ic "/R_AddressT<9>" "0" )
converge( 'ic "/R_AddressT<10>" "0" )
converge( 'ic "/R_AddressT<11>" "0" )
converge( 'ic "/W_AddressT<0>" "0" )
converge( 'ic "/W_AddressT<1>" "0" )
converge( 'ic "/W_AddressT<2>" "0" )
converge( 'ic "/W_AddressT<3>" "0" )
converge( 'ic "/W_AddressT<4>" "0" )
converge( 'ic "/W_AddressT<5>" "0" )
converge( 'ic "/W_AddressT<6>" "0" )
converge( 'ic "/W_AddressT<7>" "0" )
converge( 'ic "/W_AddressT<8>" "0" )
converge( 'ic "/W_AddressT<9>" "0" )
converge( 'ic "/W_AddressT<10>" "0" )
converge( 'ic "/W_AddressT<11>" "0" )
converge( 'ic "/WriteEnT" "0" )
converge( 'ic "/WDataT<0>" "0" )
converge( 'ic "/WDataT<1>" "0" )
converge( 'ic "/WDataT<2>" "0" )
converge( 'ic "/WDataT<3>" "0" )
converge( 'ic "/WDataT<4>" "0" )
converge( 'ic "/WDataT<5>" "0" )
converge( 'ic "/WDataT<6>" "0" )
converge( 'ic "/WDataT<7>" "0" )
converge( 'ic "/WDataT<8>" "0" )
converge( 'ic "/WDataT<9>" "0" )
converge( 'ic "/WDataT<10>" "0" )
converge( 'ic "/WDataT<11>" "0" )
converge( 'ic "/WDataT<12>" "0" )
converge( 'ic "/WDataT<13>" "0" )
converge( 'ic "/WDataT<14>" "0" )
converge( 'ic "/WDataT<15>" "0" )
converge( 'ic "/WDataT<16>" "0" )
converge( 'ic "/WDataT<17>" "0" )
converge( 'ic "/WDataT<18>" "0" )
converge( 'ic "/WDataT<19>" "0" )
converge( 'ic "/WDataT<20>" "0" )
converge( 'ic "/WDataT<21>" "0" )
converge( 'ic "/WDataT<22>" "0" )
converge( 'ic "/WDataT<23>" "0" )
converge( 'ic "/WDataT<24>" "0" )
converge( 'ic "/WDataT<25>" "0" )
converge( 'ic "/WDataT<26>" "0" )
converge( 'ic "/WDataT<27>" "0" )
converge( 'ic "/WDataT<28>" "0" )
converge( 'ic "/WDataT<29>" "0" )
converge( 'ic "/WDataT<30>" "0" )
converge( 'ic "/WDataT<31>" "0" )
converge( 'ic "/~ReadEn" "vdd" )
converge( 'ic "/~R_Address<11:0>" "vdd" )
converge( 'ic "/~WriteEn" "vdd" )
converge( 'ic "/~W_Address<11:0>" "vdd" )
converge( 'ic "/I21/I40/I0/I0/I0/I0/I7/I3/Q0" "0" )
converge( 'ic "/I21/I0/I0/I0/I0/I0/I7/I3/Q0" "0" )
converge( 'ic "/I21/I0/I0/I0/I0/I0/I7/I3/Q1" "vdd" )
converge( 'ic "/I21/I40/I0/I0/I0/I0/I7/I3/Q1" "vdd" )
temp( 30.0 )
run( ?jobName "job" ?queue "c2107" ?host "rattle" )
selectResult( 'tran )
plot(getData("/ReadEn") getData("/R_Address<11:0>") getData("/WriteEn") getData("/W_Address<11:0>") getData("/WData<31:0>") getData("/WDataAck<15:0>") getData("/RData<31:0>") getData("/ReadAck") getData("/WriteAck") getData("/ReadEnT") getData("/R_AddressT<11>") getData("/R_AddressT<10>") getData("/R_AddressT<9>") getData("/R_AddressT<8>") getData("/R_AddressT<7>") getData("/R_AddressT<6>") getData("/R_AddressT<5>") getData("/R_AddressT<4>") getData("/R_AddressT<3>") getData("/R_AddressT<2>") getData("/R_AddressT<1>") getData("/R_AddressT<0>") getData("/W_AddressT<11>") getData("/W_AddressT<10>") getData("/W_AddressT<9>") getData("/W_AddressT<8>") getData("/W_AddressT<7>") getData("/W_AddressT<6>") getData("/W_AddressT<5>") getData("/W_AddressT<4>") getData("/W_AddressT<3>") getData("/W_AddressT<2>") getData("/W_AddressT<1>") getData("/W_AddressT<0>") getData("/WriteEnT") getData("/WDataT<31>") getData("/WDataT<30>") getData("/WDataT<29>") getData("/WDataT<28>") getData("/WDataT<27>") getData("/WDataT<26>") getData("/WDataT<25>") getData("/WDataT<24>") getData("/WDataT<23>") getData("/WDataT<22>") getData("/WDataT<21>") getData("/WDataT<20>") getData("/WDataT<19>") getData("/WDataT<18>") getData("/WDataT<17>") getData("/WDataT<16>") getData("/WDataT<15>") getData("/WDataT<14>") getData("/WDataT<13>") getData("/WDataT<12>") getData("/WDataT<11>") getData("/WDataT<10>") getData("/WDataT<9>") getData("/WDataT<8>") getData("/WDataT<7>") getData("/WDataT<6>") getData("/WDataT<5>") getData("/WDataT<4>") getData("/WDataT<3>") getData("/WDataT<2>") getData("/WDataT<1>") getData("/WDataT<0>") getData("/WDataAckT<15>") getData("/WDataAckT<14>") getData("/WDataAckT<13>") getData("/WDataAckT<12>") getData("/WDataAckT<11>") getData("/WDataAckT<10>") getData("/WDataAckT<9>") getData("/WDataAckT<8>") getData("/WDataAckT<7>") getData("/WDataAckT<6>") getData("/WDataAckT<5>") getData("/WDataAckT<4>") getData("/WDataAckT<3>") getData("/WDataAckT<2>") getData("/WDataAckT<1>") getData("/WDataAckT<0>") getData("/RDataT<31>") getData("/RDataT<30>") getData("/RDataT<29>") getData("/RDataT<28>") getData("/RDataT<27>") getData("/RDataT<26>") getData("/RDataT<25>") getData("/RDataT<24>") getData("/RDataT<23>") getData("/RDataT<22>") getData("/RDataT<21>") getData("/RDataT<20>") getData("/RDataT<19>") getData("/RDataT<18>") getData("/RDataT<17>") getData("/RDataT<16>") getData("/RDataT<15>") getData("/RDataT<14>") getData("/RDataT<13>") getData("/RDataT<12>") getData("/RDataT<11>") getData("/RDataT<10>") getData("/RDataT<9>") getData("/RDataT<8>") getData("/RDataT<7>") getData("/RDataT<6>") getData("/RDataT<5>") getData("/RDataT<4>") getData("/RDataT<3>") getData("/RDataT<2>") getData("/RDataT<1>") getData("/RDataT<0>") getData("/RAckT") getData("/WAckT") getData("/V0/MINUS") )
resultsDir( "/net/bull/apps/Cadence/simulation/6T_MultiBank_16K_8K_Test/spectreVerilog/config/distributed/MBank_16K_r8K_675mV_30C" )
modelFile(
    '("/software/cadence/ncsu-FreePDK15/hspice_16nm_hp.include" "")
)
desVar(	  "vdd" .675	)
run( ?jobName "job" ?queue "c2107" ?host "crowned" )
selectResult( 'tran )
plot(getData("/ReadEn") getData("/R_Address<11:0>") getData("/WriteEn") getData("/W_Address<11:0>") getData("/WData<31:0>") getData("/WDataAck<15:0>") getData("/RData<31:0>") getData("/ReadAck") getData("/WriteAck") getData("/ReadEnT") getData("/R_AddressT<11>") getData("/R_AddressT<10>") getData("/R_AddressT<9>") getData("/R_AddressT<8>") getData("/R_AddressT<7>") getData("/R_AddressT<6>") getData("/R_AddressT<5>") getData("/R_AddressT<4>") getData("/R_AddressT<3>") getData("/R_AddressT<2>") getData("/R_AddressT<1>") getData("/R_AddressT<0>") getData("/W_AddressT<11>") getData("/W_AddressT<10>") getData("/W_AddressT<9>") getData("/W_AddressT<8>") getData("/W_AddressT<7>") getData("/W_AddressT<6>") getData("/W_AddressT<5>") getData("/W_AddressT<4>") getData("/W_AddressT<3>") getData("/W_AddressT<2>") getData("/W_AddressT<1>") getData("/W_AddressT<0>") getData("/WriteEnT") getData("/WDataT<31>") getData("/WDataT<30>") getData("/WDataT<29>") getData("/WDataT<28>") getData("/WDataT<27>") getData("/WDataT<26>") getData("/WDataT<25>") getData("/WDataT<24>") getData("/WDataT<23>") getData("/WDataT<22>") getData("/WDataT<21>") getData("/WDataT<20>") getData("/WDataT<19>") getData("/WDataT<18>") getData("/WDataT<17>") getData("/WDataT<16>") getData("/WDataT<15>") getData("/WDataT<14>") getData("/WDataT<13>") getData("/WDataT<12>") getData("/WDataT<11>") getData("/WDataT<10>") getData("/WDataT<9>") getData("/WDataT<8>") getData("/WDataT<7>") getData("/WDataT<6>") getData("/WDataT<5>") getData("/WDataT<4>") getData("/WDataT<3>") getData("/WDataT<2>") getData("/WDataT<1>") getData("/WDataT<0>") getData("/WDataAckT<15>") getData("/WDataAckT<14>") getData("/WDataAckT<13>") getData("/WDataAckT<12>") getData("/WDataAckT<11>") getData("/WDataAckT<10>") getData("/WDataAckT<9>") getData("/WDataAckT<8>") getData("/WDataAckT<7>") getData("/WDataAckT<6>") getData("/WDataAckT<5>") getData("/WDataAckT<4>") getData("/WDataAckT<3>") getData("/WDataAckT<2>") getData("/WDataAckT<1>") getData("/WDataAckT<0>") getData("/RDataT<31>") getData("/RDataT<30>") getData("/RDataT<29>") getData("/RDataT<28>") getData("/RDataT<27>") getData("/RDataT<26>") getData("/RDataT<25>") getData("/RDataT<24>") getData("/RDataT<23>") getData("/RDataT<22>") getData("/RDataT<21>") getData("/RDataT<20>") getData("/RDataT<19>") getData("/RDataT<18>") getData("/RDataT<17>") getData("/RDataT<16>") getData("/RDataT<15>") getData("/RDataT<14>") getData("/RDataT<13>") getData("/RDataT<12>") getData("/RDataT<11>") getData("/RDataT<10>") getData("/RDataT<9>") getData("/RDataT<8>") getData("/RDataT<7>") getData("/RDataT<6>") getData("/RDataT<5>") getData("/RDataT<4>") getData("/RDataT<3>") getData("/RDataT<2>") getData("/RDataT<1>") getData("/RDataT<0>") getData("/RAckT") getData("/WAckT") getData("/V0/MINUS") )
resultsDir( "/net/bull/apps/Cadence/simulation/6T_MultiBank_16K_8K_Test/spectreVerilog/config/distributed/MBank_16K_r8K_850mV_30C" )
modelFile(
    '("/software/cadence/ncsu-FreePDK15/hspice_16nm_hp.include" "")
)
desVar(	  "vdd" .85	)
run( ?jobName "job" ?queue "c2107" ?host "mamba" )
selectResult( 'tran )
plot(getData("/ReadEn") getData("/R_Address<11:0>") getData("/WriteEn") getData("/W_Address<11:0>") getData("/WData<31:0>") getData("/WDataAck<15:0>") getData("/RData<31:0>") getData("/ReadAck") getData("/WriteAck") getData("/ReadEnT") getData("/R_AddressT<11>") getData("/R_AddressT<10>") getData("/R_AddressT<9>") getData("/R_AddressT<8>") getData("/R_AddressT<7>") getData("/R_AddressT<6>") getData("/R_AddressT<5>") getData("/R_AddressT<4>") getData("/R_AddressT<3>") getData("/R_AddressT<2>") getData("/R_AddressT<1>") getData("/R_AddressT<0>") getData("/W_AddressT<11>") getData("/W_AddressT<10>") getData("/W_AddressT<9>") getData("/W_AddressT<8>") getData("/W_AddressT<7>") getData("/W_AddressT<6>") getData("/W_AddressT<5>") getData("/W_AddressT<4>") getData("/W_AddressT<3>") getData("/W_AddressT<2>") getData("/W_AddressT<1>") getData("/W_AddressT<0>") getData("/WriteEnT") getData("/WDataT<31>") getData("/WDataT<30>") getData("/WDataT<29>") getData("/WDataT<28>") getData("/WDataT<27>") getData("/WDataT<26>") getData("/WDataT<25>") getData("/WDataT<24>") getData("/WDataT<23>") getData("/WDataT<22>") getData("/WDataT<21>") getData("/WDataT<20>") getData("/WDataT<19>") getData("/WDataT<18>") getData("/WDataT<17>") getData("/WDataT<16>") getData("/WDataT<15>") getData("/WDataT<14>") getData("/WDataT<13>") getData("/WDataT<12>") getData("/WDataT<11>") getData("/WDataT<10>") getData("/WDataT<9>") getData("/WDataT<8>") getData("/WDataT<7>") getData("/WDataT<6>") getData("/WDataT<5>") getData("/WDataT<4>") getData("/WDataT<3>") getData("/WDataT<2>") getData("/WDataT<1>") getData("/WDataT<0>") getData("/WDataAckT<15>") getData("/WDataAckT<14>") getData("/WDataAckT<13>") getData("/WDataAckT<12>") getData("/WDataAckT<11>") getData("/WDataAckT<10>") getData("/WDataAckT<9>") getData("/WDataAckT<8>") getData("/WDataAckT<7>") getData("/WDataAckT<6>") getData("/WDataAckT<5>") getData("/WDataAckT<4>") getData("/WDataAckT<3>") getData("/WDataAckT<2>") getData("/WDataAckT<1>") getData("/WDataAckT<0>") getData("/RDataT<31>") getData("/RDataT<30>") getData("/RDataT<29>") getData("/RDataT<28>") getData("/RDataT<27>") getData("/RDataT<26>") getData("/RDataT<25>") getData("/RDataT<24>") getData("/RDataT<23>") getData("/RDataT<22>") getData("/RDataT<21>") getData("/RDataT<20>") getData("/RDataT<19>") getData("/RDataT<18>") getData("/RDataT<17>") getData("/RDataT<16>") getData("/RDataT<15>") getData("/RDataT<14>") getData("/RDataT<13>") getData("/RDataT<12>") getData("/RDataT<11>") getData("/RDataT<10>") getData("/RDataT<9>") getData("/RDataT<8>") getData("/RDataT<7>") getData("/RDataT<6>") getData("/RDataT<5>") getData("/RDataT<4>") getData("/RDataT<3>") getData("/RDataT<2>") getData("/RDataT<1>") getData("/RDataT<0>") getData("/RAckT") getData("/WAckT") getData("/V0/MINUS") )
