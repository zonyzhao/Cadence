simulator( 'spectreVerilog )
design(	 "/net/kafka/nfs/rstdenis/Cadence/simulation/Compare22_Test/spectreVerilog/config/netlist/analog/netlist")
resultsDir( "/net/kafka/nfs/rstdenis/Cadence/simulation/Compare22_Test/spectreVerilog/config" )
modelFile(
    '("/software/cadence/ncsu-FreePDK15/hspice_16nm_hp.include" "")
)
analysis('tran ?stop "10n"  ?errpreset "conservative"  )
desVar(	  "vdd" .850	)
envOption(
	'mspSetupNetlistSimPrecisionUnit  "ps"
	'mspSetupNetlistSimTimeUnit  "ps"
	'mspSetupNetlistSwitchRC  t
	'analysisOrder  list("tran")
)
option(	'multithread  "on"
)
saveOption( ?simOutputFormat "psfxl" )
converge( 'ic "/I4/I10/I0/net26" nil )
converge( 'ic "/net032<23>" nil )
converge( 'ic "/net033<23>" nil )
converge( 'ic "/net031<23>" nil )
converge( 'ic "/net030<23>" nil )
converge( 'ic "/I4/I10/net16" nil )
converge( 'ic "/Hit" nil )
converge( 'ic "/Valid" nil )
converge( 'ic "/Miss" nil )
converge( 'ic "/I4/1y0<3>" nil )
converge( 'ic "/I4/1y0<2>" nil )
converge( 'ic "/I4/1y0<1>" nil )
converge( 'ic "/I4/1y0<0>" nil )
converge( 'ic "/I4/3y0<3>" nil )
converge( 'ic "/I4/3y0<2>" nil )
converge( 'ic "/I4/3y0<1>" nil )
converge( 'ic "/I4/3y0<0>" nil )
converge( 'ic "/I4/2y1<3>" nil )
converge( 'ic "/I4/2y1<2>" nil )
converge( 'ic "/I4/2y1<1>" nil )
converge( 'ic "/I4/2y1<0>" nil )
converge( 'ic "/I4/3y1<3>" nil )
converge( 'ic "/I4/3y1<2>" nil )
converge( 'ic "/I4/3y1<1>" nil )
converge( 'ic "/I4/3y1<0>" nil )
converge( 'ic "/I4/1y1<3>" nil )
converge( 'ic "/I4/1y1<2>" nil )
converge( 'ic "/I4/1y1<1>" nil )
converge( 'ic "/I4/1y1<0>" nil )
converge( 'ic "/I4/2y0<3>" nil )
converge( 'ic "/I4/2y0<2>" nil )
converge( 'ic "/I4/2y0<1>" nil )
converge( 'ic "/I4/2y0<0>" nil )
converge( 'ic "/I4/4y0<3>" nil )
converge( 'ic "/I4/4y0<2>" nil )
converge( 'ic "/I4/4y0<1>" nil )
converge( 'ic "/I4/4y0<0>" nil )
converge( 'ic "/I4/5y0<3>" nil )
converge( 'ic "/I4/5y0<2>" nil )
converge( 'ic "/I4/5y0<1>" nil )
converge( 'ic "/I4/5y0<0>" nil )
converge( 'ic "/I4/4y1<3>" nil )
converge( 'ic "/I4/4y1<2>" nil )
converge( 'ic "/I4/4y1<1>" nil )
converge( 'ic "/I4/4y1<0>" nil )
converge( 'ic "/I4/5y1<3>" nil )
converge( 'ic "/I4/5y1<2>" nil )
converge( 'ic "/I4/5y1<1>" nil )
converge( 'ic "/I4/5y1<0>" nil )
converge( 'ic "/a1<23:0>" nil )
converge( 'ic "/a0<23:0>" nil )
converge( 'ic "/b1<23:0>" nil )
converge( 'ic "/b0<23:0>" nil )
temp( 27 )
run()
selectResult( 'tran )
plot(getData("/b0<23:0>") getData("/b1<23:0>") getData("/a0<23:0>") getData("/a1<23:0>") getData("/Hit") getData("/Valid") getData("/Miss") )
