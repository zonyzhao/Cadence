simulator( 'spectreVerilog )
design(	 "/net/kafka/nfs/rstdenis/Cadence/simulation/Compare22_Test/spectreVerilog/config/netlist/analog/netlist")
resultsDir( "/net/kafka/nfs/rstdenis/Cadence/simulation/Compare22_Test/spectreVerilog/config" )
modelFile(
    '("/software/cadence/ncsu-FreePDK15/hspice_16nm_hp.include" "")
)
analysis('tran ?stop "10n"  ?errpreset "conservative"  )
desVar(	  "vdd" .850	)
envOption(
	'mspSetupNetlistSimPrecisionUnit  "ps"
	'mspSetupNetlistSimTimeUnit  "ps"
	'mspSetupNetlistSwitchRC  t
	'analysisOrder  list("tran")
)
saveOption( ?simOutputFormat "psfxl" )
converge( 'ic "/net030<23>" "0" )
converge( 'ic "/net030<22>" "0" )
converge( 'ic "/net030<21>" "0" )
converge( 'ic "/net030<20>" "0" )
converge( 'ic "/net030<19>" "0" )
converge( 'ic "/net030<18>" "0" )
converge( 'ic "/net030<17>" "0" )
converge( 'ic "/net030<16>" "0" )
converge( 'ic "/net030<15>" "0" )
converge( 'ic "/net030<14>" "0" )
converge( 'ic "/net030<13>" "0" )
converge( 'ic "/net030<12>" "0" )
converge( 'ic "/net030<11>" "0" )
converge( 'ic "/net030<10>" "0" )
converge( 'ic "/net030<9>" "0" )
converge( 'ic "/net030<8>" "0" )
converge( 'ic "/net030<7>" "0" )
converge( 'ic "/net030<6>" "0" )
converge( 'ic "/net030<5>" "0" )
converge( 'ic "/net030<4>" "0" )
converge( 'ic "/net030<3>" "0" )
converge( 'ic "/net030<2>" "0" )
converge( 'ic "/net030<1>" "0" )
converge( 'ic "/net030<0>" "0" )
converge( 'ic "/net031<23>" "0" )
converge( 'ic "/net031<22>" "0" )
converge( 'ic "/net031<21>" "0" )
converge( 'ic "/net031<20>" "0" )
converge( 'ic "/net031<19>" "0" )
converge( 'ic "/net031<18>" "0" )
converge( 'ic "/net031<17>" "0" )
converge( 'ic "/net031<16>" "0" )
converge( 'ic "/net031<15>" "0" )
converge( 'ic "/net031<14>" "0" )
converge( 'ic "/net031<13>" "0" )
converge( 'ic "/net031<12>" "0" )
converge( 'ic "/net031<11>" "0" )
converge( 'ic "/net031<10>" "0" )
converge( 'ic "/net031<9>" "0" )
converge( 'ic "/net031<8>" "0" )
converge( 'ic "/net031<7>" "0" )
converge( 'ic "/net031<6>" "0" )
converge( 'ic "/net031<5>" "0" )
converge( 'ic "/net031<4>" "0" )
converge( 'ic "/net031<3>" "0" )
converge( 'ic "/net031<2>" "0" )
converge( 'ic "/net031<1>" "0" )
converge( 'ic "/net031<0>" "0" )
converge( 'ic "/net032<23>" "0" )
converge( 'ic "/net032<22>" "0" )
converge( 'ic "/net032<21>" "0" )
converge( 'ic "/net032<20>" "0" )
converge( 'ic "/net032<19>" "0" )
converge( 'ic "/net032<18>" "0" )
converge( 'ic "/net032<17>" "0" )
converge( 'ic "/net032<16>" "0" )
converge( 'ic "/net032<15>" "0" )
converge( 'ic "/net032<14>" "0" )
converge( 'ic "/net032<13>" "0" )
converge( 'ic "/net032<12>" "0" )
converge( 'ic "/net032<11>" "0" )
converge( 'ic "/net032<10>" "0" )
converge( 'ic "/net032<9>" "0" )
converge( 'ic "/net032<8>" "0" )
converge( 'ic "/net032<7>" "0" )
converge( 'ic "/net032<6>" "0" )
converge( 'ic "/net032<5>" "0" )
converge( 'ic "/net032<4>" "0" )
converge( 'ic "/net032<3>" "0" )
converge( 'ic "/net032<2>" "0" )
converge( 'ic "/net032<1>" "0" )
converge( 'ic "/net032<0>" "0" )
converge( 'ic "/net033<23>" "0" )
converge( 'ic "/net033<22>" "0" )
converge( 'ic "/net033<21>" "0" )
converge( 'ic "/net033<20>" "0" )
converge( 'ic "/net033<19>" "0" )
converge( 'ic "/net033<18>" "0" )
converge( 'ic "/net033<17>" "0" )
converge( 'ic "/net033<16>" "0" )
converge( 'ic "/net033<15>" "0" )
converge( 'ic "/net033<14>" "0" )
converge( 'ic "/net033<13>" "0" )
converge( 'ic "/net033<12>" "0" )
converge( 'ic "/net033<11>" "0" )
converge( 'ic "/net033<10>" "0" )
converge( 'ic "/net033<9>" "0" )
converge( 'ic "/net033<8>" "0" )
converge( 'ic "/net033<7>" "0" )
converge( 'ic "/net033<6>" "0" )
converge( 'ic "/net033<5>" "0" )
converge( 'ic "/net033<4>" "0" )
converge( 'ic "/net033<3>" "0" )
converge( 'ic "/net033<2>" "0" )
converge( 'ic "/net033<1>" "0" )
converge( 'ic "/net033<0>" "0" )
temp( 27 )
run()
selectResult( 'tran )
plot(getData("/Miss") getData("/Valid") getData("/Hit") getData("/b0<23:0>") getData("/b1<23:0>") getData("/a0<23:0>") getData("/a1<23:0>") )
modelFile(
    '("/software/cadence/ncsu-FreePDK15/hspice_16nm_hp.include" "")
)
run()
selectResult( 'tran )
plot(getData("/I4/sfy1<0>") getData("/I4/sfy1<1>") getData("/I4/sfy0<1>") getData("/I4/sfy0<0>") getData("/I4/s3_y0<3>") getData("/I4/s3_y0<2>") getData("/I4/s3_y1<1>") getData("/I4/s3_y1<0>") getData("/I4/s3_y1<3>") getData("/I4/s3_y1<2>") getData("/I4/s3_y0<1>") getData("/I4/s3_y0<0>") getData("/I4/s2_n3_y1<3>") getData("/I4/s2_n3_y1<2>") getData("/I4/s2_n3_y1<1>") getData("/I4/s2_n3_y1<0>") getData("/I4/s2_n3_y0<3>") getData("/I4/s2_n3_y0<2>") getData("/I4/s2_n3_y0<1>") getData("/I4/s2_n3_y0<0>") getData("/I4/net47<0>") getData("/I4/net47<1>") getData("/I4/net47<2>") getData("/I4/net47<3>") getData("/I4/net46<0>") getData("/I4/net46<1>") getData("/I4/net46<2>") getData("/I4/net46<3>") getData("/I4/s2_n2_y1<3>") getData("/I4/s2_n2_y1<2>") getData("/I4/s2_n2_y1<1>") getData("/I4/s2_n2_y1<0>") getData("/I4/s2_n1_y0<3>") getData("/I4/s2_n1_y0<2>") getData("/I4/s2_n1_y0<1>") getData("/I4/s2_n1_y0<0>") getData("/I4/s2_n2_y0<3>") getData("/I4/s2_n2_y0<2>") getData("/I4/s2_n2_y0<1>") getData("/I4/s2_n2_y0<0>") getData("/I4/s2_n1_y1<3>") getData("/I4/s2_n1_y1<2>") getData("/I4/s2_n1_y1<1>") getData("/I4/s2_n1_y1<0>") getData("/I4/1y0<3>") getData("/I4/1y0<2>") getData("/I4/1y0<1>") getData("/I4/1y0<0>") getData("/I4/1y1<3>") getData("/I4/1y1<2>") getData("/I4/1y1<1>") getData("/I4/1y1<0>") getData("/I4/2y0<3>") getData("/I4/2y0<2>") getData("/I4/2y0<1>") getData("/I4/2y0<0>") getData("/I4/2y1<3>") getData("/I4/2y1<2>") getData("/I4/2y1<1>") getData("/I4/2y1<0>") getData("/a1<23:0>") getData("/a0<23:0>") getData("/b1<23:0>") getData("/b0<23:0>") getData("/Hit") getData("/Valid") getData("/Miss") )
modelFile(
    '("/software/cadence/ncsu-FreePDK15/hspice_16nm_hp.include" "")
)
run()
selectResult( 'tran )
plot(getData("/a1<23:0>") getData("/a0<23:0>") getData("/b1<23:0>") getData("/b0<23:0>") getData("/Hit") getData("/Valid") getData("/Miss") getData("/I4/1y0<3>") getData("/I4/1y0<2>") getData("/I4/1y0<1>") getData("/I4/1y0<0>") getData("/I4/1y1<3>") getData("/I4/1y1<2>") getData("/I4/1y1<1>") getData("/I4/1y1<0>") getData("/I4/2y0<3>") getData("/I4/2y0<2>") getData("/I4/2y0<1>") getData("/I4/2y0<0>") getData("/I4/2y1<3>") getData("/I4/2y1<2>") getData("/I4/2y1<1>") getData("/I4/2y1<0>") getData("/I4/s2_n2_y1<3>") getData("/I4/s2_n2_y1<2>") getData("/I4/s2_n2_y1<1>") getData("/I4/s2_n2_y1<0>") getData("/I4/s2_n1_y0<3>") getData("/I4/s2_n1_y0<2>") getData("/I4/s2_n1_y0<1>") getData("/I4/s2_n1_y0<0>") getData("/I4/s2_n2_y0<3>") getData("/I4/s2_n2_y0<2>") getData("/I4/s2_n2_y0<1>") getData("/I4/s2_n2_y0<0>") getData("/I4/s2_n1_y1<3>") getData("/I4/s2_n1_y1<2>") getData("/I4/s2_n1_y1<1>") getData("/I4/s2_n1_y1<0>") getData("/I4/s2_n3_y1<3>") getData("/I4/s2_n3_y1<2>") getData("/I4/s2_n3_y1<1>") getData("/I4/s2_n3_y1<0>") getData("/I4/s2_n3_y0<3>") getData("/I4/s2_n3_y0<2>") getData("/I4/s2_n3_y0<1>") getData("/I4/s2_n3_y0<0>") getData("/I4/net47<0>") getData("/I4/net47<1>") getData("/I4/net47<2>") getData("/I4/net47<3>") getData("/I4/net46<0>") getData("/I4/net46<1>") getData("/I4/net46<2>") getData("/I4/net46<3>") getData("/I4/s3_y0<3>") getData("/I4/s3_y0<2>") getData("/I4/s3_y1<1>") getData("/I4/s3_y1<0>") getData("/I4/s3_y1<3>") getData("/I4/s3_y1<2>") getData("/I4/s3_y0<1>") getData("/I4/s3_y0<0>") getData("/I4/sfy1<0>") getData("/I4/sfy1<1>") getData("/I4/sfy0<1>") getData("/I4/sfy0<0>") )
modelFile(
    '("/software/cadence/ncsu-FreePDK15/hspice_16nm_hp.include" "")
)
run()
selectResult( 'tran )
plot(getData("/a1<23:0>") getData("/a0<23:0>") getData("/b1<23:0>") getData("/b0<23:0>") getData("/Hit") getData("/Valid") getData("/Miss") getData("/I4/1y0<3>") getData("/I4/1y0<2>") getData("/I4/1y0<1>") getData("/I4/1y0<0>") getData("/I4/1y1<3>") getData("/I4/1y1<2>") getData("/I4/1y1<1>") getData("/I4/1y1<0>") getData("/I4/2y0<3>") getData("/I4/2y0<2>") getData("/I4/2y0<1>") getData("/I4/2y0<0>") getData("/I4/2y1<3>") getData("/I4/2y1<2>") getData("/I4/2y1<1>") getData("/I4/2y1<0>") getData("/I4/s2_n2_y1<3>") getData("/I4/s2_n2_y1<2>") getData("/I4/s2_n2_y1<1>") getData("/I4/s2_n2_y1<0>") getData("/I4/s2_n1_y0<3>") getData("/I4/s2_n1_y0<2>") getData("/I4/s2_n1_y0<1>") getData("/I4/s2_n1_y0<0>") getData("/I4/s2_n2_y0<3>") getData("/I4/s2_n2_y0<2>") getData("/I4/s2_n2_y0<1>") getData("/I4/s2_n2_y0<0>") getData("/I4/s2_n1_y1<3>") getData("/I4/s2_n1_y1<2>") getData("/I4/s2_n1_y1<1>") getData("/I4/s2_n1_y1<0>") getData("/I4/s2_n3_y1<3>") getData("/I4/s2_n3_y1<2>") getData("/I4/s2_n3_y1<1>") getData("/I4/s2_n3_y1<0>") getData("/I4/s2_n3_y0<3>") getData("/I4/s2_n3_y0<2>") getData("/I4/s2_n3_y0<1>") getData("/I4/s2_n3_y0<0>") getData("/I4/net47<0>") getData("/I4/net47<1>") getData("/I4/net47<2>") getData("/I4/net47<3>") getData("/I4/net46<0>") getData("/I4/net46<1>") getData("/I4/net46<2>") getData("/I4/net46<3>") getData("/I4/s3_y0<3>") getData("/I4/s3_y0<2>") getData("/I4/s3_y1<1>") getData("/I4/s3_y1<0>") getData("/I4/s3_y1<3>") getData("/I4/s3_y1<2>") getData("/I4/s3_y0<1>") getData("/I4/s3_y0<0>") getData("/I4/sfy1<0>") getData("/I4/sfy1<1>") getData("/I4/sfy0<1>") getData("/I4/sfy0<0>") )
modelFile(
    '("/software/cadence/ncsu-FreePDK15/hspice_16nm_hp.include" "")
)
run()
selectResult( 'tran )
plot(getData("/a1<23:0>") getData("/a0<23:0>") getData("/b1<23:0>") getData("/b0<23:0>") getData("/Hit") getData("/Valid") getData("/Miss") getData("/I4/1y0<3>") getData("/I4/1y0<2>") getData("/I4/1y0<1>") getData("/I4/1y0<0>") getData("/I4/1y1<3>") getData("/I4/1y1<2>") getData("/I4/1y1<1>") getData("/I4/1y1<0>") getData("/I4/2y0<3>") getData("/I4/2y0<2>") getData("/I4/2y0<1>") getData("/I4/2y0<0>") getData("/I4/2y1<3>") getData("/I4/2y1<2>") getData("/I4/2y1<1>") getData("/I4/2y1<0>") getData("/I4/s2_n2_y1<3>") getData("/I4/s2_n2_y1<2>") getData("/I4/s2_n2_y1<1>") getData("/I4/s2_n2_y1<0>") getData("/I4/s2_n1_y0<3>") getData("/I4/s2_n1_y0<2>") getData("/I4/s2_n1_y0<1>") getData("/I4/s2_n1_y0<0>") getData("/I4/s2_n2_y0<3>") getData("/I4/s2_n2_y0<2>") getData("/I4/s2_n2_y0<1>") getData("/I4/s2_n2_y0<0>") getData("/I4/s2_n1_y1<3>") getData("/I4/s2_n1_y1<2>") getData("/I4/s2_n1_y1<1>") getData("/I4/s2_n1_y1<0>") getData("/I4/s2_n3_y1<3>") getData("/I4/s2_n3_y1<2>") getData("/I4/s2_n3_y1<1>") getData("/I4/s2_n3_y1<0>") getData("/I4/s2_n3_y0<3>") getData("/I4/s2_n3_y0<2>") getData("/I4/s2_n3_y0<1>") getData("/I4/s2_n3_y0<0>") getData("/I4/net47<0>") getData("/I4/net47<1>") getData("/I4/net47<2>") getData("/I4/net47<3>") getData("/I4/net46<0>") getData("/I4/net46<1>") getData("/I4/net46<2>") getData("/I4/net46<3>") getData("/I4/s3_y0<3>") getData("/I4/s3_y0<2>") getData("/I4/s3_y1<1>") getData("/I4/s3_y1<0>") getData("/I4/s3_y1<3>") getData("/I4/s3_y1<2>") getData("/I4/s3_y0<1>") getData("/I4/s3_y0<0>") getData("/I4/sfy1<0>") getData("/I4/sfy1<1>") getData("/I4/sfy0<1>") getData("/I4/sfy0<0>") )
