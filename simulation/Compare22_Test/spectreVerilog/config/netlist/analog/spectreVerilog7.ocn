simulator( 'spectreVerilog )
design(	 "/net/kafka/nfs/rstdenis/Cadence/simulation/Compare22_Test/spectreVerilog/config/netlist/analog/netlist")
resultsDir( "/net/kafka/nfs/rstdenis/Cadence/simulation/Compare22_Test/spectreVerilog/config" )
modelFile(
    '("/software/cadence/ncsu-FreePDK15/hspice_16nm_hp.include" "")
)
analysis('tran ?stop "10n"  ?errpreset "conservative"  )
desVar(	  "vdd" .850	)
envOption(
	'mspSetupNetlistSimPrecisionUnit  "ps"
	'mspSetupNetlistSimTimeUnit  "ps"
	'mspSetupNetlistSwitchRC  t
	'analysisOrder  list("tran")
)
option(	'multithread  "on"
)
saveOption( ?simOutputFormat "psfxl" )
converge( 'ic "/net012" "0" )
converge( 'ic "/net15" "0" )
converge( 'ic "/net20" "0" )
run()
selectResult( 'tran )
plot(getData("/Hit") getData("/Valid") getData("/Miss") getData("/I4/1y0<3>") getData("/I4/1y0<2>") getData("/I4/1y0<1>") getData("/I4/1y0<0>") getData("/I4/3y0<3>") getData("/I4/3y0<2>") getData("/I4/3y0<1>") getData("/I4/3y0<0>") getData("/I4/2y1<3>") getData("/I4/2y1<2>") getData("/I4/2y1<1>") getData("/I4/2y1<0>") getData("/I4/3y1<3>") getData("/I4/3y1<2>") getData("/I4/3y1<1>") getData("/I4/3y1<0>") getData("/I4/1y1<3>") getData("/I4/1y1<2>") getData("/I4/1y1<1>") getData("/I4/1y1<0>") getData("/I4/2y0<3>") getData("/I4/2y0<2>") getData("/I4/2y0<1>") getData("/I4/2y0<0>") getData("/I4/4y0<3>") getData("/I4/4y0<2>") getData("/I4/4y0<1>") getData("/I4/4y0<0>") getData("/I4/5y0<3>") getData("/I4/5y0<2>") getData("/I4/5y0<1>") getData("/I4/5y0<0>") getData("/I4/4y1<3>") getData("/I4/4y1<2>") getData("/I4/4y1<1>") getData("/I4/4y1<0>") getData("/I4/5y1<3>") getData("/I4/5y1<2>") getData("/I4/5y1<1>") getData("/I4/5y1<0>") getData("/a1<23:0>") getData("/a0<23:0>") getData("/b1<23:0>") getData("/b0<23:0>") )
modelFile(
    '("/software/cadence/ncsu-FreePDK15/hspice_16nm_hp.include" "")
)
run()
selectResult( 'tran )
plot(getData("/I4/I10/I0/net26") getData("/net032<23>") getData("/net033<23>") getData("/net031<23>") getData("/net030<23>") getData("/I4/I10/net16") getData("/Hit") getData("/Valid") getData("/Miss") getData("/I4/1y0<3>") getData("/I4/1y0<2>") getData("/I4/1y0<1>") getData("/I4/1y0<0>") getData("/I4/3y0<3>") getData("/I4/3y0<2>") getData("/I4/3y0<1>") getData("/I4/3y0<0>") getData("/I4/2y1<3>") getData("/I4/2y1<2>") getData("/I4/2y1<1>") getData("/I4/2y1<0>") getData("/I4/3y1<3>") getData("/I4/3y1<2>") getData("/I4/3y1<1>") getData("/I4/3y1<0>") getData("/I4/1y1<3>") getData("/I4/1y1<2>") getData("/I4/1y1<1>") getData("/I4/1y1<0>") getData("/I4/2y0<3>") getData("/I4/2y0<2>") getData("/I4/2y0<1>") getData("/I4/2y0<0>") getData("/I4/4y0<3>") getData("/I4/4y0<2>") getData("/I4/4y0<1>") getData("/I4/4y0<0>") getData("/I4/5y0<3>") getData("/I4/5y0<2>") getData("/I4/5y0<1>") getData("/I4/5y0<0>") getData("/I4/4y1<3>") getData("/I4/4y1<2>") getData("/I4/4y1<1>") getData("/I4/4y1<0>") getData("/I4/5y1<3>") getData("/I4/5y1<2>") getData("/I4/5y1<1>") getData("/I4/5y1<0>") getData("/a1<23:0>") getData("/a0<23:0>") getData("/b1<23:0>") getData("/b0<23:0>") )
modelFile(
    '("/software/cadence/ncsu-FreePDK15/hspice_16nm_hp.include" "")
)
run()
selectResult( 'tran )
plot(getData("/Hit") getData("/Valid") getData("/Miss") getData("/I4/1y0<3>") getData("/I4/1y0<2>") getData("/I4/1y0<1>") getData("/I4/1y0<0>") getData("/I4/3y0<3>") getData("/I4/3y0<2>") getData("/I4/3y0<1>") getData("/I4/3y0<0>") getData("/I4/2y1<3>") getData("/I4/2y1<2>") getData("/I4/2y1<1>") getData("/I4/2y1<0>") getData("/I4/3y1<3>") getData("/I4/3y1<2>") getData("/I4/3y1<1>") getData("/I4/3y1<0>") getData("/I4/1y1<3>") getData("/I4/1y1<2>") getData("/I4/1y1<1>") getData("/I4/1y1<0>") getData("/I4/2y0<3>") getData("/I4/2y0<2>") getData("/I4/2y0<1>") getData("/I4/2y0<0>") getData("/I4/4y0<3>") getData("/I4/4y0<2>") getData("/I4/4y0<1>") getData("/I4/4y0<0>") getData("/I4/5y0<3>") getData("/I4/5y0<2>") getData("/I4/5y0<1>") getData("/I4/5y0<0>") getData("/I4/4y1<3>") getData("/I4/4y1<2>") getData("/I4/4y1<1>") getData("/I4/4y1<0>") getData("/I4/5y1<3>") getData("/I4/5y1<2>") getData("/I4/5y1<1>") getData("/I4/5y1<0>") getData("/a1<23:0>") getData("/a0<23:0>") getData("/b1<23:0>") getData("/b0<23:0>") getData("/I4/I10/net16") getData("/net030<23>") getData("/net031<23>") getData("/net033<23>") getData("/net032<23>") getData("/I4/I10/I0/net26") )
modelFile(
    '("/software/cadence/ncsu-FreePDK15/hspice_16nm_hp.include" "")
)
run()
selectResult( 'tran )
plot(getData("/Hit") getData("/Valid") getData("/Miss") getData("/I4/1y0<3>") getData("/I4/1y0<2>") getData("/I4/1y0<1>") getData("/I4/1y0<0>") getData("/I4/3y0<3>") getData("/I4/3y0<2>") getData("/I4/3y0<1>") getData("/I4/3y0<0>") getData("/I4/2y1<3>") getData("/I4/2y1<2>") getData("/I4/2y1<1>") getData("/I4/2y1<0>") getData("/I4/3y1<3>") getData("/I4/3y1<2>") getData("/I4/3y1<1>") getData("/I4/3y1<0>") getData("/I4/1y1<3>") getData("/I4/1y1<2>") getData("/I4/1y1<1>") getData("/I4/1y1<0>") getData("/I4/2y0<3>") getData("/I4/2y0<2>") getData("/I4/2y0<1>") getData("/I4/2y0<0>") getData("/I4/4y0<3>") getData("/I4/4y0<2>") getData("/I4/4y0<1>") getData("/I4/4y0<0>") getData("/I4/5y0<3>") getData("/I4/5y0<2>") getData("/I4/5y0<1>") getData("/I4/5y0<0>") getData("/I4/4y1<3>") getData("/I4/4y1<2>") getData("/I4/4y1<1>") getData("/I4/4y1<0>") getData("/I4/5y1<3>") getData("/I4/5y1<2>") getData("/I4/5y1<1>") getData("/I4/5y1<0>") getData("/a1<23:0>") getData("/a0<23:0>") getData("/b1<23:0>") getData("/b0<23:0>") getData("/I4/I10/net16") getData("/net030<23>") getData("/net031<23>") getData("/net033<23>") getData("/net032<23>") getData("/I4/I10/I0/net26") )
modelFile(
    '("/software/cadence/ncsu-FreePDK15/hspice_16nm_hp.include" "")
)
converge( 'ic "/I4/I10/I0/net26" nil )
converge( 'ic "/net032<23>" nil )
converge( 'ic "/net033<23>" nil )
converge( 'ic "/net031<23>" nil )
converge( 'ic "/net030<23>" nil )
converge( 'ic "/I4/I10/net16" nil )
converge( 'ic "/Hit" nil )
converge( 'ic "/Valid" nil )
converge( 'ic "/Miss" nil )
converge( 'ic "/I4/1y0<3>" nil )
converge( 'ic "/I4/1y0<2>" nil )
converge( 'ic "/I4/1y0<1>" nil )
converge( 'ic "/I4/1y0<0>" nil )
converge( 'ic "/I4/3y0<3>" nil )
converge( 'ic "/I4/3y0<2>" nil )
converge( 'ic "/I4/3y0<1>" nil )
converge( 'ic "/I4/3y0<0>" nil )
converge( 'ic "/I4/2y1<3>" nil )
converge( 'ic "/I4/2y1<2>" nil )
converge( 'ic "/I4/2y1<1>" nil )
converge( 'ic "/I4/2y1<0>" nil )
converge( 'ic "/I4/3y1<3>" nil )
converge( 'ic "/I4/3y1<2>" nil )
converge( 'ic "/I4/3y1<1>" nil )
converge( 'ic "/I4/3y1<0>" nil )
converge( 'ic "/I4/1y1<3>" nil )
converge( 'ic "/I4/1y1<2>" nil )
converge( 'ic "/I4/1y1<1>" nil )
converge( 'ic "/I4/1y1<0>" nil )
converge( 'ic "/I4/2y0<3>" nil )
converge( 'ic "/I4/2y0<2>" nil )
converge( 'ic "/I4/2y0<1>" nil )
converge( 'ic "/I4/2y0<0>" nil )
converge( 'ic "/I4/4y0<3>" nil )
converge( 'ic "/I4/4y0<2>" nil )
converge( 'ic "/I4/4y0<1>" nil )
converge( 'ic "/I4/4y0<0>" nil )
converge( 'ic "/I4/5y0<3>" nil )
converge( 'ic "/I4/5y0<2>" nil )
converge( 'ic "/I4/5y0<1>" nil )
converge( 'ic "/I4/5y0<0>" nil )
converge( 'ic "/I4/4y1<3>" nil )
converge( 'ic "/I4/4y1<2>" nil )
converge( 'ic "/I4/4y1<1>" nil )
converge( 'ic "/I4/4y1<0>" nil )
converge( 'ic "/I4/5y1<3>" nil )
converge( 'ic "/I4/5y1<2>" nil )
converge( 'ic "/I4/5y1<1>" nil )
converge( 'ic "/I4/5y1<0>" nil )
converge( 'ic "/a1<23:0>" nil )
converge( 'ic "/a0<23:0>" nil )
converge( 'ic "/b1<23:0>" nil )
converge( 'ic "/b0<23:0>" nil )
delete( 'converge 'ic "/net012" )
delete( 'converge 'ic "/net15" )
delete( 'converge 'ic "/net20" )
run()
selectResult( 'tran )
plot(getData("/net20") getData("/net15") getData("/net012") getData("/I4/I10/I0/net26") getData("/net032<23>") getData("/net033<23>") getData("/net031<23>") getData("/net030<23>") getData("/I4/I10/net16") getData("/Hit") getData("/Valid") getData("/Miss") getData("/I4/1y0<3>") getData("/I4/1y0<2>") getData("/I4/1y0<1>") getData("/I4/1y0<0>") getData("/I4/3y0<3>") getData("/I4/3y0<2>") getData("/I4/3y0<1>") getData("/I4/3y0<0>") getData("/I4/2y1<3>") getData("/I4/2y1<2>") getData("/I4/2y1<1>") getData("/I4/2y1<0>") getData("/I4/3y1<3>") getData("/I4/3y1<2>") getData("/I4/3y1<1>") getData("/I4/3y1<0>") getData("/I4/1y1<3>") getData("/I4/1y1<2>") getData("/I4/1y1<1>") getData("/I4/1y1<0>") getData("/I4/2y0<3>") getData("/I4/2y0<2>") getData("/I4/2y0<1>") getData("/I4/2y0<0>") getData("/I4/4y0<3>") getData("/I4/4y0<2>") getData("/I4/4y0<1>") getData("/I4/4y0<0>") getData("/I4/5y0<3>") getData("/I4/5y0<2>") getData("/I4/5y0<1>") getData("/I4/5y0<0>") getData("/I4/4y1<3>") getData("/I4/4y1<2>") getData("/I4/4y1<1>") getData("/I4/4y1<0>") getData("/I4/5y1<3>") getData("/I4/5y1<2>") getData("/I4/5y1<1>") getData("/I4/5y1<0>") getData("/a1<23:0>") getData("/a0<23:0>") getData("/b1<23:0>") getData("/b0<23:0>") )
