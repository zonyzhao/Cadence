simulator( 'spectreVerilog )
design(	 "/net/kafka/nfs/rstdenis/Cadence/simulation/Compare22_Test/spectreVerilog/config/netlist/analog/netlist")
resultsDir( "/net/kafka/nfs/rstdenis/Cadence/simulation/Compare22_Test/spectreVerilog/config" )
modelFile(
    '("/software/cadence/ncsu-FreePDK15/hspice_16nm_hp.include" "")
)
analysis('tran ?stop "10n"  ?errpreset "conservative"  )
desVar(	  "vdd" .850	)
envOption(
	'mspSetupNetlistSimPrecisionUnit  "ps"
	'mspSetupNetlistSimTimeUnit  "ps"
	'mspSetupNetlistSwitchRC  t
	'analysisOrder  list("tran")
)
option(	'multithread  "on"
)
saveOption( ?simOutputFormat "psfxl" )
converge( 'ic "/net36<21>" "0" )
converge( 'ic "/net36<20>" "0" )
converge( 'ic "/net36<19>" "0" )
converge( 'ic "/net36<18>" "0" )
converge( 'ic "/net36<17>" "0" )
converge( 'ic "/net36<16>" "0" )
converge( 'ic "/net36<15>" "0" )
converge( 'ic "/net36<14>" "0" )
converge( 'ic "/net36<13>" "0" )
converge( 'ic "/net36<12>" "0" )
converge( 'ic "/net36<11>" "0" )
converge( 'ic "/net36<10>" "0" )
converge( 'ic "/net36<9>" "0" )
converge( 'ic "/net36<8>" "0" )
converge( 'ic "/net36<7>" "0" )
converge( 'ic "/net36<6>" "0" )
converge( 'ic "/net36<5>" "0" )
converge( 'ic "/net36<4>" "0" )
converge( 'ic "/net36<3>" "0" )
converge( 'ic "/net36<2>" "0" )
converge( 'ic "/net36<1>" "0" )
converge( 'ic "/net36<0>" "0" )
converge( 'ic "/net37<21>" "0" )
converge( 'ic "/net37<20>" "0" )
converge( 'ic "/net37<19>" "0" )
converge( 'ic "/net37<18>" "0" )
converge( 'ic "/net37<17>" "0" )
converge( 'ic "/net37<16>" "0" )
converge( 'ic "/net37<15>" "0" )
converge( 'ic "/net37<14>" "0" )
converge( 'ic "/net37<13>" "0" )
converge( 'ic "/net37<12>" "0" )
converge( 'ic "/net37<11>" "0" )
converge( 'ic "/net37<10>" "0" )
converge( 'ic "/net37<9>" "0" )
converge( 'ic "/net37<8>" "0" )
converge( 'ic "/net37<7>" "0" )
converge( 'ic "/net37<6>" "0" )
converge( 'ic "/net37<5>" "0" )
converge( 'ic "/net37<4>" "0" )
converge( 'ic "/net37<3>" "0" )
converge( 'ic "/net37<2>" "0" )
converge( 'ic "/net37<1>" "0" )
converge( 'ic "/net37<0>" "0" )
converge( 'ic "/net38<21>" "0" )
converge( 'ic "/net38<20>" "0" )
converge( 'ic "/net38<19>" "0" )
converge( 'ic "/net38<18>" "0" )
converge( 'ic "/net38<17>" "0" )
converge( 'ic "/net38<16>" "0" )
converge( 'ic "/net38<15>" "0" )
converge( 'ic "/net38<14>" "0" )
converge( 'ic "/net38<13>" "0" )
converge( 'ic "/net38<12>" "0" )
converge( 'ic "/net38<11>" "0" )
converge( 'ic "/net38<10>" "0" )
converge( 'ic "/net38<9>" "0" )
converge( 'ic "/net38<8>" "0" )
converge( 'ic "/net38<7>" "0" )
converge( 'ic "/net38<6>" "0" )
converge( 'ic "/net38<5>" "0" )
converge( 'ic "/net38<4>" "0" )
converge( 'ic "/net38<3>" "0" )
converge( 'ic "/net38<2>" "0" )
converge( 'ic "/net38<1>" "0" )
converge( 'ic "/net38<0>" "0" )
converge( 'ic "/net39<21>" "0" )
converge( 'ic "/net39<20>" "0" )
converge( 'ic "/net39<19>" "0" )
converge( 'ic "/net39<18>" "0" )
converge( 'ic "/net39<17>" "0" )
converge( 'ic "/net39<16>" "0" )
converge( 'ic "/net39<15>" "0" )
converge( 'ic "/net39<14>" "0" )
converge( 'ic "/net39<13>" "0" )
converge( 'ic "/net39<12>" "0" )
converge( 'ic "/net39<11>" "0" )
converge( 'ic "/net39<10>" "0" )
converge( 'ic "/net39<9>" "0" )
converge( 'ic "/net39<8>" "0" )
converge( 'ic "/net39<7>" "0" )
converge( 'ic "/net39<6>" "0" )
converge( 'ic "/net39<5>" "0" )
converge( 'ic "/net39<4>" "0" )
converge( 'ic "/net39<3>" "0" )
converge( 'ic "/net39<2>" "0" )
converge( 'ic "/net39<1>" "0" )
converge( 'ic "/net39<0>" "0" )
converge( 'ic "/net012" "0" )
converge( 'ic "/net15" "0" )
converge( 'ic "/net20" "0" )
run()
selectResult( 'tran )
plot(getData("/Miss") getData("/Valid") getData("/Hit") getData("/b0<21:0>") getData("/b1<21:0>") getData("/a0<21:0>") getData("/a1<21:0>") )
modelFile(
    '("/software/cadence/ncsu-FreePDK15/hspice_16nm_hp.include" "")
)
run()
selectResult( 'tran )
plot(getData("/I4/net029<0>") getData("/I4/net029<1>") getData("/I4/net029<2>") getData("/I4/net029<3>") getData("/I4/net032<0>") getData("/I4/net032<1>") getData("/I4/net032<2>") getData("/I4/net032<3>") getData("/I4/net030<0>") getData("/I4/net030<1>") getData("/I4/net030<2>") getData("/I4/net030<3>") getData("/I4/net031<0>") getData("/I4/net031<1>") getData("/I4/net031<2>") getData("/I4/net031<3>") getData("/I4/1y0<3>") getData("/I4/1y0<2>") getData("/I4/1y0<1>") getData("/I4/1y0<0>") getData("/I4/3y0<3>") getData("/I4/3y0<2>") getData("/I4/3y0<1>") getData("/I4/3y0<0>") getData("/I4/2y1<3>") getData("/I4/2y1<2>") getData("/I4/2y1<1>") getData("/I4/2y1<0>") getData("/I4/3y1<3>") getData("/I4/3y1<2>") getData("/I4/3y1<1>") getData("/I4/3y1<0>") getData("/I4/1y1<3>") getData("/I4/1y1<2>") getData("/I4/1y1<1>") getData("/I4/1y1<0>") getData("/I4/2y0<3>") getData("/I4/2y0<2>") getData("/I4/2y0<1>") getData("/I4/2y0<0>") getData("/I4/4y0<3>") getData("/I4/4y0<2>") getData("/I4/4y0<1>") getData("/I4/4y0<0>") getData("/I4/5y0<3>") getData("/I4/5y0<2>") getData("/I4/5y0<1>") getData("/I4/5y0<0>") getData("/I4/4y1<3>") getData("/I4/4y1<2>") getData("/I4/4y1<1>") getData("/I4/4y1<0>") getData("/I4/5y1<3>") getData("/I4/5y1<2>") getData("/I4/5y1<1>") getData("/I4/5y1<0>") getData("/a1<21:0>") getData("/a0<21:0>") getData("/b1<21:0>") getData("/b0<21:0>") getData("/Hit") getData("/Valid") getData("/Miss") )
