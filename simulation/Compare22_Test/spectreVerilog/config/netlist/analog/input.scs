// Design: 16nm_Tests/Compare22_Test
simulator lang=spectre
global 0 vdd! vcc!
parameters vdd=.850
include "/software/cadence/ncsu-FreePDK15/hspice_16nm_hp.include"

// 16nm/inv_1xt/schematic
//system verilogNetlist schematic cmos.sch cmos_sch veriloga ahdl
subckt inv_1xt A Y
    M0 (Y A 0 0) nfet w=60n l=20n nfin=1 m=1 degradation=no
    M1 (Y A vcc! vcc!) pfet w=100n l=20n nfin=1 m=1 degradation=no
ends inv_1xt

// 16nm/nor_1x/schematic
//system verilogNetlist schematic cmos.sch cmos_sch veriloga ahdl
subckt nor_1x A B Y
    M3 (Y B or_pd_ps vdd!) pfet w=200n l=20n nfin=1 m=1 degradation=no
    M2 (or_pd_ps A vdd! vdd!) pfet w=200n l=20n nfin=1 m=1 degradation=no
    M1 (Y B 0 0) nfet w=60n l=20n nfin=1 m=1 degradation=no
    M0 (Y A 0 0) nfet w=60n l=20n nfin=1 m=1 degradation=no
ends nor_1x

// 16nm/inv_1x/schematic
//system verilogNetlist schematic cmos.sch cmos_sch veriloga ahdl
subckt inv_1x A Y
    M0 (Y A 0 0) nfet w=60n l=20n nfin=1 m=1 degradation=no
    M1 (Y A vdd! vdd!) pfet w=100n l=20n nfin=1 m=1 degradation=no
ends inv_1x

// 16nm/TH22~/schematic
//system verilogNetlist schematic cmos.sch cmos_sch veriloga ahdl
subckt _sub7 A B Y
    I6 (net010 Y) inv_1x
    M5 (net010 net5 0 0) nfet w=48n l=16n nfin=1 m=1 degradation=no
    M4 (net5 net010 net9 0) nfet w=48n l=16n nfin=1 m=1 degradation=no
    M3 (net9 B 0 0) nfet w=48n l=16n nfin=1 m=1 degradation=no
    M2 (net9 A 0 0) nfet w=48n l=16n nfin=1 m=1 degradation=no
    M1 (net5 B net17 0) nfet w=80n l=16n nfin=1 m=1 degradation=no
    M0 (net17 A 0 0) nfet w=80n l=16n nfin=1 m=1 degradation=no
    M11 (net010 net5 vdd! vdd!) pfet w=80n l=16n nfin=1 m=1 degradation=no
    M10 (net5 B net032 vdd!) pfet w=160n l=16n nfin=1 m=1 degradation=no
    M9 (net032 A vdd! vdd!) pfet w=160n l=16n nfin=1 m=1 degradation=no
    M8 (net037 B vdd! vdd!) pfet w=80n l=16n nfin=1 m=1 degradation=no
    M7 (net037 A vdd! vdd!) pfet w=80n l=16n nfin=1 m=1 degradation=no
    M6 (net5 net010 net037 vdd!) pfet w=80n l=16n nfin=1 m=1 degradation=no
ends _sub7

// 16nm/Valid_DR/schematic
//system verilogNetlist schematic cmos.sch cmos_sch veriloga ahdl
subckt Valid_DR a0 a1 b0 b1 v
    I1 (b0 b1 net11) nor_1x
    I0 (a0 a1 net12) nor_1x
    I2 (net12 net11 v) _sub7
ends Valid_DR

// 16nm/Compare_DR/schematic
//system verilogNetlist schematic cmos.sch cmos_sch veriloga ahdl
subckt Compare_DR y0 y1 a0 a1 b0 b1 vAck
    M10 (net023 vAck vdd! vdd!) pfet w=80n l=20n nfin=1 m=1 degradation=yes
    M0 (net015 vAck vdd! vdd!) pfet w=80n l=20n nfin=1 m=1 degradation=yes
    M9 (net26 vAck 0 0) nfet w=120n l=20n nfin=1 m=1 degradation=no
    M8 (net023 a1 net35 0) nfet w=120n l=20n nfin=1 m=1 degradation=no
    M7 (net35 b0 net26 0) nfet w=120n l=20n nfin=1 m=1 degradation=no
    M6 (net36 b1 net26 0) nfet w=120n l=20n nfin=1 m=1 degradation=no
    M5 (net023 a0 net36 0) nfet w=120n l=20n nfin=1 m=1 degradation=no
    M4 (net38 b0 net26 0) nfet w=120n l=20n nfin=1 m=1 degradation=no
    M3 (net37 b1 net26 0) nfet w=120n l=20n nfin=1 m=1 degradation=no
    M2 (net015 a1 net37 0) nfet w=120n l=20n nfin=1 m=1 degradation=no
    M1 (net015 a0 net38 0) nfet w=120n l=20n nfin=1 m=1 degradation=no
    I61 (a0 a1 b0 b1 vAck) Valid_DR
    I6 (net015 y1) inv_1x
    I5 (net023 y0) inv_1x
ends Compare_DR

// 16nm/Compare4_DR/schematic
//system verilogNetlist schematic cmos.sch cmos_sch veriloga ahdl
subckt Compare4_DR a0_3 a0_2 a0_1 a0_0 a1_3 a1_2 a1_1 a1_0 b0_3 b0_2 b0_1 b0_0 b1_3 b1_2 b1_1 b1_0 y0_3 y0_2 y0_1 y0_0 y1_3 y1_2 y1_1 y1_0
    I6 (y0_3 y1_3 a0_3 a1_3 b0_3 b1_3 net13) Compare_DR
    I4 (y0_2 y1_2 a0_2 a1_2 b0_2 b1_2 net14) Compare_DR
    I2 (y0_1 y1_1 a0_1 a1_1 b0_1 b1_1 net15) Compare_DR
    I0 (y0_0 y1_0 a0_0 a1_0 b0_0 b1_0 net16) Compare_DR
ends Compare4_DR

// 16nm/or_1x/schematic
//system verilogNetlist schematic cmos.sch cmos_sch veriloga ahdl
subckt or_1x A B Y
    I6 (A B AnorB) nor_1x
    I7 (AnorB Y) inv_1x
ends or_1x

// 16nm/Compare2_DR/schematic
//system verilogNetlist schematic cmos.sch cmos_sch veriloga ahdl
subckt Compare2_DR y0_1 y0_0 y1_1 y1_0 a0_1 a0_0 a1_1 a1_0 b0_1 b0_0 b1_1 b1_0
    I2 (y0_1 y1_1 a0_1 a1_1 b0_1 b1_1 net15) Compare_DR
    I0 (y0_0 y1_0 a0_0 a1_0 b0_0 b1_0 net16) Compare_DR
ends Compare2_DR

// 16nm/Compare24_DR/schematic
//system verilogNetlist schematic cmos.sch cmos_sch veriloga ahdl
subckt Compare24_DR a0_23 a0_22 a0_21 a0_20 a0_19 a0_18 a0_17 a0_16 a0_15 a0_14 a0_13 a0_12 a0_11 a0_10 a0_9 a0_8 a0_7 a0_6 a0_5 a0_4 a0_3 a0_2 a0_1 a0_0 a1_23 a1_22 a1_21 a1_20 a1_19 a1_18 a1_17 a1_16 a1_15 a1_14 a1_13 a1_12 a1_11 a1_10 a1_9 a1_8 a1_7 a1_6 a1_5 a1_4 a1_3 a1_2 a1_1 a1_0 b0_23 b0_22 b0_21 b0_20 b0_19 b0_18 b0_17 b0_16 b0_15 b0_14 b0_13 b0_12 b0_11 b0_10 b0_9 b0_8 b0_7 b0_6 b0_5 b0_4 b0_3 b0_2 b0_1 b0_0 b1_23 b1_22 b1_21 b1_20 b1_19 b1_18 b1_17 b1_16 b1_15 b1_14 b1_13 b1_12 b1_11 b1_10 b1_9 b1_8 b1_7 b1_6 b1_5 b1_4 b1_3 b1_2 b1_1 b1_0 Eq \~Eq vAck
    I46 (net47_0 net47_1 net47_2 net47_3 net46_0 net46_1 net46_2 net46_3 s2_n3_y0_3 s2_n3_y0_2 s2_n3_y0_1 s2_n3_y0_0 s2_n3_y1_3 s2_n3_y1_2 s2_n3_y1_1 s2_n3_y1_0 s3_y0_3 s3_y0_2 s3_y0_1 s3_y0_0 s3_y1_3 s3_y1_2 s3_y1_1 s3_y1_0) Compare4_DR
    I41 (a0_23 a0_22 a0_21 a0_20 a1_23 a1_22 a1_21 a1_20 b0_23 b0_22 b0_21 b0_20 b1_23 b1_22 b1_21 b1_20 _6y0_3 _6y0_2 _6y0_1 _6y0_0 _6y1_3 _6y1_2 _6y1_1 _6y1_0) Compare4_DR
    I16 (a0_19 a0_18 a0_17 a0_16 a1_19 a1_18 a1_17 a1_16 b0_19 b0_18 b0_17 b0_16 b1_19 b1_18 b1_17 b1_16 _5y0_3 _5y0_2 _5y0_1 _5y0_0 _5y1_3 _5y1_2 _5y1_1 _5y1_0) Compare4_DR
    I11 (a0_7 a0_6 a0_5 a0_4 a1_7 a1_6 a1_5 a1_4 b0_7 b0_6 b0_5 b0_4 b1_7 b1_6 b1_5 b1_4 _2y0_3 _2y0_2 _2y0_1 _2y0_0 _2y1_3 _2y1_2 _2y1_1 _2y1_0) Compare4_DR
    I10 (a0_3 a0_2 a0_1 a0_0 a1_3 a1_2 a1_1 a1_0 b0_3 b0_2 b0_1 b0_0 b1_3 b1_2 b1_1 b1_0 _1y0_3 _1y0_2 _1y0_1 _1y0_0 _1y1_3 _1y1_2 _1y1_1 _1y1_0) Compare4_DR
    I14 (a0_11 a0_10 a0_9 a0_8 a1_11 a1_10 a1_9 a1_8 b0_11 b0_10 b0_9 b0_8 b1_11 b1_10 b1_9 b1_8 _3y0_3 _3y0_2 _3y0_1 _3y0_0 _3y1_3 _3y1_2 _3y1_1 _3y1_0) Compare4_DR
    I13 (a0_15 a0_14 a0_13 a0_12 a1_15 a1_14 a1_13 a1_12 b0_15 b0_14 b0_13 b0_12 b1_15 b1_14 b1_13 b1_12 _4y0_3 _4y0_2 _4y0_1 _4y0_0 _4y1_3 _4y1_2 _4y1_1 _4y1_0) Compare4_DR
    I43 (s2_n1_y0_3 s2_n1_y0_2 s2_n1_y0_1 s2_n1_y0_0 s2_n1_y1_3 s2_n1_y1_2 s2_n1_y1_1 s2_n1_y1_0 s2_n2_y0_3 s2_n2_y0_2 s2_n2_y0_1 s2_n2_y0_0 s2_n2_y1_3 s2_n2_y1_2 s2_n2_y1_1 s2_n2_y1_0 net47_0 net47_1 net47_2 net47_3 net46_0 net46_1 net46_2 net46_3) Compare4_DR
    I42 (_3y0_3 _3y0_2 _3y0_1 _3y0_0 _3y1_3 _3y1_2 _3y1_1 _3y1_0 _4y0_3 _4y0_2 _4y0_1 _4y0_0 _4y1_3 _4y1_2 _4y1_1 _4y1_0 s2_n2_y0_3 s2_n2_y0_2 s2_n2_y0_1 s2_n2_y0_0 s2_n2_y1_3 s2_n2_y1_2 s2_n2_y1_1 s2_n2_y1_0) Compare4_DR
    I45 (_5y0_3 _5y0_2 _5y0_1 _5y0_0 _5y1_3 _5y1_2 _5y1_1 _5y1_0 _6y0_3 _6y0_2 _6y0_1 _6y0_0 _6y1_3 _6y1_2 _6y1_1 _6y1_0 s2_n3_y0_3 s2_n3_y0_2 s2_n3_y0_1 s2_n3_y0_0 s2_n3_y1_3 s2_n3_y1_2 s2_n3_y1_1 s2_n3_y1_0) Compare4_DR
    I44 (_1y0_3 _1y0_2 _1y0_1 _1y0_0 _1y1_3 _1y1_2 _1y1_1 _1y1_0 _2y0_3 _2y0_2 _2y0_1 _2y0_0 _2y1_3 _2y1_2 _2y1_1 _2y1_0 s2_n1_y0_3 s2_n1_y0_2 s2_n1_y0_1 s2_n1_y0_0 s2_n1_y1_3 s2_n1_y1_2 s2_n1_y1_1 s2_n1_y1_0) Compare4_DR
    I48 (\~Eq Eq sfy0_0 sfy1_0 sfy0_1 sfy1_1 net50) Compare_DR
    I49 (Eq \~Eq vAck) or_1x
    I47 (sfy0_1 sfy0_0 sfy1_1 sfy1_0 s3_y0_1 s3_y0_0 s3_y1_1 s3_y1_0 s3_y0_3 s3_y0_2 s3_y1_3 s3_y1_2) Compare2_DR
ends Compare24_DR

// 16nm_Tests/Compare22_Test/schematic
// system verilogNetlist schematic cmos.sch cmos_sch veriloga ahdl
V1 (vcc! 0) vsource type=dc dc=vdd
V0 (vdd! 0) vsource type=dc dc=vdd
I13 (net012 net22) inv_1xt
I15 (net20 net23) inv_1xt
I14 (net15 net21) inv_1xt
I5_23 (net029_0 net033_0) inv_1xt
I5_22 (net029_1 net033_1) inv_1xt
I5_21 (net029_2 net033_2) inv_1xt
I5_20 (net029_3 net033_3) inv_1xt
I5_19 (net029_4 net033_4) inv_1xt
I5_18 (net029_5 net033_5) inv_1xt
I5_17 (net029_6 net033_6) inv_1xt
I5_16 (net029_7 net033_7) inv_1xt
I5_15 (net029_8 net033_8) inv_1xt
I5_14 (net029_9 net033_9) inv_1xt
I5_13 (net029_10 net033_10) inv_1xt
I5_12 (net029_11 net033_11) inv_1xt
I5_11 (net029_12 net033_12) inv_1xt
I5_10 (net029_13 net033_13) inv_1xt
I5_9 (net029_14 net033_14) inv_1xt
I5_8 (net029_15 net033_15) inv_1xt
I5_7 (net029_16 net033_16) inv_1xt
I5_6 (net029_17 net033_17) inv_1xt
I5_5 (net029_18 net033_18) inv_1xt
I5_4 (net029_19 net033_19) inv_1xt
I5_3 (net029_20 net033_20) inv_1xt
I5_2 (net029_21 net033_21) inv_1xt
I5_1 (net029_22 net033_22) inv_1xt
I5_0 (net029_23 net033_23) inv_1xt
I22_23 (net027_0 net031_0) inv_1xt
I22_22 (net027_1 net031_1) inv_1xt
I22_21 (net027_2 net031_2) inv_1xt
I22_20 (net027_3 net031_3) inv_1xt
I22_19 (net027_4 net031_4) inv_1xt
I22_18 (net027_5 net031_5) inv_1xt
I22_17 (net027_6 net031_6) inv_1xt
I22_16 (net027_7 net031_7) inv_1xt
I22_15 (net027_8 net031_8) inv_1xt
I22_14 (net027_9 net031_9) inv_1xt
I22_13 (net027_10 net031_10) inv_1xt
I22_12 (net027_11 net031_11) inv_1xt
I22_11 (net027_12 net031_12) inv_1xt
I22_10 (net027_13 net031_13) inv_1xt
I22_9 (net027_14 net031_14) inv_1xt
I22_8 (net027_15 net031_15) inv_1xt
I22_7 (net027_16 net031_16) inv_1xt
I22_6 (net027_17 net031_17) inv_1xt
I22_5 (net027_18 net031_18) inv_1xt
I22_4 (net027_19 net031_19) inv_1xt
I22_3 (net027_20 net031_20) inv_1xt
I22_2 (net027_21 net031_21) inv_1xt
I22_1 (net027_22 net031_22) inv_1xt
I22_0 (net027_23 net031_23) inv_1xt
I23_23 (net026_0 net030_0) inv_1xt
I23_22 (net026_1 net030_1) inv_1xt
I23_21 (net026_2 net030_2) inv_1xt
I23_20 (net026_3 net030_3) inv_1xt
I23_19 (net026_4 net030_4) inv_1xt
I23_18 (net026_5 net030_5) inv_1xt
I23_17 (net026_6 net030_6) inv_1xt
I23_16 (net026_7 net030_7) inv_1xt
I23_15 (net026_8 net030_8) inv_1xt
I23_14 (net026_9 net030_9) inv_1xt
I23_13 (net026_10 net030_10) inv_1xt
I23_12 (net026_11 net030_11) inv_1xt
I23_11 (net026_12 net030_12) inv_1xt
I23_10 (net026_13 net030_13) inv_1xt
I23_9 (net026_14 net030_14) inv_1xt
I23_8 (net026_15 net030_15) inv_1xt
I23_7 (net026_16 net030_16) inv_1xt
I23_6 (net026_17 net030_17) inv_1xt
I23_5 (net026_18 net030_18) inv_1xt
I23_4 (net026_19 net030_19) inv_1xt
I23_3 (net026_20 net030_20) inv_1xt
I23_2 (net026_21 net030_21) inv_1xt
I23_1 (net026_22 net030_22) inv_1xt
I23_0 (net026_23 net030_23) inv_1xt
I19_23 (net028_0 net032_0) inv_1xt
I19_22 (net028_1 net032_1) inv_1xt
I19_21 (net028_2 net032_2) inv_1xt
I19_20 (net028_3 net032_3) inv_1xt
I19_19 (net028_4 net032_4) inv_1xt
I19_18 (net028_5 net032_5) inv_1xt
I19_17 (net028_6 net032_6) inv_1xt
I19_16 (net028_7 net032_7) inv_1xt
I19_15 (net028_8 net032_8) inv_1xt
I19_14 (net028_9 net032_9) inv_1xt
I19_13 (net028_10 net032_10) inv_1xt
I19_12 (net028_11 net032_11) inv_1xt
I19_11 (net028_12 net032_12) inv_1xt
I19_10 (net028_13 net032_13) inv_1xt
I19_9 (net028_14 net032_14) inv_1xt
I19_8 (net028_15 net032_15) inv_1xt
I19_7 (net028_16 net032_16) inv_1xt
I19_6 (net028_17 net032_17) inv_1xt
I19_5 (net028_18 net032_18) inv_1xt
I19_4 (net028_19 net032_19) inv_1xt
I19_3 (net028_20 net032_20) inv_1xt
I19_2 (net028_21 net032_21) inv_1xt
I19_1 (net028_22 net032_22) inv_1xt
I19_0 (net028_23 net032_23) inv_1xt
I4 (net033_0 net033_1 net033_2 net033_3 net033_4 net033_5 net033_6 net033_7 net033_8 net033_9 net033_10 net033_11 net033_12 net033_13 net033_14 net033_15 net033_16 net033_17 net033_18 net033_19 net033_20 net033_21 net033_22 net033_23 net032_0 net032_1 net032_2 net032_3 net032_4 net032_5 net032_6 net032_7 net032_8 net032_9 net032_10 net032_11 net032_12 net032_13 net032_14 net032_15 net032_16 net032_17 net032_18 net032_19 net032_20 net032_21 net032_22 net032_23 net031_0 net031_1 net031_2 net031_3 net031_4 net031_5 net031_6 net031_7 net031_8 net031_9 net031_10 net031_11 net031_12 net031_13 net031_14 net031_15 net031_16 net031_17 net031_18 net031_19 net031_20 net031_21 net031_22 net031_23 net030_0 net030_1 net030_2 net030_3 net030_4 net030_5 net030_6 net030_7 net030_8 net030_9 net030_10 net030_11 net030_12 net030_13 net030_14 net030_15 net030_16 net030_17 net030_18 net030_19 net030_20 net030_21 net030_22 net030_23 net20 net012 net15) Compare24_DR
// BEGIN Hierarchical Interface Elements
_ie99901 (net029_15 0) d2a src="99901" val0=0.0 val1=vdd valx=vdd/2 rise=2p fall=2p
_ie99902 (net028_14 0) d2a src="99902" val0=0.0 val1=vdd valx=vdd/2 rise=2p fall=2p
_ie99903 (net027_13 0) d2a src="99903" val0=0.0 val1=vdd valx=vdd/2 rise=2p fall=2p
_ie99904 (net027_12 0) d2a src="99904" val0=0.0 val1=vdd valx=vdd/2 rise=2p fall=2p
_ie99905 (net027_11 0) d2a src="99905" val0=0.0 val1=vdd valx=vdd/2 rise=2p fall=2p
_ie99906 (net026_4 0) d2a src="99906" val0=0.0 val1=vdd valx=vdd/2 rise=2p fall=2p
_ie99907 (net026_5 0) d2a src="99907" val0=0.0 val1=vdd valx=vdd/2 rise=2p fall=2p
_ie99908 (net026_6 0) d2a src="99908" val0=0.0 val1=vdd valx=vdd/2 rise=2p fall=2p
_ie99909 (net026_3 0) d2a src="99909" val0=0.0 val1=vdd valx=vdd/2 rise=2p fall=2p
_ie99910 (net21 0) a2d dest="99910" vl=0.3*vdd vh=0.7*vdd timex=20n
_ie99911 (net22 0) a2d dest="99911" vl=0.3*vdd vh=0.7*vdd timex=20n
_ie99912 (net23 0) a2d dest="99912" vl=0.3*vdd vh=0.7*vdd timex=20n
_ie99913 (net026_0 0) d2a src="99913" val0=0.0 val1=vdd valx=vdd/2 rise=2p fall=2p
_ie99914 (net026_1 0) d2a src="99914" val0=0.0 val1=vdd valx=vdd/2 rise=2p fall=2p
_ie99915 (net026_2 0) d2a src="99915" val0=0.0 val1=vdd valx=vdd/2 rise=2p fall=2p
_ie99916 (net026_14 0) d2a src="99916" val0=0.0 val1=vdd valx=vdd/2 rise=2p fall=2p
_ie99917 (net026_13 0) d2a src="99917" val0=0.0 val1=vdd valx=vdd/2 rise=2p fall=2p
_ie99918 (net026_12 0) d2a src="99918" val0=0.0 val1=vdd valx=vdd/2 rise=2p fall=2p
_ie99919 (net027_19 0) d2a src="99919" val0=0.0 val1=vdd valx=vdd/2 rise=2p fall=2p
_ie99920 (net027_18 0) d2a src="99920" val0=0.0 val1=vdd valx=vdd/2 rise=2p fall=2p
_ie99921 (net029_23 0) d2a src="99921" val0=0.0 val1=vdd valx=vdd/2 rise=2p fall=2p
_ie99922 (net029_22 0) d2a src="99922" val0=0.0 val1=vdd valx=vdd/2 rise=2p fall=2p
_ie99923 (net027_7 0) d2a src="99923" val0=0.0 val1=vdd valx=vdd/2 rise=2p fall=2p
_ie99924 (net027_8 0) d2a src="99924" val0=0.0 val1=vdd valx=vdd/2 rise=2p fall=2p
_ie99925 (net027_9 0) d2a src="99925" val0=0.0 val1=vdd valx=vdd/2 rise=2p fall=2p
_ie99926 (net027_10 0) d2a src="99926" val0=0.0 val1=vdd valx=vdd/2 rise=2p fall=2p
_ie99927 (net027_6 0) d2a src="99927" val0=0.0 val1=vdd valx=vdd/2 rise=2p fall=2p
_ie99928 (net027_5 0) d2a src="99928" val0=0.0 val1=vdd valx=vdd/2 rise=2p fall=2p
_ie99929 (net027_4 0) d2a src="99929" val0=0.0 val1=vdd valx=vdd/2 rise=2p fall=2p
_ie99930 (net026_16 0) d2a src="99930" val0=0.0 val1=vdd valx=vdd/2 rise=2p fall=2p
_ie99931 (net028_2 0) d2a src="99931" val0=0.0 val1=vdd valx=vdd/2 rise=2p fall=2p
_ie99932 (net029_4 0) d2a src="99932" val0=0.0 val1=vdd valx=vdd/2 rise=2p fall=2p
_ie99933 (net029_21 0) d2a src="99933" val0=0.0 val1=vdd valx=vdd/2 rise=2p fall=2p
_ie99934 (net029_20 0) d2a src="99934" val0=0.0 val1=vdd valx=vdd/2 rise=2p fall=2p
_ie99935 (net027_20 0) d2a src="99935" val0=0.0 val1=vdd valx=vdd/2 rise=2p fall=2p
_ie99936 (net027_21 0) d2a src="99936" val0=0.0 val1=vdd valx=vdd/2 rise=2p fall=2p
_ie99937 (net027_22 0) d2a src="99937" val0=0.0 val1=vdd valx=vdd/2 rise=2p fall=2p
_ie99938 (net027_23 0) d2a src="99938" val0=0.0 val1=vdd valx=vdd/2 rise=2p fall=2p
_ie99939 (net028_0 0) d2a src="99939" val0=0.0 val1=vdd valx=vdd/2 rise=2p fall=2p
_ie99940 (net028_1 0) d2a src="99940" val0=0.0 val1=vdd valx=vdd/2 rise=2p fall=2p
_ie99941 (net026_17 0) d2a src="99941" val0=0.0 val1=vdd valx=vdd/2 rise=2p fall=2p
_ie99942 (net026_18 0) d2a src="99942" val0=0.0 val1=vdd valx=vdd/2 rise=2p fall=2p
_ie99943 (net026_19 0) d2a src="99943" val0=0.0 val1=vdd valx=vdd/2 rise=2p fall=2p
_ie99944 (net026_20 0) d2a src="99944" val0=0.0 val1=vdd valx=vdd/2 rise=2p fall=2p
_ie99945 (net026_21 0) d2a src="99945" val0=0.0 val1=vdd valx=vdd/2 rise=2p fall=2p
_ie99946 (net026_22 0) d2a src="99946" val0=0.0 val1=vdd valx=vdd/2 rise=2p fall=2p
_ie99947 (net026_23 0) d2a src="99947" val0=0.0 val1=vdd valx=vdd/2 rise=2p fall=2p
_ie99948 (net027_0 0) d2a src="99948" val0=0.0 val1=vdd valx=vdd/2 rise=2p fall=2p
_ie99949 (net027_1 0) d2a src="99949" val0=0.0 val1=vdd valx=vdd/2 rise=2p fall=2p
_ie99950 (net027_2 0) d2a src="99950" val0=0.0 val1=vdd valx=vdd/2 rise=2p fall=2p
_ie99951 (net027_3 0) d2a src="99951" val0=0.0 val1=vdd valx=vdd/2 rise=2p fall=2p
_ie99952 (net028_3 0) d2a src="99952" val0=0.0 val1=vdd valx=vdd/2 rise=2p fall=2p
_ie99953 (net028_4 0) d2a src="99953" val0=0.0 val1=vdd valx=vdd/2 rise=2p fall=2p
_ie99954 (net028_5 0) d2a src="99954" val0=0.0 val1=vdd valx=vdd/2 rise=2p fall=2p
_ie99955 (net028_6 0) d2a src="99955" val0=0.0 val1=vdd valx=vdd/2 rise=2p fall=2p
_ie99956 (net028_7 0) d2a src="99956" val0=0.0 val1=vdd valx=vdd/2 rise=2p fall=2p
_ie99957 (net028_8 0) d2a src="99957" val0=0.0 val1=vdd valx=vdd/2 rise=2p fall=2p
_ie99958 (net028_9 0) d2a src="99958" val0=0.0 val1=vdd valx=vdd/2 rise=2p fall=2p
_ie99959 (net028_10 0) d2a src="99959" val0=0.0 val1=vdd valx=vdd/2 rise=2p fall=2p
_ie99960 (net028_11 0) d2a src="99960" val0=0.0 val1=vdd valx=vdd/2 rise=2p fall=2p
_ie99961 (net028_12 0) d2a src="99961" val0=0.0 val1=vdd valx=vdd/2 rise=2p fall=2p
_ie99962 (net028_13 0) d2a src="99962" val0=0.0 val1=vdd valx=vdd/2 rise=2p fall=2p
_ie99963 (net029_16 0) d2a src="99963" val0=0.0 val1=vdd valx=vdd/2 rise=2p fall=2p
_ie99964 (net026_7 0) d2a src="99964" val0=0.0 val1=vdd valx=vdd/2 rise=2p fall=2p
_ie99965 (net026_8 0) d2a src="99965" val0=0.0 val1=vdd valx=vdd/2 rise=2p fall=2p
_ie99966 (net026_9 0) d2a src="99966" val0=0.0 val1=vdd valx=vdd/2 rise=2p fall=2p
_ie99967 (net026_10 0) d2a src="99967" val0=0.0 val1=vdd valx=vdd/2 rise=2p fall=2p
_ie99968 (net026_11 0) d2a src="99968" val0=0.0 val1=vdd valx=vdd/2 rise=2p fall=2p
_ie99969 (net029_3 0) d2a src="99969" val0=0.0 val1=vdd valx=vdd/2 rise=2p fall=2p
_ie99970 (net029_2 0) d2a src="99970" val0=0.0 val1=vdd valx=vdd/2 rise=2p fall=2p
_ie99971 (net029_1 0) d2a src="99971" val0=0.0 val1=vdd valx=vdd/2 rise=2p fall=2p
_ie99972 (net029_0 0) d2a src="99972" val0=0.0 val1=vdd valx=vdd/2 rise=2p fall=2p
_ie99973 (net028_23 0) d2a src="99973" val0=0.0 val1=vdd valx=vdd/2 rise=2p fall=2p
_ie99974 (net027_17 0) d2a src="99974" val0=0.0 val1=vdd valx=vdd/2 rise=2p fall=2p
_ie99975 (net029_19 0) d2a src="99975" val0=0.0 val1=vdd valx=vdd/2 rise=2p fall=2p
_ie99976 (net029_18 0) d2a src="99976" val0=0.0 val1=vdd valx=vdd/2 rise=2p fall=2p
_ie99977 (net029_17 0) d2a src="99977" val0=0.0 val1=vdd valx=vdd/2 rise=2p fall=2p
_ie99978 (net027_16 0) d2a src="99978" val0=0.0 val1=vdd valx=vdd/2 rise=2p fall=2p
_ie99979 (net027_15 0) d2a src="99979" val0=0.0 val1=vdd valx=vdd/2 rise=2p fall=2p
_ie99980 (net028_22 0) d2a src="99980" val0=0.0 val1=vdd valx=vdd/2 rise=2p fall=2p
_ie99981 (net027_14 0) d2a src="99981" val0=0.0 val1=vdd valx=vdd/2 rise=2p fall=2p
_ie99982 (net026_15 0) d2a src="99982" val0=0.0 val1=vdd valx=vdd/2 rise=2p fall=2p
_ie99983 (net028_15 0) d2a src="99983" val0=0.0 val1=vdd valx=vdd/2 rise=2p fall=2p
_ie99984 (net028_16 0) d2a src="99984" val0=0.0 val1=vdd valx=vdd/2 rise=2p fall=2p
_ie99985 (net028_17 0) d2a src="99985" val0=0.0 val1=vdd valx=vdd/2 rise=2p fall=2p
_ie99986 (net028_18 0) d2a src="99986" val0=0.0 val1=vdd valx=vdd/2 rise=2p fall=2p
_ie99987 (net028_19 0) d2a src="99987" val0=0.0 val1=vdd valx=vdd/2 rise=2p fall=2p
_ie99988 (net028_20 0) d2a src="99988" val0=0.0 val1=vdd valx=vdd/2 rise=2p fall=2p
_ie99989 (net028_21 0) d2a src="99989" val0=0.0 val1=vdd valx=vdd/2 rise=2p fall=2p
_ie99990 (net029_5 0) d2a src="99990" val0=0.0 val1=vdd valx=vdd/2 rise=2p fall=2p
_ie99991 (net029_6 0) d2a src="99991" val0=0.0 val1=vdd valx=vdd/2 rise=2p fall=2p
_ie99992 (net029_7 0) d2a src="99992" val0=0.0 val1=vdd valx=vdd/2 rise=2p fall=2p
_ie99993 (net029_8 0) d2a src="99993" val0=0.0 val1=vdd valx=vdd/2 rise=2p fall=2p
_ie99994 (net029_9 0) d2a src="99994" val0=0.0 val1=vdd valx=vdd/2 rise=2p fall=2p
_ie99995 (net029_10 0) d2a src="99995" val0=0.0 val1=vdd valx=vdd/2 rise=2p fall=2p
_ie99996 (net029_11 0) d2a src="99996" val0=0.0 val1=vdd valx=vdd/2 rise=2p fall=2p
_ie99997 (net029_12 0) d2a src="99997" val0=0.0 val1=vdd valx=vdd/2 rise=2p fall=2p
_ie99998 (net029_13 0) d2a src="99998" val0=0.0 val1=vdd valx=vdd/2 rise=2p fall=2p
_ie99999 (net029_14 0) d2a src="99999" val0=0.0 val1=vdd valx=vdd/2 rise=2p fall=2p
// END Hierarchical Interface Elements
ic net033_0=0 net033_1=0 net033_2=0 net033_3=0 net033_4=0 net033_5=0 net033_6=0 net033_7=0 net033_8=0 net033_9=0 net033_10=0 net033_11=0 net033_12=0 net033_13=0 net033_14=0 net033_15=0 net033_16=0 net033_17=0 net033_18=0 net033_19=0 net033_20=0 net033_21=0 net033_22=0 net033_23=0 net032_0=0 net032_1=0 net032_2=0 net032_3=0 net032_4=0 net032_5=0 net032_6=0 net032_7=0 net032_8=0 net032_9=0 net032_10=0 net032_11=0 net032_12=0 net032_13=0 net032_14=0 net032_15=0 net032_16=0 net032_17=0 net032_18=0 net032_19=0 net032_20=0 net032_21=0 net032_22=0 net032_23=0 net031_0=0 net031_1=0 net031_2=0 net031_3=0 net031_4=0 net031_5=0 net031_6=0 net031_7=0 net031_8=0 net031_9=0 net031_10=0 net031_11=0 net031_12=0 net031_13=0 net031_14=0 net031_15=0 net031_16=0 net031_17=0 net031_18=0 net031_19=0 net031_20=0 net031_21=0 net031_22=0 net031_23=0 net030_0=0 net030_1=0 net030_2=0 net030_3=0 net030_4=0 net030_5=0 net030_6=0 net030_7=0 net030_8=0 net030_9=0 net030_10=0 net030_11=0 net030_12=0 net030_13=0 net030_14=0 net030_15=0 net030_16=0 net030_17=0 net030_18=0 net030_19=0 net030_20=0 net030_21=0 net030_22=0 net030_23=0
simulatorOptions options temp=27
tran tran stop=10n errpreset=conservative
