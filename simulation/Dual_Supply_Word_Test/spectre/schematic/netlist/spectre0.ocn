simulator( 'spectre )
design(	 "/net/kafka/nfs/rstdenis/Cadence/simulation/Dual_Supply_Word_Test/spectre/schematic/netlist/netlist")
resultsDir( "/net/kafka/nfs/rstdenis/Cadence/simulation/Dual_Supply_Word_Test/spectre/schematic" )
modelFile(
    '("/software/cadence/ncsu-FreePDK15/hspice_20nm_hp.include" "")
)
analysis('tran ?stop "VAR(\"timeStop\")"  ?errpreset "conservative"  )
desVar(	  "timeStop" 18n	)
desVar(	  "startDelay" 3n	)
desVar(	  "pulseWidth" 3n	)
desVar(	  "C" 26.374f	)
desVar(	  "period" 6n	)
desVar(	  "VDDL" .450	)
desVar(	  "VDDH" .600	)
desVar(	  "nfin" 12	)
envOption(
	'cmd64bit  t
	'analysisOrder  list("tran")
)
option(	'multithread  "on"
)
save( 'v "/VH" "/VL" "/Vline" )
save( 'i "/ILine/src" "/IVDDH/src" "/IVDDL/dst" )
converge( 'ic "/net035" "0" )
converge( 'ic "/VL" "0" )
converge( 'ic "/VH" "VDDH" )
converge( 'ic "/sH" "VDDH" )
converge( 'ic "/Vline" "VDDL" )
converge( 'ic "/net031" "VDDL" )
converge( 'ic "/VDD<0>" "VDDL" )
converge( 'ic "/VDD<1>" "VDDL" )
converge( 'ic "/vcc!" "VDDL" )
converge( 'ic "/I33/I7/I3/Q1" "VDDL" )
converge( 'ic "/I33/I7/I3/Q0" "0" )
converge( 'ic "/net026" "VDDL" )
converge( 'ic "/net027" "VDDL" )
converge( 'ic "/I33/I7/I2/Q0" "0" )
converge( 'ic "/I33/I7/I2/Q1" "VDDL" )
temp( 27 )
run()
selectResult( 'tran )
plot(getData("/ILine/src") getData("/IVDDH/src") getData("/IVDDL/dst") getData("/VH") getData("/VL") getData("/Vline") )
EFall = ymax(iinteg(clip(iPwr tFallSettleStart tFallSettleEnd)))
plot( EFall ?expr '( "EFall" ) )
ERise = ymax(iinteg(clip(iPwr tRiseSettleStart tRiseSettleEnd)))
plot( ERise ?expr '( "ERise" ) )
LeakageIntoVDDL = average(clip(i("/IVDDL/dst" ?result "tran") tLeakageStart tLeakageEnd))
plot( LeakageIntoVDDL ?expr '( "LeakageIntoVDDL" ) )
LeakageLine = average(clip(i("/ILine/src" ?result "tran") tLeakageStart tLeakageEnd))
plot( LeakageLine ?expr '( "LeakageLine" ) )
LeakageVDDH = average(clip(i("/IVDDH/src" ?result "tran") tLeakageStart tLeakageEnd))
plot( LeakageVDDH ?expr '( "LeakageVDDH" ) )
TFall = (tFallEnd - tFallStart)
plot( TFall ?expr '( "TFall" ) )
TPFall = (tTPFallEnd - tFallSettleStart)
plot( TPFall ?expr '( "TPFall" ) )
TPRise = (tTPRiseEnd - tRiseSettleStart)
plot( TPRise ?expr '( "TPRise" ) )
TRise = (tRiseEnd - tRiseStart)
plot( TRise ?expr '( "TRise" ) )
TSettleFall = (tFallSettleEnd - tFallSettleStart)
plot( TSettleFall ?expr '( "TSettleFall" ) )
TSettleRise = (tRiseSettleEnd - tRiseSettleStart)
plot( TSettleRise ?expr '( "TSettleRise" ) )
cVH = clip(v("/VH" ?result "tran") clipStart (VAR("timeStop") - (0.75 * VAR("period"))))
plot( cVH ?expr '( "cVH" ) )
cVL = clip(v("/VL" ?result "tran") clipStart (VAR("timeStop") - (0.75 * VAR("period"))))
plot( cVL ?expr '( "cVL" ) )
cVline = clip(v("/Vline" ?result "tran") clipStart (VAR("timeStop") - (0.75 * VAR("period"))))
plot( cVline ?expr '( "cVline" ) )
clipStart = ((0.75 * VAR("period")) + VAR("startDelay"))
plot( clipStart ?expr '( "clipStart" ) )
iPwr = (i("/IVDDL/dst" ?result "tran") * v("/Vline" ?result "tran"))
plot( iPwr ?expr '( "iPwr" ) )
tFallEnd = cross(cVline (VAR("VDDH") - (0.9 * vDiff)) 1 "falling")
plot( tFallEnd ?expr '( "tFallEnd" ) )
tFallSettleEnd = cross(cVline (1.05 * VAR("VDDL")) 1 "falling")
plot( tFallSettleEnd ?expr '( "tFallSettleEnd" ) )
tFallSettleStart = xmax(intersect(cVH cVL))
plot( tFallSettleStart ?expr '( "tFallSettleStart" ) )
tFallStart = cross(cVline (VAR("VDDH") - (0.1 * vDiff)) 1 "falling")
plot( tFallStart ?expr '( "tFallStart" ) )
tLeakageEnd = (clipStart + (0.58 * VAR("period")))
plot( tLeakageEnd ?expr '( "tLeakageEnd" ) )
tLeakageStart = (clipStart + (0.42 * VAR("period")))
plot( tLeakageStart ?expr '( "tLeakageStart" ) )
tRiseEnd = cross(cVline (VAR("VDDL") + (0.9 * vDiff)) 1 "rising")
plot( tRiseEnd ?expr '( "tRiseEnd" ) )
tRiseSettleEnd = cross(cVline (0.95 * VAR("VDDH")) 1 "rising")
plot( tRiseSettleEnd ?expr '( "tRiseSettleEnd" ) )
tRiseSettleStart = xmax(intersect(cVH cVL))
plot( tRiseSettleStart ?expr '( "tRiseSettleStart" ) )
tRiseStart = cross(cVline (VAR("VDDL") + (0.1 * vDiff)) 1 "rising")
plot( tRiseStart ?expr '( "tRiseStart" ) )
tTPFallEnd = cross(cVline (VAR("VDDH") - (0.5 * vDiff)) 1 "falling")
plot( tTPFallEnd ?expr '( "tTPFallEnd" ) )
tTPRiseEnd = cross(cVline (VAR("VDDL") + (0.5 * vDiff)) 1 "rising")
plot( tTPRiseEnd ?expr '( "tTPRiseEnd" ) )
vDiff = (VAR("VDDH") - VAR("VDDL"))
plot( vDiff ?expr '( "vDiff" ) )
modelFile(
    '("/software/cadence/ncsu-FreePDK15/hspice_20nm_hp.include" "")
)
converge( 'ic "/gnd!" "0" )
converge( 'ic "/I33/I7/I1/Q0" "0" )
converge( 'ic "/I33/I7/I1/Q1" "VDDL" )
run()
selectResult( 'tran )
plot(getData("/I33/I7/I3/Q0") getData("/I33/I7/I3/Q1") getData("/ILine/src") getData("/IVDDH/src") getData("/IVDDL/dst") getData("/VH") getData("/VL") getData("/Vline") )
EFall = ymax(iinteg(clip(iPwr tFallSettleStart tFallSettleEnd)))
plot( EFall ?expr '( "EFall" ) )
ERise = ymax(iinteg(clip(iPwr tRiseSettleStart tRiseSettleEnd)))
plot( ERise ?expr '( "ERise" ) )
LeakageIntoVDDL = average(clip(i("/IVDDL/dst" ?result "tran") tLeakageStart tLeakageEnd))
plot( LeakageIntoVDDL ?expr '( "LeakageIntoVDDL" ) )
LeakageLine = average(clip(i("/ILine/src" ?result "tran") tLeakageStart tLeakageEnd))
plot( LeakageLine ?expr '( "LeakageLine" ) )
LeakageVDDH = average(clip(i("/IVDDH/src" ?result "tran") tLeakageStart tLeakageEnd))
plot( LeakageVDDH ?expr '( "LeakageVDDH" ) )
TFall = (tFallEnd - tFallStart)
plot( TFall ?expr '( "TFall" ) )
TPFall = (tTPFallEnd - tFallSettleStart)
plot( TPFall ?expr '( "TPFall" ) )
TPRise = (tTPRiseEnd - tRiseSettleStart)
plot( TPRise ?expr '( "TPRise" ) )
TRise = (tRiseEnd - tRiseStart)
plot( TRise ?expr '( "TRise" ) )
TSettleFall = (tFallSettleEnd - tFallSettleStart)
plot( TSettleFall ?expr '( "TSettleFall" ) )
TSettleRise = (tRiseSettleEnd - tRiseSettleStart)
plot( TSettleRise ?expr '( "TSettleRise" ) )
cVH = clip(v("/VH" ?result "tran") clipStart (VAR("timeStop") - (0.75 * VAR("period"))))
plot( cVH ?expr '( "cVH" ) )
cVL = clip(v("/VL" ?result "tran") clipStart (VAR("timeStop") - (0.75 * VAR("period"))))
plot( cVL ?expr '( "cVL" ) )
cVline = clip(v("/Vline" ?result "tran") clipStart (VAR("timeStop") - (0.75 * VAR("period"))))
plot( cVline ?expr '( "cVline" ) )
clipStart = ((0.75 * VAR("period")) + VAR("startDelay"))
plot( clipStart ?expr '( "clipStart" ) )
iPwr = (i("/IVDDL/dst" ?result "tran") * v("/Vline" ?result "tran"))
plot( iPwr ?expr '( "iPwr" ) )
tFallEnd = cross(cVline (VAR("VDDH") - (0.9 * vDiff)) 1 "falling")
plot( tFallEnd ?expr '( "tFallEnd" ) )
tFallSettleEnd = cross(cVline (1.05 * VAR("VDDL")) 1 "falling")
plot( tFallSettleEnd ?expr '( "tFallSettleEnd" ) )
tFallSettleStart = xmax(intersect(cVH cVL))
plot( tFallSettleStart ?expr '( "tFallSettleStart" ) )
tFallStart = cross(cVline (VAR("VDDH") - (0.1 * vDiff)) 1 "falling")
plot( tFallStart ?expr '( "tFallStart" ) )
tLeakageEnd = (clipStart + (0.58 * VAR("period")))
plot( tLeakageEnd ?expr '( "tLeakageEnd" ) )
tLeakageStart = (clipStart + (0.42 * VAR("period")))
plot( tLeakageStart ?expr '( "tLeakageStart" ) )
tRiseEnd = cross(cVline (VAR("VDDL") + (0.9 * vDiff)) 1 "rising")
plot( tRiseEnd ?expr '( "tRiseEnd" ) )
tRiseSettleEnd = cross(cVline (0.95 * VAR("VDDH")) 1 "rising")
plot( tRiseSettleEnd ?expr '( "tRiseSettleEnd" ) )
tRiseSettleStart = xmax(intersect(cVH cVL))
plot( tRiseSettleStart ?expr '( "tRiseSettleStart" ) )
tRiseStart = cross(cVline (VAR("VDDL") + (0.1 * vDiff)) 1 "rising")
plot( tRiseStart ?expr '( "tRiseStart" ) )
tTPFallEnd = cross(cVline (VAR("VDDH") - (0.5 * vDiff)) 1 "falling")
plot( tTPFallEnd ?expr '( "tTPFallEnd" ) )
tTPRiseEnd = cross(cVline (VAR("VDDL") + (0.5 * vDiff)) 1 "rising")
plot( tTPRiseEnd ?expr '( "tTPRiseEnd" ) )
vDiff = (VAR("VDDH") - VAR("VDDL"))
plot( vDiff ?expr '( "vDiff" ) )
modelFile(
    '("/software/cadence/ncsu-FreePDK15/hspice_20nm_hp.include" "")
)
delete( 'converge 'ic "/Vline" )
delete( 'converge 'ic "/net031" )
delete( 'converge 'ic "/VDD<0>" )
delete( 'converge 'ic "/VDD<1>" )
delete( 'converge 'ic "/net026" )
delete( 'converge 'ic "/net027" )
run()
selectResult( 'tran )
plot(getData("/ILine/src") getData("/IVDDH/src") getData("/IVDDL/dst") getData("/VH") getData("/VL") getData("/Vline") getData("/I33/I7/I3/Q1") getData("/I33/I7/I3/Q0") )
EFall = ymax(iinteg(clip(iPwr tFallSettleStart tFallSettleEnd)))
plot( EFall ?expr '( "EFall" ) )
ERise = ymax(iinteg(clip(iPwr tRiseSettleStart tRiseSettleEnd)))
plot( ERise ?expr '( "ERise" ) )
LeakageIntoVDDL = average(clip(i("/IVDDL/dst" ?result "tran") tLeakageStart tLeakageEnd))
plot( LeakageIntoVDDL ?expr '( "LeakageIntoVDDL" ) )
LeakageLine = average(clip(i("/ILine/src" ?result "tran") tLeakageStart tLeakageEnd))
plot( LeakageLine ?expr '( "LeakageLine" ) )
LeakageVDDH = average(clip(i("/IVDDH/src" ?result "tran") tLeakageStart tLeakageEnd))
plot( LeakageVDDH ?expr '( "LeakageVDDH" ) )
TFall = (tFallEnd - tFallStart)
plot( TFall ?expr '( "TFall" ) )
TPFall = (tTPFallEnd - tFallSettleStart)
plot( TPFall ?expr '( "TPFall" ) )
TPRise = (tTPRiseEnd - tRiseSettleStart)
plot( TPRise ?expr '( "TPRise" ) )
TRise = (tRiseEnd - tRiseStart)
plot( TRise ?expr '( "TRise" ) )
TSettleFall = (tFallSettleEnd - tFallSettleStart)
plot( TSettleFall ?expr '( "TSettleFall" ) )
TSettleRise = (tRiseSettleEnd - tRiseSettleStart)
plot( TSettleRise ?expr '( "TSettleRise" ) )
cVH = clip(v("/VH" ?result "tran") clipStart (VAR("timeStop") - (0.75 * VAR("period"))))
plot( cVH ?expr '( "cVH" ) )
cVL = clip(v("/VL" ?result "tran") clipStart (VAR("timeStop") - (0.75 * VAR("period"))))
plot( cVL ?expr '( "cVL" ) )
cVline = clip(v("/Vline" ?result "tran") clipStart (VAR("timeStop") - (0.75 * VAR("period"))))
plot( cVline ?expr '( "cVline" ) )
clipStart = ((0.75 * VAR("period")) + VAR("startDelay"))
plot( clipStart ?expr '( "clipStart" ) )
iPwr = (i("/IVDDL/dst" ?result "tran") * v("/Vline" ?result "tran"))
plot( iPwr ?expr '( "iPwr" ) )
tFallEnd = cross(cVline (VAR("VDDH") - (0.9 * vDiff)) 1 "falling")
plot( tFallEnd ?expr '( "tFallEnd" ) )
tFallSettleEnd = cross(cVline (1.05 * VAR("VDDL")) 1 "falling")
plot( tFallSettleEnd ?expr '( "tFallSettleEnd" ) )
tFallSettleStart = xmax(intersect(cVH cVL))
plot( tFallSettleStart ?expr '( "tFallSettleStart" ) )
tFallStart = cross(cVline (VAR("VDDH") - (0.1 * vDiff)) 1 "falling")
plot( tFallStart ?expr '( "tFallStart" ) )
tLeakageEnd = (clipStart + (0.58 * VAR("period")))
plot( tLeakageEnd ?expr '( "tLeakageEnd" ) )
tLeakageStart = (clipStart + (0.42 * VAR("period")))
plot( tLeakageStart ?expr '( "tLeakageStart" ) )
tRiseEnd = cross(cVline (VAR("VDDL") + (0.9 * vDiff)) 1 "rising")
plot( tRiseEnd ?expr '( "tRiseEnd" ) )
tRiseSettleEnd = cross(cVline (0.95 * VAR("VDDH")) 1 "rising")
plot( tRiseSettleEnd ?expr '( "tRiseSettleEnd" ) )
tRiseSettleStart = xmax(intersect(cVH cVL))
plot( tRiseSettleStart ?expr '( "tRiseSettleStart" ) )
tRiseStart = cross(cVline (VAR("VDDL") + (0.1 * vDiff)) 1 "rising")
plot( tRiseStart ?expr '( "tRiseStart" ) )
tTPFallEnd = cross(cVline (VAR("VDDH") - (0.5 * vDiff)) 1 "falling")
plot( tTPFallEnd ?expr '( "tTPFallEnd" ) )
tTPRiseEnd = cross(cVline (VAR("VDDL") + (0.5 * vDiff)) 1 "rising")
plot( tTPRiseEnd ?expr '( "tTPRiseEnd" ) )
vDiff = (VAR("VDDH") - VAR("VDDL"))
plot( vDiff ?expr '( "vDiff" ) )
modelFile(
    '("/software/cadence/ncsu-FreePDK15/hspice_20nm_hp.include" "")
)
converge( 'ic "/I34/I7/I3/Q0" "0" )
converge( 'ic "/I34/I7/I3/Q1" "VDDL" )
run()
selectResult( 'tran )
plot(getData("/ILine/src") getData("/IVDDH/src") getData("/IVDDL/dst") getData("/VH") getData("/VL") getData("/Vline") getData("/I33/I7/I3/Q1") getData("/I33/I7/I3/Q0") )
EFall = ymax(iinteg(clip(iPwr tFallSettleStart tFallSettleEnd)))
plot( EFall ?expr '( "EFall" ) )
ERise = ymax(iinteg(clip(iPwr tRiseSettleStart tRiseSettleEnd)))
plot( ERise ?expr '( "ERise" ) )
LeakageIntoVDDL = average(clip(i("/IVDDL/dst" ?result "tran") tLeakageStart tLeakageEnd))
plot( LeakageIntoVDDL ?expr '( "LeakageIntoVDDL" ) )
LeakageLine = average(clip(i("/ILine/src" ?result "tran") tLeakageStart tLeakageEnd))
plot( LeakageLine ?expr '( "LeakageLine" ) )
LeakageVDDH = average(clip(i("/IVDDH/src" ?result "tran") tLeakageStart tLeakageEnd))
plot( LeakageVDDH ?expr '( "LeakageVDDH" ) )
TFall = (tFallEnd - tFallStart)
plot( TFall ?expr '( "TFall" ) )
TPFall = (tTPFallEnd - tFallSettleStart)
plot( TPFall ?expr '( "TPFall" ) )
TPRise = (tTPRiseEnd - tRiseSettleStart)
plot( TPRise ?expr '( "TPRise" ) )
TRise = (tRiseEnd - tRiseStart)
plot( TRise ?expr '( "TRise" ) )
TSettleFall = (tFallSettleEnd - tFallSettleStart)
plot( TSettleFall ?expr '( "TSettleFall" ) )
TSettleRise = (tRiseSettleEnd - tRiseSettleStart)
plot( TSettleRise ?expr '( "TSettleRise" ) )
cVH = clip(v("/VH" ?result "tran") clipStart (VAR("timeStop") - (0.75 * VAR("period"))))
plot( cVH ?expr '( "cVH" ) )
cVL = clip(v("/VL" ?result "tran") clipStart (VAR("timeStop") - (0.75 * VAR("period"))))
plot( cVL ?expr '( "cVL" ) )
cVline = clip(v("/Vline" ?result "tran") clipStart (VAR("timeStop") - (0.75 * VAR("period"))))
plot( cVline ?expr '( "cVline" ) )
clipStart = ((0.75 * VAR("period")) + VAR("startDelay"))
plot( clipStart ?expr '( "clipStart" ) )
iPwr = (i("/IVDDL/dst" ?result "tran") * v("/Vline" ?result "tran"))
plot( iPwr ?expr '( "iPwr" ) )
tFallEnd = cross(cVline (VAR("VDDH") - (0.9 * vDiff)) 1 "falling")
plot( tFallEnd ?expr '( "tFallEnd" ) )
tFallSettleEnd = cross(cVline (1.05 * VAR("VDDL")) 1 "falling")
plot( tFallSettleEnd ?expr '( "tFallSettleEnd" ) )
tFallSettleStart = xmax(intersect(cVH cVL))
plot( tFallSettleStart ?expr '( "tFallSettleStart" ) )
tFallStart = cross(cVline (VAR("VDDH") - (0.1 * vDiff)) 1 "falling")
plot( tFallStart ?expr '( "tFallStart" ) )
tLeakageEnd = (clipStart + (0.58 * VAR("period")))
plot( tLeakageEnd ?expr '( "tLeakageEnd" ) )
tLeakageStart = (clipStart + (0.42 * VAR("period")))
plot( tLeakageStart ?expr '( "tLeakageStart" ) )
tRiseEnd = cross(cVline (VAR("VDDL") + (0.9 * vDiff)) 1 "rising")
plot( tRiseEnd ?expr '( "tRiseEnd" ) )
tRiseSettleEnd = cross(cVline (0.95 * VAR("VDDH")) 1 "rising")
plot( tRiseSettleEnd ?expr '( "tRiseSettleEnd" ) )
tRiseSettleStart = xmax(intersect(cVH cVL))
plot( tRiseSettleStart ?expr '( "tRiseSettleStart" ) )
tRiseStart = cross(cVline (VAR("VDDL") + (0.1 * vDiff)) 1 "rising")
plot( tRiseStart ?expr '( "tRiseStart" ) )
tTPFallEnd = cross(cVline (VAR("VDDH") - (0.5 * vDiff)) 1 "falling")
plot( tTPFallEnd ?expr '( "tTPFallEnd" ) )
tTPRiseEnd = cross(cVline (VAR("VDDL") + (0.5 * vDiff)) 1 "rising")
plot( tTPRiseEnd ?expr '( "tTPRiseEnd" ) )
vDiff = (VAR("VDDH") - VAR("VDDL"))
plot( vDiff ?expr '( "vDiff" ) )
modelFile(
    '("/software/cadence/ncsu-FreePDK15/hspice_20nm_hp.include" "")
)
analysis('tran ?ic "all"
		?readic "/net/kafka/nfs/rstdenis/Cadence/simulation/Dual_Supply_Word_Test/spectre/schematic/netlist/spectre.ic"
		)
run()
selectResult( 'tran )
plot(getData("/ILine/src") getData("/IVDDH/src") getData("/IVDDL/dst") getData("/VH") getData("/VL") getData("/Vline") getData("/I33/I7/I3/Q1") getData("/I33/I7/I3/Q0") )
EFall = ymax(iinteg(clip(iPwr tFallSettleStart tFallSettleEnd)))
plot( EFall ?expr '( "EFall" ) )
ERise = ymax(iinteg(clip(iPwr tRiseSettleStart tRiseSettleEnd)))
plot( ERise ?expr '( "ERise" ) )
LeakageIntoVDDL = average(clip(i("/IVDDL/dst" ?result "tran") tLeakageStart tLeakageEnd))
plot( LeakageIntoVDDL ?expr '( "LeakageIntoVDDL" ) )
LeakageLine = average(clip(i("/ILine/src" ?result "tran") tLeakageStart tLeakageEnd))
plot( LeakageLine ?expr '( "LeakageLine" ) )
LeakageVDDH = average(clip(i("/IVDDH/src" ?result "tran") tLeakageStart tLeakageEnd))
plot( LeakageVDDH ?expr '( "LeakageVDDH" ) )
TFall = (tFallEnd - tFallStart)
plot( TFall ?expr '( "TFall" ) )
TPFall = (tTPFallEnd - tFallSettleStart)
plot( TPFall ?expr '( "TPFall" ) )
TPRise = (tTPRiseEnd - tRiseSettleStart)
plot( TPRise ?expr '( "TPRise" ) )
TRise = (tRiseEnd - tRiseStart)
plot( TRise ?expr '( "TRise" ) )
TSettleFall = (tFallSettleEnd - tFallSettleStart)
plot( TSettleFall ?expr '( "TSettleFall" ) )
TSettleRise = (tRiseSettleEnd - tRiseSettleStart)
plot( TSettleRise ?expr '( "TSettleRise" ) )
cVH = clip(v("/VH" ?result "tran") clipStart (VAR("timeStop") - (0.75 * VAR("period"))))
plot( cVH ?expr '( "cVH" ) )
cVL = clip(v("/VL" ?result "tran") clipStart (VAR("timeStop") - (0.75 * VAR("period"))))
plot( cVL ?expr '( "cVL" ) )
cVline = clip(v("/Vline" ?result "tran") clipStart (VAR("timeStop") - (0.75 * VAR("period"))))
plot( cVline ?expr '( "cVline" ) )
clipStart = ((0.75 * VAR("period")) + VAR("startDelay"))
plot( clipStart ?expr '( "clipStart" ) )
iPwr = (i("/IVDDL/dst" ?result "tran") * v("/Vline" ?result "tran"))
plot( iPwr ?expr '( "iPwr" ) )
tFallEnd = cross(cVline (VAR("VDDH") - (0.9 * vDiff)) 1 "falling")
plot( tFallEnd ?expr '( "tFallEnd" ) )
tFallSettleEnd = cross(cVline (1.05 * VAR("VDDL")) 1 "falling")
plot( tFallSettleEnd ?expr '( "tFallSettleEnd" ) )
tFallSettleStart = xmax(intersect(cVH cVL))
plot( tFallSettleStart ?expr '( "tFallSettleStart" ) )
tFallStart = cross(cVline (VAR("VDDH") - (0.1 * vDiff)) 1 "falling")
plot( tFallStart ?expr '( "tFallStart" ) )
tLeakageEnd = (clipStart + (0.58 * VAR("period")))
plot( tLeakageEnd ?expr '( "tLeakageEnd" ) )
tLeakageStart = (clipStart + (0.42 * VAR("period")))
plot( tLeakageStart ?expr '( "tLeakageStart" ) )
tRiseEnd = cross(cVline (VAR("VDDL") + (0.9 * vDiff)) 1 "rising")
plot( tRiseEnd ?expr '( "tRiseEnd" ) )
tRiseSettleEnd = cross(cVline (0.95 * VAR("VDDH")) 1 "rising")
plot( tRiseSettleEnd ?expr '( "tRiseSettleEnd" ) )
tRiseSettleStart = xmax(intersect(cVH cVL))
plot( tRiseSettleStart ?expr '( "tRiseSettleStart" ) )
tRiseStart = cross(cVline (VAR("VDDL") + (0.1 * vDiff)) 1 "rising")
plot( tRiseStart ?expr '( "tRiseStart" ) )
tTPFallEnd = cross(cVline (VAR("VDDH") - (0.5 * vDiff)) 1 "falling")
plot( tTPFallEnd ?expr '( "tTPFallEnd" ) )
tTPRiseEnd = cross(cVline (VAR("VDDL") + (0.5 * vDiff)) 1 "rising")
plot( tTPRiseEnd ?expr '( "tTPRiseEnd" ) )
vDiff = (VAR("VDDH") - VAR("VDDL"))
plot( vDiff ?expr '( "vDiff" ) )
