simulator( 'spectre )
design(	 "/net/kafka/nfs/rstdenis/Cadence/simulation/Dual_Supply_Word_Test/spectre/schematic/netlist/netlist")
resultsDir( "/net/kafka/nfs/rstdenis/Cadence/simulation/Dual_Supply_Word_Test/spectre/schematic" )
modelFile(
    '("/software/cadence/ncsu-FreePDK15/hspice_20nm_hp.include" "")
)
analysis('tran ?stop "VAR(\"timeStop\")"  ?errpreset "conservative"  )
desVar(	  "C" 100f	)
desVar(	  "startDelay" 5n	)
desVar(	  "pulseWidth" 7n	)
desVar(	  "period" 14n	)
desVar(	  "timeStop" 32n	)
desVar(	  "VDDL" .450	)
desVar(	  "VDDH" .600	)
desVar(	  "nfin" 12	)
envOption(
	'cmd64bit  t
	'analysisOrder  list("tran")
)
option(	'multithread  "on"
)
save( 'v "/VH" "/VL" "/Vline" )
save( 'i "/IVDDH/src" "/IVDDL/dst" "/ILine/src" )
converge( 'ic "/net035" "0" )
converge( 'ic "/sH" "VDDH" )
converge( 'ic "/VH" "VDDH" )
converge( 'ic "/VL" "0" )
temp( 27 )
run()
selectResult( 'tran )
plot(getData("/IVDDH/src") getData("/IVDDL/dst") getData("/VH") getData("/VL") getData("/Vline") getData("/ILine/src") )
LeakageIntoVDDL = average(clip(i("/IVDDL/dst" ?result "tran") tLeakageStart tLeakageEnd))
plot( LeakageIntoVDDL ?expr '( "LeakageIntoVDDL" ) )
LeakageLine = average(clip(i("/ILine/src" ?result "tran") tLeakageStart tLeakageEnd))
plot( LeakageLine ?expr '( "LeakageLine" ) )
LeakageVDDH = average(clip(i("/IVDDH/src" ?result "tran") tLeakageStart tLeakageEnd))
plot( LeakageVDDH ?expr '( "LeakageVDDH" ) )
QFall_pVDDL = ymax(iinteg(clip(i("/IVDDL/dst" ?result "tran") tFallSettleStart tFallSettleEnd)))
plot( QFall_pVDDL ?expr '( "QFall_pVDDL" ) )
QRise_pVDDH = ymax(iinteg(clip(i("/IVDDH/src" ?result "tran") tRiseSettleStart tRiseSettleEnd)))
plot( QRise_pVDDH ?expr '( "QRise_pVDDH" ) )
TFall = (tFallEnd - tFallStart)
plot( TFall ?expr '( "TFall" ) )
TPFall = (tTPFallEnd - tFallSettleStart)
plot( TPFall ?expr '( "TPFall" ) )
TPRise = (tTPRiseEnd - tRiseSettleStart)
plot( TPRise ?expr '( "TPRise" ) )
TRise = (tRiseEnd - tRiseStart)
plot( TRise ?expr '( "TRise" ) )
TSettleFall = (tFallSettleEnd - tFallSettleStart)
plot( TSettleFall ?expr '( "TSettleFall" ) )
TSettleRise = (tRiseSettleEnd - tRiseSettleStart)
plot( TSettleRise ?expr '( "TSettleRise" ) )
cVline = clip(v("/Vline" ?result "tran") clipStart VAR("timeStop"))
plot( cVline ?expr '( "cVline" ) )
clipStart = (1.25 * VAR("period"))
plot( clipStart ?expr '( "clipStart" ) )
tFallEnd = cross(cVline (VAR("VDDH") - (0.9 * vDiff)) 1 "falling")
plot( tFallEnd ?expr '( "tFallEnd" ) )
tFallSettleEnd = cross(cVline (1.05 * VAR("VDDL")) 1 "falling")
plot( tFallSettleEnd ?expr '( "tFallSettleEnd" ) )
tFallSettleStart = cross(clip(v("/VH" ?result "tran") clipStart VAR("timeStop")) (0.5 * VAR("VDDH")) 1 "rising")
plot( tFallSettleStart ?expr '( "tFallSettleStart" ) )
tFallStart = cross(cVline (VAR("VDDH") - (0.1 * vDiff)) 1 "falling")
plot( tFallStart ?expr '( "tFallStart" ) )
tLeakageEnd = (clipStart + (0.51 * VAR("period")))
plot( tLeakageEnd ?expr '( "tLeakageEnd" ) )
tLeakageStart = (clipStart + (0.49 * VAR("period")))
plot( tLeakageStart ?expr '( "tLeakageStart" ) )
tRiseEnd = cross(cVline (VAR("VDDL") + (0.9 * vDiff)) 1 "rising")
plot( tRiseEnd ?expr '( "tRiseEnd" ) )
tRiseSettleEnd = cross(cVline (0.95 * VAR("VDDH")) 1 "rising")
plot( tRiseSettleEnd ?expr '( "tRiseSettleEnd" ) )
tRiseSettleStart = cross(clip(v("/VH" ?result "tran") clipStart VAR("timeStop")) (0.5 * VAR("VDDH")) 1 "falling")
plot( tRiseSettleStart ?expr '( "tRiseSettleStart" ) )
tRiseStart = cross(cVline (VAR("VDDL") + (0.1 * vDiff)) 1 "rising")
plot( tRiseStart ?expr '( "tRiseStart" ) )
tTPFallEnd = cross(cVline (VAR("VDDH") - (0.5 * vDiff)) 1 "falling")
plot( tTPFallEnd ?expr '( "tTPFallEnd" ) )
tTPRiseEnd = cross(cVline (VAR("VDDL") + (0.5 * vDiff)) 1 "rising")
plot( tTPRiseEnd ?expr '( "tTPRiseEnd" ) )
vDiff = (VAR("VDDH") - VAR("VDDL"))
plot( vDiff ?expr '( "vDiff" ) )
modelFile(
    '("/software/cadence/ncsu-FreePDK15/hspice_20nm_hp.include" "")
)
desVar(	  "C" 596.31f	)
desVar(	  "nfin" 32	)
run()
selectResult( 'tran )
plot(getData("/IVDDH/src") getData("/IVDDL/dst") getData("/VH") getData("/VL") getData("/Vline") getData("/ILine/src") )
LeakageIntoVDDL = average(clip(i("/IVDDL/dst" ?result "tran") tLeakageStart tLeakageEnd))
plot( LeakageIntoVDDL ?expr '( "LeakageIntoVDDL" ) )
LeakageLine = average(clip(i("/ILine/src" ?result "tran") tLeakageStart tLeakageEnd))
plot( LeakageLine ?expr '( "LeakageLine" ) )
LeakageVDDH = average(clip(i("/IVDDH/src" ?result "tran") tLeakageStart tLeakageEnd))
plot( LeakageVDDH ?expr '( "LeakageVDDH" ) )
QFall_pVDDL = ymax(iinteg(clip(i("/IVDDL/dst" ?result "tran") tFallSettleStart tFallSettleEnd)))
plot( QFall_pVDDL ?expr '( "QFall_pVDDL" ) )
QRise_pVDDH = ymax(iinteg(clip(i("/IVDDH/src" ?result "tran") tRiseSettleStart tRiseSettleEnd)))
plot( QRise_pVDDH ?expr '( "QRise_pVDDH" ) )
TFall = (tFallEnd - tFallStart)
plot( TFall ?expr '( "TFall" ) )
TPFall = (tTPFallEnd - tFallSettleStart)
plot( TPFall ?expr '( "TPFall" ) )
TPRise = (tTPRiseEnd - tRiseSettleStart)
plot( TPRise ?expr '( "TPRise" ) )
TRise = (tRiseEnd - tRiseStart)
plot( TRise ?expr '( "TRise" ) )
TSettleFall = (tFallSettleEnd - tFallSettleStart)
plot( TSettleFall ?expr '( "TSettleFall" ) )
TSettleRise = (tRiseSettleEnd - tRiseSettleStart)
plot( TSettleRise ?expr '( "TSettleRise" ) )
cVline = clip(v("/Vline" ?result "tran") clipStart VAR("timeStop"))
plot( cVline ?expr '( "cVline" ) )
clipStart = (1.25 * VAR("period"))
plot( clipStart ?expr '( "clipStart" ) )
tFallEnd = cross(cVline (VAR("VDDH") - (0.9 * vDiff)) 1 "falling")
plot( tFallEnd ?expr '( "tFallEnd" ) )
tFallSettleEnd = cross(cVline (1.05 * VAR("VDDL")) 1 "falling")
plot( tFallSettleEnd ?expr '( "tFallSettleEnd" ) )
tFallSettleStart = cross(clip(v("/VH" ?result "tran") clipStart VAR("timeStop")) (0.5 * VAR("VDDH")) 1 "rising")
plot( tFallSettleStart ?expr '( "tFallSettleStart" ) )
tFallStart = cross(cVline (VAR("VDDH") - (0.1 * vDiff)) 1 "falling")
plot( tFallStart ?expr '( "tFallStart" ) )
tLeakageEnd = (clipStart + (0.51 * VAR("period")))
plot( tLeakageEnd ?expr '( "tLeakageEnd" ) )
tLeakageStart = (clipStart + (0.49 * VAR("period")))
plot( tLeakageStart ?expr '( "tLeakageStart" ) )
tRiseEnd = cross(cVline (VAR("VDDL") + (0.9 * vDiff)) 1 "rising")
plot( tRiseEnd ?expr '( "tRiseEnd" ) )
tRiseSettleEnd = cross(cVline (0.95 * VAR("VDDH")) 1 "rising")
plot( tRiseSettleEnd ?expr '( "tRiseSettleEnd" ) )
tRiseSettleStart = cross(clip(v("/VH" ?result "tran") clipStart VAR("timeStop")) (0.5 * VAR("VDDH")) 1 "falling")
plot( tRiseSettleStart ?expr '( "tRiseSettleStart" ) )
tRiseStart = cross(cVline (VAR("VDDL") + (0.1 * vDiff)) 1 "rising")
plot( tRiseStart ?expr '( "tRiseStart" ) )
tTPFallEnd = cross(cVline (VAR("VDDH") - (0.5 * vDiff)) 1 "falling")
plot( tTPFallEnd ?expr '( "tTPFallEnd" ) )
tTPRiseEnd = cross(cVline (VAR("VDDL") + (0.5 * vDiff)) 1 "rising")
plot( tTPRiseEnd ?expr '( "tTPRiseEnd" ) )
vDiff = (VAR("VDDH") - VAR("VDDL"))
plot( vDiff ?expr '( "vDiff" ) )
modelFile(
    '("/software/cadence/ncsu-FreePDK15/hspice_20nm_hp.include" "")
)
desVar(	  "pulseWidth" 3n	)
desVar(	  "period" 6n	)
run()
selectResult( 'tran )
plot(getData("/IVDDH/src") getData("/IVDDL/dst") getData("/VH") getData("/VL") getData("/Vline") getData("/ILine/src") )
LeakageIntoVDDL = average(clip(i("/IVDDL/dst" ?result "tran") tLeakageStart tLeakageEnd))
plot( LeakageIntoVDDL ?expr '( "LeakageIntoVDDL" ) )
LeakageLine = average(clip(i("/ILine/src" ?result "tran") tLeakageStart tLeakageEnd))
plot( LeakageLine ?expr '( "LeakageLine" ) )
LeakageVDDH = average(clip(i("/IVDDH/src" ?result "tran") tLeakageStart tLeakageEnd))
plot( LeakageVDDH ?expr '( "LeakageVDDH" ) )
QFall_pVDDL = ymax(iinteg(clip(i("/IVDDL/dst" ?result "tran") tFallSettleStart tFallSettleEnd)))
plot( QFall_pVDDL ?expr '( "QFall_pVDDL" ) )
QRise_pVDDH = ymax(iinteg(clip(i("/IVDDH/src" ?result "tran") tRiseSettleStart tRiseSettleEnd)))
plot( QRise_pVDDH ?expr '( "QRise_pVDDH" ) )
TFall = (tFallEnd - tFallStart)
plot( TFall ?expr '( "TFall" ) )
TPFall = (tTPFallEnd - tFallSettleStart)
plot( TPFall ?expr '( "TPFall" ) )
TPRise = (tTPRiseEnd - tRiseSettleStart)
plot( TPRise ?expr '( "TPRise" ) )
TRise = (tRiseEnd - tRiseStart)
plot( TRise ?expr '( "TRise" ) )
TSettleFall = (tFallSettleEnd - tFallSettleStart)
plot( TSettleFall ?expr '( "TSettleFall" ) )
TSettleRise = (tRiseSettleEnd - tRiseSettleStart)
plot( TSettleRise ?expr '( "TSettleRise" ) )
cVline = clip(v("/Vline" ?result "tran") clipStart VAR("timeStop"))
plot( cVline ?expr '( "cVline" ) )
clipStart = (1.25 * VAR("period"))
plot( clipStart ?expr '( "clipStart" ) )
tFallEnd = cross(cVline (VAR("VDDH") - (0.9 * vDiff)) 1 "falling")
plot( tFallEnd ?expr '( "tFallEnd" ) )
tFallSettleEnd = cross(cVline (1.05 * VAR("VDDL")) 1 "falling")
plot( tFallSettleEnd ?expr '( "tFallSettleEnd" ) )
tFallSettleStart = cross(clip(v("/VH" ?result "tran") clipStart VAR("timeStop")) (0.5 * VAR("VDDH")) 1 "rising")
plot( tFallSettleStart ?expr '( "tFallSettleStart" ) )
tFallStart = cross(cVline (VAR("VDDH") - (0.1 * vDiff)) 1 "falling")
plot( tFallStart ?expr '( "tFallStart" ) )
tLeakageEnd = (clipStart + (0.51 * VAR("period")))
plot( tLeakageEnd ?expr '( "tLeakageEnd" ) )
tLeakageStart = (clipStart + (0.49 * VAR("period")))
plot( tLeakageStart ?expr '( "tLeakageStart" ) )
tRiseEnd = cross(cVline (VAR("VDDL") + (0.9 * vDiff)) 1 "rising")
plot( tRiseEnd ?expr '( "tRiseEnd" ) )
tRiseSettleEnd = cross(cVline (0.95 * VAR("VDDH")) 1 "rising")
plot( tRiseSettleEnd ?expr '( "tRiseSettleEnd" ) )
tRiseSettleStart = cross(clip(v("/VH" ?result "tran") clipStart VAR("timeStop")) (0.5 * VAR("VDDH")) 1 "falling")
plot( tRiseSettleStart ?expr '( "tRiseSettleStart" ) )
tRiseStart = cross(cVline (VAR("VDDL") + (0.1 * vDiff)) 1 "rising")
plot( tRiseStart ?expr '( "tRiseStart" ) )
tTPFallEnd = cross(cVline (VAR("VDDH") - (0.5 * vDiff)) 1 "falling")
plot( tTPFallEnd ?expr '( "tTPFallEnd" ) )
tTPRiseEnd = cross(cVline (VAR("VDDL") + (0.5 * vDiff)) 1 "rising")
plot( tTPRiseEnd ?expr '( "tTPRiseEnd" ) )
vDiff = (VAR("VDDH") - VAR("VDDL"))
plot( vDiff ?expr '( "vDiff" ) )
modelFile(
    '("/software/cadence/ncsu-FreePDK15/hspice_20nm_hp.include" "")
)
desVar(	  "timeStop" "3*period"	)
run()
selectResult( 'tran )
plot(getData("/IVDDH/src") getData("/IVDDL/dst") getData("/VH") getData("/VL") getData("/Vline") getData("/ILine/src") )
LeakageIntoVDDL = average(clip(i("/IVDDL/dst" ?result "tran") tLeakageStart tLeakageEnd))
plot( LeakageIntoVDDL ?expr '( "LeakageIntoVDDL" ) )
LeakageLine = average(clip(i("/ILine/src" ?result "tran") tLeakageStart tLeakageEnd))
plot( LeakageLine ?expr '( "LeakageLine" ) )
LeakageVDDH = average(clip(i("/IVDDH/src" ?result "tran") tLeakageStart tLeakageEnd))
plot( LeakageVDDH ?expr '( "LeakageVDDH" ) )
QFall_pVDDL = ymax(iinteg(clip(i("/IVDDL/dst" ?result "tran") tFallSettleStart tFallSettleEnd)))
plot( QFall_pVDDL ?expr '( "QFall_pVDDL" ) )
QRise_pVDDH = ymax(iinteg(clip(i("/IVDDH/src" ?result "tran") tRiseSettleStart tRiseSettleEnd)))
plot( QRise_pVDDH ?expr '( "QRise_pVDDH" ) )
TFall = (tFallEnd - tFallStart)
plot( TFall ?expr '( "TFall" ) )
TPFall = (tTPFallEnd - tFallSettleStart)
plot( TPFall ?expr '( "TPFall" ) )
TPRise = (tTPRiseEnd - tRiseSettleStart)
plot( TPRise ?expr '( "TPRise" ) )
TRise = (tRiseEnd - tRiseStart)
plot( TRise ?expr '( "TRise" ) )
TSettleFall = (tFallSettleEnd - tFallSettleStart)
plot( TSettleFall ?expr '( "TSettleFall" ) )
TSettleRise = (tRiseSettleEnd - tRiseSettleStart)
plot( TSettleRise ?expr '( "TSettleRise" ) )
cVline = clip(v("/Vline" ?result "tran") clipStart VAR("timeStop"))
plot( cVline ?expr '( "cVline" ) )
clipStart = (1.25 * VAR("period"))
plot( clipStart ?expr '( "clipStart" ) )
tFallEnd = cross(cVline (VAR("VDDH") - (0.9 * vDiff)) 1 "falling")
plot( tFallEnd ?expr '( "tFallEnd" ) )
tFallSettleEnd = cross(cVline (1.05 * VAR("VDDL")) 1 "falling")
plot( tFallSettleEnd ?expr '( "tFallSettleEnd" ) )
tFallSettleStart = cross(clip(v("/VH" ?result "tran") clipStart VAR("timeStop")) (0.5 * VAR("VDDH")) 1 "rising")
plot( tFallSettleStart ?expr '( "tFallSettleStart" ) )
tFallStart = cross(cVline (VAR("VDDH") - (0.1 * vDiff)) 1 "falling")
plot( tFallStart ?expr '( "tFallStart" ) )
tLeakageEnd = (clipStart + (0.51 * VAR("period")))
plot( tLeakageEnd ?expr '( "tLeakageEnd" ) )
tLeakageStart = (clipStart + (0.49 * VAR("period")))
plot( tLeakageStart ?expr '( "tLeakageStart" ) )
tRiseEnd = cross(cVline (VAR("VDDL") + (0.9 * vDiff)) 1 "rising")
plot( tRiseEnd ?expr '( "tRiseEnd" ) )
tRiseSettleEnd = cross(cVline (0.95 * VAR("VDDH")) 1 "rising")
plot( tRiseSettleEnd ?expr '( "tRiseSettleEnd" ) )
tRiseSettleStart = cross(clip(v("/VH" ?result "tran") clipStart VAR("timeStop")) (0.5 * VAR("VDDH")) 1 "falling")
plot( tRiseSettleStart ?expr '( "tRiseSettleStart" ) )
tRiseStart = cross(cVline (VAR("VDDL") + (0.1 * vDiff)) 1 "rising")
plot( tRiseStart ?expr '( "tRiseStart" ) )
tTPFallEnd = cross(cVline (VAR("VDDH") - (0.5 * vDiff)) 1 "falling")
plot( tTPFallEnd ?expr '( "tTPFallEnd" ) )
tTPRiseEnd = cross(cVline (VAR("VDDL") + (0.5 * vDiff)) 1 "rising")
plot( tTPRiseEnd ?expr '( "tTPRiseEnd" ) )
vDiff = (VAR("VDDH") - VAR("VDDL"))
plot( vDiff ?expr '( "vDiff" ) )
modelFile(
    '("/software/cadence/ncsu-FreePDK15/hspice_20nm_hp.include" "")
)
desVar(	  "C" 0f	)
desVar(	  "nfin" 12	)
run()
selectResult( 'tran )
plot(getData("/IVDDH/src") getData("/IVDDL/dst") getData("/VH") getData("/VL") getData("/Vline") getData("/ILine/src") )
LeakageIntoVDDL = average(clip(i("/IVDDL/dst" ?result "tran") tLeakageStart tLeakageEnd))
plot( LeakageIntoVDDL ?expr '( "LeakageIntoVDDL" ) )
LeakageLine = average(clip(i("/ILine/src" ?result "tran") tLeakageStart tLeakageEnd))
plot( LeakageLine ?expr '( "LeakageLine" ) )
LeakageVDDH = average(clip(i("/IVDDH/src" ?result "tran") tLeakageStart tLeakageEnd))
plot( LeakageVDDH ?expr '( "LeakageVDDH" ) )
QFall_pVDDL = ymax(iinteg(clip(i("/IVDDL/dst" ?result "tran") tFallSettleStart tFallSettleEnd)))
plot( QFall_pVDDL ?expr '( "QFall_pVDDL" ) )
QRise_pVDDH = ymax(iinteg(clip(i("/IVDDH/src" ?result "tran") tRiseSettleStart tRiseSettleEnd)))
plot( QRise_pVDDH ?expr '( "QRise_pVDDH" ) )
TFall = (tFallEnd - tFallStart)
plot( TFall ?expr '( "TFall" ) )
TPFall = (tTPFallEnd - tFallSettleStart)
plot( TPFall ?expr '( "TPFall" ) )
TPRise = (tTPRiseEnd - tRiseSettleStart)
plot( TPRise ?expr '( "TPRise" ) )
TRise = (tRiseEnd - tRiseStart)
plot( TRise ?expr '( "TRise" ) )
TSettleFall = (tFallSettleEnd - tFallSettleStart)
plot( TSettleFall ?expr '( "TSettleFall" ) )
TSettleRise = (tRiseSettleEnd - tRiseSettleStart)
plot( TSettleRise ?expr '( "TSettleRise" ) )
cVline = clip(v("/Vline" ?result "tran") clipStart VAR("timeStop"))
plot( cVline ?expr '( "cVline" ) )
clipStart = (1.25 * VAR("period"))
plot( clipStart ?expr '( "clipStart" ) )
tFallEnd = cross(cVline (VAR("VDDH") - (0.9 * vDiff)) 1 "falling")
plot( tFallEnd ?expr '( "tFallEnd" ) )
tFallSettleEnd = cross(cVline (1.05 * VAR("VDDL")) 1 "falling")
plot( tFallSettleEnd ?expr '( "tFallSettleEnd" ) )
tFallSettleStart = cross(clip(v("/VH" ?result "tran") clipStart VAR("timeStop")) (0.5 * VAR("VDDH")) 1 "rising")
plot( tFallSettleStart ?expr '( "tFallSettleStart" ) )
tFallStart = cross(cVline (VAR("VDDH") - (0.1 * vDiff)) 1 "falling")
plot( tFallStart ?expr '( "tFallStart" ) )
tLeakageEnd = (clipStart + (0.51 * VAR("period")))
plot( tLeakageEnd ?expr '( "tLeakageEnd" ) )
tLeakageStart = (clipStart + (0.49 * VAR("period")))
plot( tLeakageStart ?expr '( "tLeakageStart" ) )
tRiseEnd = cross(cVline (VAR("VDDL") + (0.9 * vDiff)) 1 "rising")
plot( tRiseEnd ?expr '( "tRiseEnd" ) )
tRiseSettleEnd = cross(cVline (0.95 * VAR("VDDH")) 1 "rising")
plot( tRiseSettleEnd ?expr '( "tRiseSettleEnd" ) )
tRiseSettleStart = cross(clip(v("/VH" ?result "tran") clipStart VAR("timeStop")) (0.5 * VAR("VDDH")) 1 "falling")
plot( tRiseSettleStart ?expr '( "tRiseSettleStart" ) )
tRiseStart = cross(cVline (VAR("VDDL") + (0.1 * vDiff)) 1 "rising")
plot( tRiseStart ?expr '( "tRiseStart" ) )
tTPFallEnd = cross(cVline (VAR("VDDH") - (0.5 * vDiff)) 1 "falling")
plot( tTPFallEnd ?expr '( "tTPFallEnd" ) )
tTPRiseEnd = cross(cVline (VAR("VDDL") + (0.5 * vDiff)) 1 "rising")
plot( tTPRiseEnd ?expr '( "tTPRiseEnd" ) )
vDiff = (VAR("VDDH") - VAR("VDDL"))
plot( vDiff ?expr '( "vDiff" ) )
modelFile(
    '("/software/cadence/ncsu-FreePDK15/hspice_20nm_hp.include" "")
)
run()
selectResult( 'tran )
plot(getData("/IVDDH/src") getData("/IVDDL/dst") getData("/VH") getData("/VL") getData("/Vline") getData("/ILine/src") )
LeakageIntoVDDL = average(clip(i("/IVDDL/dst" ?result "tran") tLeakageStart tLeakageEnd))
plot( LeakageIntoVDDL ?expr '( "LeakageIntoVDDL" ) )
LeakageLine = average(clip(i("/ILine/src" ?result "tran") tLeakageStart tLeakageEnd))
plot( LeakageLine ?expr '( "LeakageLine" ) )
LeakageVDDH = average(clip(i("/IVDDH/src" ?result "tran") tLeakageStart tLeakageEnd))
plot( LeakageVDDH ?expr '( "LeakageVDDH" ) )
QFall_pVDDL = ymax(iinteg(clip(i("/IVDDL/dst" ?result "tran") tFallSettleStart tFallSettleEnd)))
plot( QFall_pVDDL ?expr '( "QFall_pVDDL" ) )
QRise_pVDDH = ymax(iinteg(clip(i("/IVDDH/src" ?result "tran") tRiseSettleStart tRiseSettleEnd)))
plot( QRise_pVDDH ?expr '( "QRise_pVDDH" ) )
TFall = (tFallEnd - tFallStart)
plot( TFall ?expr '( "TFall" ) )
TPFall = (tTPFallEnd - tFallSettleStart)
plot( TPFall ?expr '( "TPFall" ) )
TPRise = (tTPRiseEnd - tRiseSettleStart)
plot( TPRise ?expr '( "TPRise" ) )
TRise = (tRiseEnd - tRiseStart)
plot( TRise ?expr '( "TRise" ) )
TSettleFall = (tFallSettleEnd - tFallSettleStart)
plot( TSettleFall ?expr '( "TSettleFall" ) )
TSettleRise = (tRiseSettleEnd - tRiseSettleStart)
plot( TSettleRise ?expr '( "TSettleRise" ) )
cVline = clip(v("/Vline" ?result "tran") clipStart VAR("timeStop"))
plot( cVline ?expr '( "cVline" ) )
clipStart = (1.25 * VAR("period"))
plot( clipStart ?expr '( "clipStart" ) )
tFallEnd = cross(cVline (VAR("VDDH") - (0.9 * vDiff)) 1 "falling")
plot( tFallEnd ?expr '( "tFallEnd" ) )
tFallSettleEnd = cross(cVline (1.05 * VAR("VDDL")) 1 "falling")
plot( tFallSettleEnd ?expr '( "tFallSettleEnd" ) )
tFallSettleStart = cross(clip(v("/VH" ?result "tran") clipStart VAR("timeStop")) (0.5 * VAR("VDDH")) 1 "rising")
plot( tFallSettleStart ?expr '( "tFallSettleStart" ) )
tFallStart = cross(cVline (VAR("VDDH") - (0.1 * vDiff)) 1 "falling")
plot( tFallStart ?expr '( "tFallStart" ) )
tLeakageEnd = (clipStart + (0.51 * VAR("period")))
plot( tLeakageEnd ?expr '( "tLeakageEnd" ) )
tLeakageStart = (clipStart + (0.49 * VAR("period")))
plot( tLeakageStart ?expr '( "tLeakageStart" ) )
tRiseEnd = cross(cVline (VAR("VDDL") + (0.9 * vDiff)) 1 "rising")
plot( tRiseEnd ?expr '( "tRiseEnd" ) )
tRiseSettleEnd = cross(cVline (0.95 * VAR("VDDH")) 1 "rising")
plot( tRiseSettleEnd ?expr '( "tRiseSettleEnd" ) )
tRiseSettleStart = cross(clip(v("/VH" ?result "tran") clipStart VAR("timeStop")) (0.5 * VAR("VDDH")) 1 "falling")
plot( tRiseSettleStart ?expr '( "tRiseSettleStart" ) )
tRiseStart = cross(cVline (VAR("VDDL") + (0.1 * vDiff)) 1 "rising")
plot( tRiseStart ?expr '( "tRiseStart" ) )
tTPFallEnd = cross(cVline (VAR("VDDH") - (0.5 * vDiff)) 1 "falling")
plot( tTPFallEnd ?expr '( "tTPFallEnd" ) )
tTPRiseEnd = cross(cVline (VAR("VDDL") + (0.5 * vDiff)) 1 "rising")
plot( tTPRiseEnd ?expr '( "tTPRiseEnd" ) )
vDiff = (VAR("VDDH") - VAR("VDDL"))
plot( vDiff ?expr '( "vDiff" ) )
hostMode( 'distributed )
resultsDir( "/net/kafka/nfs/rstdenis/Cadence/simulation/Dual_Supply_Word_Test/spectre/schematic/distributed/job005" )
modelFile(
    '("/software/cadence/ncsu-FreePDK15/hspice_20nm_hp.include" "")
)
desVar(	  "C" 100f	)
run( ?jobName "job" ?queue "c2107" )
selectResult( 'tran )
plot(getData("/IVDDH/src") getData("/IVDDL/dst") getData("/VH") getData("/VL") getData("/Vline") getData("/ILine/src") )
LeakageIntoVDDL = average(clip(i("/IVDDL/dst" ?result "tran") tLeakageStart tLeakageEnd))
plot( LeakageIntoVDDL ?expr '( "LeakageIntoVDDL" ) )
LeakageLine = average(clip(i("/ILine/src" ?result "tran") tLeakageStart tLeakageEnd))
plot( LeakageLine ?expr '( "LeakageLine" ) )
LeakageVDDH = average(clip(i("/IVDDH/src" ?result "tran") tLeakageStart tLeakageEnd))
plot( LeakageVDDH ?expr '( "LeakageVDDH" ) )
QFall_pVDDL = ymax(iinteg(clip((i("/IVDDL/dst" ?result "tran")**v("/vLine" ?result "tran")) tFallSettleStart tFallSettleEnd)))
plot( QFall_pVDDL ?expr '( "QFall_pVDDL" ) )
QRise_pVDDH = ymax(iinteg(clip((i("/IVDDH/src" ?result "tran")**i("/vLine" ?result "tran")) tRiseSettleStart tRiseSettleEnd)))
plot( QRise_pVDDH ?expr '( "QRise_pVDDH" ) )
TFall = (tFallEnd - tFallStart)
plot( TFall ?expr '( "TFall" ) )
TPFall = (tTPFallEnd - tFallSettleStart)
plot( TPFall ?expr '( "TPFall" ) )
TPRise = (tTPRiseEnd - tRiseSettleStart)
plot( TPRise ?expr '( "TPRise" ) )
TRise = (tRiseEnd - tRiseStart)
plot( TRise ?expr '( "TRise" ) )
TSettleFall = (tFallSettleEnd - tFallSettleStart)
plot( TSettleFall ?expr '( "TSettleFall" ) )
TSettleRise = (tRiseSettleEnd - tRiseSettleStart)
plot( TSettleRise ?expr '( "TSettleRise" ) )
cVline = clip(v("/Vline" ?result "tran") clipStart VAR("timeStop"))
plot( cVline ?expr '( "cVline" ) )
clipStart = (1.25 * VAR("period"))
plot( clipStart ?expr '( "clipStart" ) )
tFallEnd = cross(cVline (VAR("VDDH") - (0.9 * vDiff)) 1 "falling")
plot( tFallEnd ?expr '( "tFallEnd" ) )
tFallSettleEnd = cross(cVline (1.05 * VAR("VDDL")) 1 "falling")
plot( tFallSettleEnd ?expr '( "tFallSettleEnd" ) )
tFallSettleStart = cross(clip(v("/VH" ?result "tran") clipStart VAR("timeStop")) (0.5 * VAR("VDDH")) 1 "rising")
plot( tFallSettleStart ?expr '( "tFallSettleStart" ) )
tFallStart = cross(cVline (VAR("VDDH") - (0.1 * vDiff)) 1 "falling")
plot( tFallStart ?expr '( "tFallStart" ) )
tLeakageEnd = (clipStart + (0.51 * VAR("period")))
plot( tLeakageEnd ?expr '( "tLeakageEnd" ) )
tLeakageStart = (clipStart + (0.49 * VAR("period")))
plot( tLeakageStart ?expr '( "tLeakageStart" ) )
tRiseEnd = cross(cVline (VAR("VDDL") + (0.9 * vDiff)) 1 "rising")
plot( tRiseEnd ?expr '( "tRiseEnd" ) )
tRiseSettleEnd = cross(cVline (0.95 * VAR("VDDH")) 1 "rising")
plot( tRiseSettleEnd ?expr '( "tRiseSettleEnd" ) )
tRiseSettleStart = cross(clip(v("/VH" ?result "tran") clipStart VAR("timeStop")) (0.5 * VAR("VDDH")) 1 "falling")
plot( tRiseSettleStart ?expr '( "tRiseSettleStart" ) )
tRiseStart = cross(cVline (VAR("VDDL") + (0.1 * vDiff)) 1 "rising")
plot( tRiseStart ?expr '( "tRiseStart" ) )
tTPFallEnd = cross(cVline (VAR("VDDH") - (0.5 * vDiff)) 1 "falling")
plot( tTPFallEnd ?expr '( "tTPFallEnd" ) )
tTPRiseEnd = cross(cVline (VAR("VDDL") + (0.5 * vDiff)) 1 "rising")
plot( tTPRiseEnd ?expr '( "tTPRiseEnd" ) )
vDiff = (VAR("VDDH") - VAR("VDDL"))
plot( vDiff ?expr '( "vDiff" ) )
resultsDir( "/net/kafka/nfs/rstdenis/Cadence/simulation/Dual_Supply_Word_Test/spectre/schematic/distributed/job006" )
modelFile(
    '("/software/cadence/ncsu-FreePDK15/hspice_20nm_hp.include" "")
)
run( ?jobName "job" ?queue "c2107" )
selectResult( 'tran )
plot(getData("/IVDDH/src") getData("/IVDDL/dst") getData("/VH") getData("/VL") getData("/Vline") getData("/ILine/src") )
QFall_pVDDL = ymax(iinteg(clip((i("/IVDDL/dst" ?result "tran") * v("/Vline" ?result "tran")) tFallSettleStart tFallSettleEnd)))
plot( QFall_pVDDL ?expr '( "QFall_pVDDL" ) )
QRise_pVDDH = ymax(iinteg(clip((i("/IVDDH/src" ?result "tran") * v("/Vline" ?result "tran")) tRiseSettleStart tRiseSettleEnd)))
plot( QRise_pVDDH ?expr '( "QRise_pVDDH" ) )
vDiff = (VAR("VDDH") - VAR("VDDL"))
plot( vDiff ?expr '( "vDiff" ) )
LeakageLine = average(clip(i("/ILine/src" ?result "tran") tLeakageStart tLeakageEnd))
plot( LeakageLine ?expr '( "LeakageLine" ) )
tRiseEnd = cross(cVline (VAR("VDDL") + (0.9 * vDiff)) 1 "rising")
plot( tRiseEnd ?expr '( "tRiseEnd" ) )
tRiseSettleEnd = cross(cVline (0.95 * VAR("VDDH")) 1 "rising")
plot( tRiseSettleEnd ?expr '( "tRiseSettleEnd" ) )
tTPRiseEnd = cross(cVline (VAR("VDDL") + (0.5 * vDiff)) 1 "rising")
plot( tTPRiseEnd ?expr '( "tTPRiseEnd" ) )
tRiseStart = cross(cVline (VAR("VDDL") + (0.1 * vDiff)) 1 "rising")
plot( tRiseStart ?expr '( "tRiseStart" ) )
tRiseSettleStart = cross(clip(v("/VH" ?result "tran") clipStart VAR("timeStop")) (0.5 * VAR("VDDH")) 1 "falling")
plot( tRiseSettleStart ?expr '( "tRiseSettleStart" ) )
tLeakageEnd = (clipStart + (0.51 * VAR("period")))
plot( tLeakageEnd ?expr '( "tLeakageEnd" ) )
tLeakageStart = (clipStart + (0.49 * VAR("period")))
plot( tLeakageStart ?expr '( "tLeakageStart" ) )
LeakageVDDH = average(clip(i("/IVDDH/src" ?result "tran") tLeakageStart tLeakageEnd))
plot( LeakageVDDH ?expr '( "LeakageVDDH" ) )
tFallEnd = cross(cVline (VAR("VDDH") - (0.9 * vDiff)) 1 "falling")
plot( tFallEnd ?expr '( "tFallEnd" ) )
tFallSettleEnd = cross(cVline (1.05 * VAR("VDDL")) 1 "falling")
plot( tFallSettleEnd ?expr '( "tFallSettleEnd" ) )
tTPFallEnd = cross(cVline (VAR("VDDH") - (0.5 * vDiff)) 1 "falling")
plot( tTPFallEnd ?expr '( "tTPFallEnd" ) )
tFallSettleStart = cross(clip(v("/VH" ?result "tran") clipStart VAR("timeStop")) (0.5 * VAR("VDDH")) 1 "rising")
plot( tFallSettleStart ?expr '( "tFallSettleStart" ) )
tFallStart = cross(cVline (VAR("VDDH") - (0.1 * vDiff)) 1 "falling")
plot( tFallStart ?expr '( "tFallStart" ) )
clipStart = (1.25 * VAR("period"))
plot( clipStart ?expr '( "clipStart" ) )
TFall = (tFallEnd - tFallStart)
plot( TFall ?expr '( "TFall" ) )
TRise = (tRiseEnd - tRiseStart)
plot( TRise ?expr '( "TRise" ) )
TSettleFall = (tFallSettleEnd - tFallSettleStart)
plot( TSettleFall ?expr '( "TSettleFall" ) )
TSettleRise = (tRiseSettleEnd - tRiseSettleStart)
plot( TSettleRise ?expr '( "TSettleRise" ) )
TPRise = (tTPRiseEnd - tRiseSettleStart)
plot( TPRise ?expr '( "TPRise" ) )
TPFall = (tTPFallEnd - tFallSettleStart)
plot( TPFall ?expr '( "TPFall" ) )
LeakageIntoVDDL = average(clip(i("/IVDDL/dst" ?result "tran") tLeakageStart tLeakageEnd))
plot( LeakageIntoVDDL ?expr '( "LeakageIntoVDDL" ) )
cVline = clip(v("/Vline" ?result "tran") clipStart VAR("timeStop"))
plot( cVline ?expr '( "cVline" ) )
resultsDir( "/net/kafka/nfs/rstdenis/Cadence/simulation/Dual_Supply_Word_Test/spectre/schematic/distributed/job007" )
modelFile(
    '("/software/cadence/ncsu-FreePDK15/hspice_20nm_hp.include" "")
)
desVar(	  "C" 20f	)
run( ?jobName "job" ?queue "c2107" )
selectResult( 'tran )
plot(getData("/IVDDH/src") getData("/IVDDL/dst") getData("/VH") getData("/VL") getData("/Vline") getData("/ILine/src") )
QFall_pVDDL = integ((i("/IVDDL/dst" ?result "tran") * v("/Vline" ?result "tran")) tFallSettleStart tFallSettleEnd)
plot( QFall_pVDDL ?expr '( "QFall_pVDDL" ) )
QRise_pVDDH = integ((i("/IVDDH/src" ?result "tran") * v("/Vline" ?result "tran")) tRiseSettleStart tRiseSettleEnd)
plot( QRise_pVDDH ?expr '( "QRise_pVDDH" ) )
vDiff = (VAR("VDDH") - VAR("VDDL"))
plot( vDiff ?expr '( "vDiff" ) )
LeakageLine = average(clip(i("/ILine/src" ?result "tran") tLeakageStart tLeakageEnd))
plot( LeakageLine ?expr '( "LeakageLine" ) )
tRiseEnd = cross(cVline (VAR("VDDL") + (0.9 * vDiff)) 1 "rising")
plot( tRiseEnd ?expr '( "tRiseEnd" ) )
tRiseSettleEnd = cross(cVline (0.95 * VAR("VDDH")) 1 "rising")
plot( tRiseSettleEnd ?expr '( "tRiseSettleEnd" ) )
tTPRiseEnd = cross(cVline (VAR("VDDL") + (0.5 * vDiff)) 1 "rising")
plot( tTPRiseEnd ?expr '( "tTPRiseEnd" ) )
tRiseStart = cross(cVline (VAR("VDDL") + (0.1 * vDiff)) 1 "rising")
plot( tRiseStart ?expr '( "tRiseStart" ) )
tRiseSettleStart = cross(clip(v("/VH" ?result "tran") clipStart VAR("timeStop")) (0.5 * VAR("VDDH")) 1 "falling")
plot( tRiseSettleStart ?expr '( "tRiseSettleStart" ) )
tLeakageEnd = (clipStart + (0.51 * VAR("period")))
plot( tLeakageEnd ?expr '( "tLeakageEnd" ) )
tLeakageStart = (clipStart + (0.49 * VAR("period")))
plot( tLeakageStart ?expr '( "tLeakageStart" ) )
LeakageVDDH = average(clip(i("/IVDDH/src" ?result "tran") tLeakageStart tLeakageEnd))
plot( LeakageVDDH ?expr '( "LeakageVDDH" ) )
tFallEnd = cross(cVline (VAR("VDDH") - (0.9 * vDiff)) 1 "falling")
plot( tFallEnd ?expr '( "tFallEnd" ) )
tFallSettleEnd = cross(cVline (1.05 * VAR("VDDL")) 1 "falling")
plot( tFallSettleEnd ?expr '( "tFallSettleEnd" ) )
tTPFallEnd = cross(cVline (VAR("VDDH") - (0.5 * vDiff)) 1 "falling")
plot( tTPFallEnd ?expr '( "tTPFallEnd" ) )
tFallSettleStart = cross(clip(v("/VH" ?result "tran") clipStart VAR("timeStop")) (0.5 * VAR("VDDH")) 1 "rising")
plot( tFallSettleStart ?expr '( "tFallSettleStart" ) )
tFallStart = cross(cVline (VAR("VDDH") - (0.1 * vDiff)) 1 "falling")
plot( tFallStart ?expr '( "tFallStart" ) )
clipStart = (1.25 * VAR("period"))
plot( clipStart ?expr '( "clipStart" ) )
TFall = (tFallEnd - tFallStart)
plot( TFall ?expr '( "TFall" ) )
TRise = (tRiseEnd - tRiseStart)
plot( TRise ?expr '( "TRise" ) )
TSettleFall = (tFallSettleEnd - tFallSettleStart)
plot( TSettleFall ?expr '( "TSettleFall" ) )
TSettleRise = (tRiseSettleEnd - tRiseSettleStart)
plot( TSettleRise ?expr '( "TSettleRise" ) )
TPRise = (tTPRiseEnd - tRiseSettleStart)
plot( TPRise ?expr '( "TPRise" ) )
TPFall = (tTPFallEnd - tFallSettleStart)
plot( TPFall ?expr '( "TPFall" ) )
LeakageIntoVDDL = average(clip(i("/IVDDL/dst" ?result "tran") tLeakageStart tLeakageEnd))
plot( LeakageIntoVDDL ?expr '( "LeakageIntoVDDL" ) )
cVline = clip(v("/Vline" ?result "tran") clipStart VAR("timeStop"))
plot( cVline ?expr '( "cVline" ) )
resultsDir( "/net/kafka/nfs/rstdenis/Cadence/simulation/Dual_Supply_Word_Test/spectre/schematic/distributed/job008" )
modelFile(
    '("/software/cadence/ncsu-FreePDK15/hspice_20nm_hp.include" "")
)
desVar(	  "nfin" 64	)
run( ?jobName "job" ?queue "c2107" )
selectResult( 'tran )
plot(getData("/IVDDH/src") getData("/IVDDL/dst") getData("/VH") getData("/VL") getData("/Vline") getData("/ILine/src") )
QFall_pVDDL = integ((i("/IVDDL/dst" ?result "tran") * v("/Vline" ?result "tran")) tFallSettleStart tFallSettleEnd)
plot( QFall_pVDDL ?expr '( "QFall_pVDDL" ) )
QRise_pVDDH = integ((i("/IVDDH/src" ?result "tran") * v("/Vline" ?result "tran")) tRiseSettleStart tRiseSettleEnd)
plot( QRise_pVDDH ?expr '( "QRise_pVDDH" ) )
vDiff = (VAR("VDDH") - VAR("VDDL"))
plot( vDiff ?expr '( "vDiff" ) )
LeakageLine = average(clip(i("/ILine/src" ?result "tran") tLeakageStart tLeakageEnd))
plot( LeakageLine ?expr '( "LeakageLine" ) )
tRiseEnd = cross(cVline (VAR("VDDL") + (0.9 * vDiff)) 1 "rising")
plot( tRiseEnd ?expr '( "tRiseEnd" ) )
tRiseSettleEnd = cross(cVline (0.95 * VAR("VDDH")) 1 "rising")
plot( tRiseSettleEnd ?expr '( "tRiseSettleEnd" ) )
tTPRiseEnd = cross(cVline (VAR("VDDL") + (0.5 * vDiff)) 1 "rising")
plot( tTPRiseEnd ?expr '( "tTPRiseEnd" ) )
tRiseStart = cross(cVline (VAR("VDDL") + (0.1 * vDiff)) 1 "rising")
plot( tRiseStart ?expr '( "tRiseStart" ) )
tRiseSettleStart = cross(clip(v("/VH" ?result "tran") clipStart VAR("timeStop")) (0.5 * VAR("VDDH")) 1 "falling")
plot( tRiseSettleStart ?expr '( "tRiseSettleStart" ) )
tLeakageEnd = (clipStart + (0.51 * VAR("period")))
plot( tLeakageEnd ?expr '( "tLeakageEnd" ) )
tLeakageStart = (clipStart + (0.49 * VAR("period")))
plot( tLeakageStart ?expr '( "tLeakageStart" ) )
LeakageVDDH = average(clip(i("/IVDDH/src" ?result "tran") tLeakageStart tLeakageEnd))
plot( LeakageVDDH ?expr '( "LeakageVDDH" ) )
tFallEnd = cross(cVline (VAR("VDDH") - (0.9 * vDiff)) 1 "falling")
plot( tFallEnd ?expr '( "tFallEnd" ) )
tFallSettleEnd = cross(cVline (1.05 * VAR("VDDL")) 1 "falling")
plot( tFallSettleEnd ?expr '( "tFallSettleEnd" ) )
tTPFallEnd = cross(cVline (VAR("VDDH") - (0.5 * vDiff)) 1 "falling")
plot( tTPFallEnd ?expr '( "tTPFallEnd" ) )
tFallSettleStart = cross(clip(v("/VH" ?result "tran") clipStart VAR("timeStop")) (0.5 * VAR("VDDH")) 1 "rising")
plot( tFallSettleStart ?expr '( "tFallSettleStart" ) )
tFallStart = cross(cVline (VAR("VDDH") - (0.1 * vDiff)) 1 "falling")
plot( tFallStart ?expr '( "tFallStart" ) )
clipStart = (1.25 * VAR("period"))
plot( clipStart ?expr '( "clipStart" ) )
TFall = (tFallEnd - tFallStart)
plot( TFall ?expr '( "TFall" ) )
TRise = (tRiseEnd - tRiseStart)
plot( TRise ?expr '( "TRise" ) )
TSettleFall = (tFallSettleEnd - tFallSettleStart)
plot( TSettleFall ?expr '( "TSettleFall" ) )
TSettleRise = (tRiseSettleEnd - tRiseSettleStart)
plot( TSettleRise ?expr '( "TSettleRise" ) )
TPRise = (tTPRiseEnd - tRiseSettleStart)
plot( TPRise ?expr '( "TPRise" ) )
TPFall = (tTPFallEnd - tFallSettleStart)
plot( TPFall ?expr '( "TPFall" ) )
LeakageIntoVDDL = average(clip(i("/IVDDL/dst" ?result "tran") tLeakageStart tLeakageEnd))
plot( LeakageIntoVDDL ?expr '( "LeakageIntoVDDL" ) )
cVline = clip(v("/Vline" ?result "tran") clipStart VAR("timeStop"))
plot( cVline ?expr '( "cVline" ) )
hostMode( 'local )
resultsDir( "/net/kafka/nfs/rstdenis/Cadence/simulation/Dual_Supply_Word_Test/spectre/schematic" )
modelFile(
    '("/software/cadence/ncsu-FreePDK15/hspice_20nm_hp.include" "")
)
run()
selectResult( 'tran )
plot(getData("/IVDDH/src") getData("/IVDDL/dst") getData("/VH") getData("/VL") getData("/Vline") getData("/ILine/src") )
QFall_pVDDL = integ((i("/IVDDL/dst" ?result "tran") * v("/Vline" ?result "tran")) tFallSettleStart tFallSettleEnd)
plot( QFall_pVDDL ?expr '( "QFall_pVDDL" ) )
QRise_pVDDH = integ((i("/IVDDH/src" ?result "tran") * v("/Vline" ?result "tran")) tRiseSettleStart tRiseSettleEnd)
plot( QRise_pVDDH ?expr '( "QRise_pVDDH" ) )
vDiff = (VAR("VDDH") - VAR("VDDL"))
plot( vDiff ?expr '( "vDiff" ) )
LeakageLine = average(clip(i("/ILine/src" ?result "tran") tLeakageStart tLeakageEnd))
plot( LeakageLine ?expr '( "LeakageLine" ) )
tRiseEnd = cross(cVline (VAR("VDDL") + (0.9 * vDiff)) 1 "rising")
plot( tRiseEnd ?expr '( "tRiseEnd" ) )
tRiseSettleEnd = cross(cVline (0.95 * VAR("VDDH")) 1 "rising")
plot( tRiseSettleEnd ?expr '( "tRiseSettleEnd" ) )
tTPRiseEnd = cross(cVline (VAR("VDDL") + (0.5 * vDiff)) 1 "rising")
plot( tTPRiseEnd ?expr '( "tTPRiseEnd" ) )
tRiseStart = cross(cVline (VAR("VDDL") + (0.1 * vDiff)) 1 "rising")
plot( tRiseStart ?expr '( "tRiseStart" ) )
tRiseSettleStart = cross(clip(v("/VH" ?result "tran") clipStart VAR("timeStop")) (0.5 * VAR("VDDH")) 1 "falling")
plot( tRiseSettleStart ?expr '( "tRiseSettleStart" ) )
tLeakageEnd = (clipStart + (0.51 * VAR("period")))
plot( tLeakageEnd ?expr '( "tLeakageEnd" ) )
tLeakageStart = (clipStart + (0.49 * VAR("period")))
plot( tLeakageStart ?expr '( "tLeakageStart" ) )
LeakageVDDH = average(clip(i("/IVDDH/src" ?result "tran") tLeakageStart tLeakageEnd))
plot( LeakageVDDH ?expr '( "LeakageVDDH" ) )
tFallEnd = cross(cVline (VAR("VDDH") - (0.9 * vDiff)) 1 "falling")
plot( tFallEnd ?expr '( "tFallEnd" ) )
tFallSettleEnd = cross(cVline (1.05 * VAR("VDDL")) 1 "falling")
plot( tFallSettleEnd ?expr '( "tFallSettleEnd" ) )
tTPFallEnd = cross(cVline (VAR("VDDH") - (0.5 * vDiff)) 1 "falling")
plot( tTPFallEnd ?expr '( "tTPFallEnd" ) )
tFallSettleStart = cross(clip(v("/VH" ?result "tran") clipStart VAR("timeStop")) (0.5 * VAR("VDDH")) 1 "rising")
plot( tFallSettleStart ?expr '( "tFallSettleStart" ) )
tFallStart = cross(cVline (VAR("VDDH") - (0.1 * vDiff)) 1 "falling")
plot( tFallStart ?expr '( "tFallStart" ) )
clipStart = (1.25 * VAR("period"))
plot( clipStart ?expr '( "clipStart" ) )
TFall = (tFallEnd - tFallStart)
plot( TFall ?expr '( "TFall" ) )
TRise = (tRiseEnd - tRiseStart)
plot( TRise ?expr '( "TRise" ) )
TSettleFall = (tFallSettleEnd - tFallSettleStart)
plot( TSettleFall ?expr '( "TSettleFall" ) )
TSettleRise = (tRiseSettleEnd - tRiseSettleStart)
plot( TSettleRise ?expr '( "TSettleRise" ) )
TPRise = (tTPRiseEnd - tRiseSettleStart)
plot( TPRise ?expr '( "TPRise" ) )
TPFall = (tTPFallEnd - tFallSettleStart)
plot( TPFall ?expr '( "TPFall" ) )
LeakageIntoVDDL = average(clip(i("/IVDDL/dst" ?result "tran") tLeakageStart tLeakageEnd))
plot( LeakageIntoVDDL ?expr '( "LeakageIntoVDDL" ) )
cVline = clip(v("/Vline" ?result "tran") clipStart VAR("timeStop"))
plot( cVline ?expr '( "cVline" ) )
cVH = clip(v("/VH" ?result "tran") clipStart VAR("timeStop"))
plot( cVH ?expr '( "cVH" ) )
cVL = clip(v("/VL" ?result "tran") clipStart VAR("timeStop"))
plot( cVL ?expr '( "cVL" ) )
modelFile(
    '("/software/cadence/ncsu-FreePDK15/hspice_20nm_hp.include" "")
)
run()
selectResult( 'tran )
plot(getData("/IVDDH/src") getData("/IVDDL/dst") getData("/VH") getData("/VL") getData("/Vline") getData("/ILine/src") )
QFall_pVDDL = integ((i("/IVDDL/dst" ?result "tran") * v("/Vline" ?result "tran")) tFallSettleStart tFallSettleEnd)
plot( QFall_pVDDL ?expr '( "QFall_pVDDL" ) )
QRise_pVDDH = integ((i("/IVDDH/src" ?result "tran") * v("/Vline" ?result "tran")) tRiseSettleStart tRiseSettleEnd)
plot( QRise_pVDDH ?expr '( "QRise_pVDDH" ) )
vDiff = (VAR("VDDH") - VAR("VDDL"))
plot( vDiff ?expr '( "vDiff" ) )
LeakageLine = average(clip(i("/ILine/src" ?result "tran") tLeakageStart tLeakageEnd))
plot( LeakageLine ?expr '( "LeakageLine" ) )
tRiseEnd = cross(cVline (VAR("VDDL") + (0.9 * vDiff)) 1 "rising")
plot( tRiseEnd ?expr '( "tRiseEnd" ) )
tRiseSettleEnd = cross(cVline (0.95 * VAR("VDDH")) 1 "rising")
plot( tRiseSettleEnd ?expr '( "tRiseSettleEnd" ) )
tTPRiseEnd = cross(cVline (VAR("VDDL") + (0.5 * vDiff)) 1 "rising")
plot( tTPRiseEnd ?expr '( "tTPRiseEnd" ) )
tRiseStart = cross(cVline (VAR("VDDL") + (0.1 * vDiff)) 1 "rising")
plot( tRiseStart ?expr '( "tRiseStart" ) )
tRiseSettleStart = cross(clip(v("/VH" ?result "tran") clipStart VAR("timeStop")) (0.5 * VAR("VDDH")) 1 "falling")
plot( tRiseSettleStart ?expr '( "tRiseSettleStart" ) )
tLeakageEnd = (clipStart + (0.51 * VAR("period")))
plot( tLeakageEnd ?expr '( "tLeakageEnd" ) )
tLeakageStart = (clipStart + (0.49 * VAR("period")))
plot( tLeakageStart ?expr '( "tLeakageStart" ) )
LeakageVDDH = average(clip(i("/IVDDH/src" ?result "tran") tLeakageStart tLeakageEnd))
plot( LeakageVDDH ?expr '( "LeakageVDDH" ) )
tFallEnd = cross(cVline (VAR("VDDH") - (0.9 * vDiff)) 1 "falling")
plot( tFallEnd ?expr '( "tFallEnd" ) )
tFallSettleEnd = cross(cVline (1.05 * VAR("VDDL")) 1 "falling")
plot( tFallSettleEnd ?expr '( "tFallSettleEnd" ) )
tTPFallEnd = cross(cVline (VAR("VDDH") - (0.5 * vDiff)) 1 "falling")
plot( tTPFallEnd ?expr '( "tTPFallEnd" ) )
tFallSettleStart = cross(clip(v("/VH" ?result "tran") clipStart VAR("timeStop")) (0.5 * VAR("VDDH")) 1 "rising")
plot( tFallSettleStart ?expr '( "tFallSettleStart" ) )
tFallStart = cross(cVline (VAR("VDDH") - (0.1 * vDiff)) 1 "falling")
plot( tFallStart ?expr '( "tFallStart" ) )
clipStart = ((1.25 * VAR("period")) + VAR("startDelay"))
plot( clipStart ?expr '( "clipStart" ) )
TFall = (tFallEnd - tFallStart)
plot( TFall ?expr '( "TFall" ) )
TRise = (tRiseEnd - tRiseStart)
plot( TRise ?expr '( "TRise" ) )
TSettleFall = (tFallSettleEnd - tFallSettleStart)
plot( TSettleFall ?expr '( "TSettleFall" ) )
TSettleRise = (tRiseSettleEnd - tRiseSettleStart)
plot( TSettleRise ?expr '( "TSettleRise" ) )
TPRise = (tTPRiseEnd - tRiseSettleStart)
plot( TPRise ?expr '( "TPRise" ) )
TPFall = (tTPFallEnd - tFallSettleStart)
plot( TPFall ?expr '( "TPFall" ) )
LeakageIntoVDDL = average(clip(i("/IVDDL/dst" ?result "tran") tLeakageStart tLeakageEnd))
plot( LeakageIntoVDDL ?expr '( "LeakageIntoVDDL" ) )
cVline = clip(v("/Vline" ?result "tran") clipStart VAR("timeStop"))
plot( cVline ?expr '( "cVline" ) )
cVH = clip(v("/VH" ?result "tran") clipStart VAR("timeStop"))
plot( cVH ?expr '( "cVH" ) )
cVL = clip(v("/VL" ?result "tran") clipStart VAR("timeStop"))
plot( cVL ?expr '( "cVL" ) )
modelFile(
    '("/software/cadence/ncsu-FreePDK15/hspice_20nm_hp.include" "")
)
run()
selectResult( 'tran )
plot(getData("/IVDDH/src") getData("/IVDDL/dst") getData("/VH") getData("/VL") getData("/Vline") getData("/ILine/src") )
QFall_pVDDL = integ((i("/IVDDL/dst" ?result "tran") * v("/Vline" ?result "tran")) tFallSettleStart tFallSettleEnd)
plot( QFall_pVDDL ?expr '( "QFall_pVDDL" ) )
QRise_pVDDH = integ((i("/IVDDH/src" ?result "tran") * v("/Vline" ?result "tran")) tRiseSettleStart tRiseSettleEnd)
plot( QRise_pVDDH ?expr '( "QRise_pVDDH" ) )
vDiff = (VAR("VDDH") - VAR("VDDL"))
plot( vDiff ?expr '( "vDiff" ) )
LeakageLine = average(clip(i("/ILine/src" ?result "tran") tLeakageStart tLeakageEnd))
plot( LeakageLine ?expr '( "LeakageLine" ) )
tRiseEnd = cross(cVline (VAR("VDDL") + (0.9 * vDiff)) 1 "rising")
plot( tRiseEnd ?expr '( "tRiseEnd" ) )
tRiseSettleEnd = cross(cVline (0.95 * VAR("VDDH")) 1 "rising")
plot( tRiseSettleEnd ?expr '( "tRiseSettleEnd" ) )
tTPRiseEnd = cross(cVline (VAR("VDDL") + (0.5 * vDiff)) 1 "rising")
plot( tTPRiseEnd ?expr '( "tTPRiseEnd" ) )
tRiseStart = cross(cVline (VAR("VDDL") + (0.1 * vDiff)) 1 "rising")
plot( tRiseStart ?expr '( "tRiseStart" ) )
tRiseSettleStart = xmax(intersect(cVH cVL))
plot( tRiseSettleStart ?expr '( "tRiseSettleStart" ) )
tLeakageEnd = (clipStart + (0.51 * VAR("period")))
plot( tLeakageEnd ?expr '( "tLeakageEnd" ) )
tLeakageStart = (clipStart + (0.49 * VAR("period")))
plot( tLeakageStart ?expr '( "tLeakageStart" ) )
LeakageVDDH = average(clip(i("/IVDDH/src" ?result "tran") tLeakageStart tLeakageEnd))
plot( LeakageVDDH ?expr '( "LeakageVDDH" ) )
tFallEnd = cross(cVline (VAR("VDDH") - (0.9 * vDiff)) 1 "falling")
plot( tFallEnd ?expr '( "tFallEnd" ) )
tFallSettleEnd = cross(cVline (1.05 * VAR("VDDL")) 1 "falling")
plot( tFallSettleEnd ?expr '( "tFallSettleEnd" ) )
tTPFallEnd = cross(cVline (VAR("VDDH") - (0.5 * vDiff)) 1 "falling")
plot( tTPFallEnd ?expr '( "tTPFallEnd" ) )
tFallSettleStart = xmin(intersect(cVH cVL))
plot( tFallSettleStart ?expr '( "tFallSettleStart" ) )
tFallStart = cross(cVline (VAR("VDDH") - (0.1 * vDiff)) 1 "falling")
plot( tFallStart ?expr '( "tFallStart" ) )
clipStart = ((1.25 * VAR("period")) + VAR("startDelay"))
plot( clipStart ?expr '( "clipStart" ) )
TFall = (tFallEnd - tFallStart)
plot( TFall ?expr '( "TFall" ) )
TRise = (tRiseEnd - tRiseStart)
plot( TRise ?expr '( "TRise" ) )
TSettleFall = (tFallSettleEnd - tFallSettleStart)
plot( TSettleFall ?expr '( "TSettleFall" ) )
TSettleRise = (tRiseSettleEnd - tRiseSettleStart)
plot( TSettleRise ?expr '( "TSettleRise" ) )
TPRise = (tTPRiseEnd - tRiseSettleStart)
plot( TPRise ?expr '( "TPRise" ) )
TPFall = (tTPFallEnd - tFallSettleStart)
plot( TPFall ?expr '( "TPFall" ) )
LeakageIntoVDDL = average(clip(i("/IVDDL/dst" ?result "tran") tLeakageStart tLeakageEnd))
plot( LeakageIntoVDDL ?expr '( "LeakageIntoVDDL" ) )
cVline = clip(v("/Vline" ?result "tran") clipStart VAR("timeStop"))
plot( cVline ?expr '( "cVline" ) )
cVH = clip(v("/VH" ?result "tran") clipStart VAR("timeStop"))
plot( cVH ?expr '( "cVH" ) )
cVL = clip(v("/VL" ?result "tran") clipStart VAR("timeStop"))
plot( cVL ?expr '( "cVL" ) )
modelFile(
    '("/software/cadence/ncsu-FreePDK15/hspice_20nm_hp.include" "")
)
run()
selectResult( 'tran )
plot(getData("/ILine/src") getData("/IVDDH/src") getData("/IVDDL/dst") getData("/VH") getData("/VL") getData("/Vline") )
LeakageIntoVDDL = average(clip(i("/IVDDL/dst" ?result "tran") tLeakageStart tLeakageEnd))
plot( LeakageIntoVDDL ?expr '( "LeakageIntoVDDL" ) )
LeakageLine = average(clip(i("/ILine/src" ?result "tran") tLeakageStart tLeakageEnd))
plot( LeakageLine ?expr '( "LeakageLine" ) )
LeakageVDDH = average(clip(i("/IVDDH/src" ?result "tran") tLeakageStart tLeakageEnd))
plot( LeakageVDDH ?expr '( "LeakageVDDH" ) )
QFall_pVDDL = integ((i("/IVDDL/dst" ?result "tran") * v("/Vline" ?result "tran")) tFallSettleStart tFallSettleEnd)
plot( QFall_pVDDL ?expr '( "QFall_pVDDL" ) )
QRise_pVDDH = integ((i("/IVDDH/src" ?result "tran") * v("/Vline" ?result "tran")) tRiseSettleStart tRiseSettleEnd)
plot( QRise_pVDDH ?expr '( "QRise_pVDDH" ) )
TFall = (tFallEnd - tFallStart)
plot( TFall ?expr '( "TFall" ) )
TPFall = (tTPFallEnd - tFallSettleStart)
plot( TPFall ?expr '( "TPFall" ) )
TPRise = (tTPRiseEnd - tRiseSettleStart)
plot( TPRise ?expr '( "TPRise" ) )
TRise = (tRiseEnd - tRiseStart)
plot( TRise ?expr '( "TRise" ) )
TSettleFall = (tFallSettleEnd - tFallSettleStart)
plot( TSettleFall ?expr '( "TSettleFall" ) )
TSettleRise = (tRiseSettleEnd - tRiseSettleStart)
plot( TSettleRise ?expr '( "TSettleRise" ) )
cVH = clip(v("/VH" ?result "tran") clipStart VAR("timeStop"))
plot( cVH ?expr '( "cVH" ) )
cVL = clip(v("/VL" ?result "tran") clipStart VAR("timeStop"))
plot( cVL ?expr '( "cVL" ) )
cVline = clip(v("/Vline" ?result "tran") clipStart VAR("timeStop"))
plot( cVline ?expr '( "cVline" ) )
clipStart = ((0.75 * VAR("period")) + VAR("startDelay"))
plot( clipStart ?expr '( "clipStart" ) )
tFallEnd = cross(cVline (VAR("VDDH") - (0.9 * vDiff)) 1 "falling")
plot( tFallEnd ?expr '( "tFallEnd" ) )
tFallSettleEnd = cross(cVline (1.05 * VAR("VDDL")) 1 "falling")
plot( tFallSettleEnd ?expr '( "tFallSettleEnd" ) )
tFallSettleStart = xmin(intersect(cVH cVL))
plot( tFallSettleStart ?expr '( "tFallSettleStart" ) )
tFallStart = cross(cVline (VAR("VDDH") - (0.1 * vDiff)) 1 "falling")
plot( tFallStart ?expr '( "tFallStart" ) )
tLeakageEnd = (clipStart + (0.51 * VAR("period")))
plot( tLeakageEnd ?expr '( "tLeakageEnd" ) )
tLeakageStart = (clipStart + (0.49 * VAR("period")))
plot( tLeakageStart ?expr '( "tLeakageStart" ) )
tRiseEnd = cross(cVline (VAR("VDDL") + (0.9 * vDiff)) 1 "rising")
plot( tRiseEnd ?expr '( "tRiseEnd" ) )
tRiseSettleEnd = cross(cVline (0.95 * VAR("VDDH")) 1 "rising")
plot( tRiseSettleEnd ?expr '( "tRiseSettleEnd" ) )
tRiseSettleStart = xmax(intersect(cVH cVL))
plot( tRiseSettleStart ?expr '( "tRiseSettleStart" ) )
tRiseStart = cross(cVline (VAR("VDDL") + (0.1 * vDiff)) 1 "rising")
plot( tRiseStart ?expr '( "tRiseStart" ) )
tTPFallEnd = cross(cVline (VAR("VDDH") - (0.5 * vDiff)) 1 "falling")
plot( tTPFallEnd ?expr '( "tTPFallEnd" ) )
tTPRiseEnd = cross(cVline (VAR("VDDL") + (0.5 * vDiff)) 1 "rising")
plot( tTPRiseEnd ?expr '( "tTPRiseEnd" ) )
vDiff = (VAR("VDDH") - VAR("VDDL"))
plot( vDiff ?expr '( "vDiff" ) )
modelFile(
    '("/software/cadence/ncsu-FreePDK15/hspice_20nm_hp.include" "")
)
run()
selectResult( 'tran )
plot(getData("/ILine/src") getData("/IVDDH/src") getData("/IVDDL/dst") getData("/VH") getData("/VL") getData("/Vline") )
LeakageIntoVDDL = average(clip(i("/IVDDL/dst" ?result "tran") tLeakageStart tLeakageEnd))
plot( LeakageIntoVDDL ?expr '( "LeakageIntoVDDL" ) )
LeakageLine = average(clip(i("/ILine/src" ?result "tran") tLeakageStart tLeakageEnd))
plot( LeakageLine ?expr '( "LeakageLine" ) )
LeakageVDDH = average(clip(i("/IVDDH/src" ?result "tran") tLeakageStart tLeakageEnd))
plot( LeakageVDDH ?expr '( "LeakageVDDH" ) )
QFall_pVDDL = integ((i("/IVDDL/dst" ?result "tran") * v("/Vline" ?result "tran")) tFallSettleStart tFallSettleEnd)
plot( QFall_pVDDL ?expr '( "QFall_pVDDL" ) )
QRise_pVDDH = integ((i("/IVDDH/src" ?result "tran") * v("/Vline" ?result "tran")) tRiseSettleStart tRiseSettleEnd)
plot( QRise_pVDDH ?expr '( "QRise_pVDDH" ) )
TFall = (tFallEnd - tFallStart)
plot( TFall ?expr '( "TFall" ) )
TPFall = (tTPFallEnd - tFallSettleStart)
plot( TPFall ?expr '( "TPFall" ) )
TPRise = (tTPRiseEnd - tRiseSettleStart)
plot( TPRise ?expr '( "TPRise" ) )
TRise = (tRiseEnd - tRiseStart)
plot( TRise ?expr '( "TRise" ) )
TSettleFall = (tFallSettleEnd - tFallSettleStart)
plot( TSettleFall ?expr '( "TSettleFall" ) )
TSettleRise = (tRiseSettleEnd - tRiseSettleStart)
plot( TSettleRise ?expr '( "TSettleRise" ) )
cVH = clip(v("/VH" ?result "tran") clipStart (VAR("timeStop") - (0.25 * VAR("period"))))
plot( cVH ?expr '( "cVH" ) )
cVL = clip(v("/VL" ?result "tran") clipStart (VAR("timeStop") - (0.25 * VAR("period"))))
plot( cVL ?expr '( "cVL" ) )
cVline = clip(v("/Vline" ?result "tran") clipStart (VAR("timeStop") - (0.25 * VAR("period"))))
plot( cVline ?expr '( "cVline" ) )
clipStart = ((0.75 * VAR("period")) + VAR("startDelay"))
plot( clipStart ?expr '( "clipStart" ) )
tFallEnd = cross(cVline (VAR("VDDH") - (0.9 * vDiff)) 1 "falling")
plot( tFallEnd ?expr '( "tFallEnd" ) )
tFallSettleEnd = cross(cVline (1.05 * VAR("VDDL")) 1 "falling")
plot( tFallSettleEnd ?expr '( "tFallSettleEnd" ) )
tFallSettleStart = xmin(intersect(cVH cVL))
plot( tFallSettleStart ?expr '( "tFallSettleStart" ) )
tFallStart = cross(cVline (VAR("VDDH") - (0.1 * vDiff)) 1 "falling")
plot( tFallStart ?expr '( "tFallStart" ) )
tLeakageEnd = (clipStart + (0.51 * VAR("period")))
plot( tLeakageEnd ?expr '( "tLeakageEnd" ) )
tLeakageStart = (clipStart + (0.49 * VAR("period")))
plot( tLeakageStart ?expr '( "tLeakageStart" ) )
tRiseEnd = cross(cVline (VAR("VDDL") + (0.9 * vDiff)) 1 "rising")
plot( tRiseEnd ?expr '( "tRiseEnd" ) )
tRiseSettleEnd = cross(cVline (0.95 * VAR("VDDH")) 1 "rising")
plot( tRiseSettleEnd ?expr '( "tRiseSettleEnd" ) )
tRiseSettleStart = xmax(intersect(cVH cVL))
plot( tRiseSettleStart ?expr '( "tRiseSettleStart" ) )
tRiseStart = cross(cVline (VAR("VDDL") + (0.1 * vDiff)) 1 "rising")
plot( tRiseStart ?expr '( "tRiseStart" ) )
tTPFallEnd = cross(cVline (VAR("VDDH") - (0.5 * vDiff)) 1 "falling")
plot( tTPFallEnd ?expr '( "tTPFallEnd" ) )
tTPRiseEnd = cross(cVline (VAR("VDDL") + (0.5 * vDiff)) 1 "rising")
plot( tTPRiseEnd ?expr '( "tTPRiseEnd" ) )
vDiff = (VAR("VDDH") - VAR("VDDL"))
plot( vDiff ?expr '( "vDiff" ) )
modelFile(
    '("/software/cadence/ncsu-FreePDK15/hspice_20nm_hp.include" "")
)
run()
selectResult( 'tran )
plot(getData("/ILine/src") getData("/IVDDH/src") getData("/IVDDL/dst") getData("/VH") getData("/VL") getData("/Vline") )
LeakageIntoVDDL = average(clip(i("/IVDDL/dst" ?result "tran") tLeakageStart tLeakageEnd))
plot( LeakageIntoVDDL ?expr '( "LeakageIntoVDDL" ) )
LeakageLine = average(clip(i("/ILine/src" ?result "tran") tLeakageStart tLeakageEnd))
plot( LeakageLine ?expr '( "LeakageLine" ) )
LeakageVDDH = average(clip(i("/IVDDH/src" ?result "tran") tLeakageStart tLeakageEnd))
plot( LeakageVDDH ?expr '( "LeakageVDDH" ) )
QFall_pVDDL = integ((i("/IVDDL/dst" ?result "tran") * v("/Vline" ?result "tran")) tFallSettleStart tFallSettleEnd)
plot( QFall_pVDDL ?expr '( "QFall_pVDDL" ) )
QRise_pVDDH = integ((i("/IVDDH/src" ?result "tran") * v("/Vline" ?result "tran")) tRiseSettleStart tRiseSettleEnd)
plot( QRise_pVDDH ?expr '( "QRise_pVDDH" ) )
TFall = (tFallEnd - tFallStart)
plot( TFall ?expr '( "TFall" ) )
TPFall = (tTPFallEnd - tFallSettleStart)
plot( TPFall ?expr '( "TPFall" ) )
TPRise = (tTPRiseEnd - tRiseSettleStart)
plot( TPRise ?expr '( "TPRise" ) )
TRise = (tRiseEnd - tRiseStart)
plot( TRise ?expr '( "TRise" ) )
TSettleFall = (tFallSettleEnd - tFallSettleStart)
plot( TSettleFall ?expr '( "TSettleFall" ) )
TSettleRise = (tRiseSettleEnd - tRiseSettleStart)
plot( TSettleRise ?expr '( "TSettleRise" ) )
cVH = clip(v("/VH" ?result "tran") clipStart (VAR("timeStop") - (0.5 * VAR("period"))))
plot( cVH ?expr '( "cVH" ) )
cVL = clip(v("/VL" ?result "tran") clipStart (VAR("timeStop") - (0.5 * VAR("period"))))
plot( cVL ?expr '( "cVL" ) )
cVline = clip(v("/Vline" ?result "tran") clipStart (VAR("timeStop") - (0.5 * VAR("period"))))
plot( cVline ?expr '( "cVline" ) )
clipStart = ((0.75 * VAR("period")) + VAR("startDelay"))
plot( clipStart ?expr '( "clipStart" ) )
tFallEnd = cross(cVline (VAR("VDDH") - (0.9 * vDiff)) 1 "falling")
plot( tFallEnd ?expr '( "tFallEnd" ) )
tFallSettleEnd = cross(cVline (1.05 * VAR("VDDL")) 1 "falling")
plot( tFallSettleEnd ?expr '( "tFallSettleEnd" ) )
tFallSettleStart = xmin(intersect(cVH cVL))
plot( tFallSettleStart ?expr '( "tFallSettleStart" ) )
tFallStart = cross(cVline (VAR("VDDH") - (0.1 * vDiff)) 1 "falling")
plot( tFallStart ?expr '( "tFallStart" ) )
tLeakageEnd = (clipStart + (0.51 * VAR("period")))
plot( tLeakageEnd ?expr '( "tLeakageEnd" ) )
tLeakageStart = (clipStart + (0.49 * VAR("period")))
plot( tLeakageStart ?expr '( "tLeakageStart" ) )
tRiseEnd = cross(cVline (VAR("VDDL") + (0.9 * vDiff)) 1 "rising")
plot( tRiseEnd ?expr '( "tRiseEnd" ) )
tRiseSettleEnd = cross(cVline (0.95 * VAR("VDDH")) 1 "rising")
plot( tRiseSettleEnd ?expr '( "tRiseSettleEnd" ) )
tRiseSettleStart = xmax(intersect(cVH cVL))
plot( tRiseSettleStart ?expr '( "tRiseSettleStart" ) )
tRiseStart = cross(cVline (VAR("VDDL") + (0.1 * vDiff)) 1 "rising")
plot( tRiseStart ?expr '( "tRiseStart" ) )
tTPFallEnd = cross(cVline (VAR("VDDH") - (0.5 * vDiff)) 1 "falling")
plot( tTPFallEnd ?expr '( "tTPFallEnd" ) )
tTPRiseEnd = cross(cVline (VAR("VDDL") + (0.5 * vDiff)) 1 "rising")
plot( tTPRiseEnd ?expr '( "tTPRiseEnd" ) )
vDiff = (VAR("VDDH") - VAR("VDDL"))
plot( vDiff ?expr '( "vDiff" ) )
modelFile(
    '("/software/cadence/ncsu-FreePDK15/hspice_20nm_hp.include" "")
)
desVar(	  "startDelay" "period/2"	)
desVar(	  "pulseWidth" "period/2"	)
run()
selectResult( 'tran )
plot(getData("/ILine/src") getData("/IVDDH/src") getData("/IVDDL/dst") getData("/VH") getData("/VL") getData("/Vline") )
LeakageIntoVDDL = average(clip(i("/IVDDL/dst" ?result "tran") tLeakageStart tLeakageEnd))
plot( LeakageIntoVDDL ?expr '( "LeakageIntoVDDL" ) )
LeakageLine = average(clip(i("/ILine/src" ?result "tran") tLeakageStart tLeakageEnd))
plot( LeakageLine ?expr '( "LeakageLine" ) )
LeakageVDDH = average(clip(i("/IVDDH/src" ?result "tran") tLeakageStart tLeakageEnd))
plot( LeakageVDDH ?expr '( "LeakageVDDH" ) )
QFall_pVDDL = integ((i("/IVDDL/dst" ?result "tran") * v("/Vline" ?result "tran")) tFallSettleStart tFallSettleEnd)
plot( QFall_pVDDL ?expr '( "QFall_pVDDL" ) )
QRise_pVDDH = integ((i("/IVDDH/src" ?result "tran") * v("/Vline" ?result "tran")) tRiseSettleStart tRiseSettleEnd)
plot( QRise_pVDDH ?expr '( "QRise_pVDDH" ) )
TFall = (tFallEnd - tFallStart)
plot( TFall ?expr '( "TFall" ) )
TPFall = (tTPFallEnd - tFallSettleStart)
plot( TPFall ?expr '( "TPFall" ) )
TPRise = (tTPRiseEnd - tRiseSettleStart)
plot( TPRise ?expr '( "TPRise" ) )
TRise = (tRiseEnd - tRiseStart)
plot( TRise ?expr '( "TRise" ) )
TSettleFall = (tFallSettleEnd - tFallSettleStart)
plot( TSettleFall ?expr '( "TSettleFall" ) )
TSettleRise = (tRiseSettleEnd - tRiseSettleStart)
plot( TSettleRise ?expr '( "TSettleRise" ) )
cVH = clip(v("/VH" ?result "tran") clipStart (VAR("timeStop") - (0.5 * VAR("period"))))
plot( cVH ?expr '( "cVH" ) )
cVL = clip(v("/VL" ?result "tran") clipStart (VAR("timeStop") - (0.5 * VAR("period"))))
plot( cVL ?expr '( "cVL" ) )
cVline = clip(v("/Vline" ?result "tran") clipStart (VAR("timeStop") - (0.5 * VAR("period"))))
plot( cVline ?expr '( "cVline" ) )
clipStart = ((0.75 * VAR("period")) + VAR("startDelay"))
plot( clipStart ?expr '( "clipStart" ) )
tFallEnd = cross(cVline (VAR("VDDH") - (0.9 * vDiff)) 1 "falling")
plot( tFallEnd ?expr '( "tFallEnd" ) )
tFallSettleEnd = cross(cVline (1.05 * VAR("VDDL")) 1 "falling")
plot( tFallSettleEnd ?expr '( "tFallSettleEnd" ) )
tFallSettleStart = xmin(intersect(cVH cVL))
plot( tFallSettleStart ?expr '( "tFallSettleStart" ) )
tFallStart = cross(cVline (VAR("VDDH") - (0.1 * vDiff)) 1 "falling")
plot( tFallStart ?expr '( "tFallStart" ) )
tLeakageEnd = (clipStart + (0.51 * VAR("period")))
plot( tLeakageEnd ?expr '( "tLeakageEnd" ) )
tLeakageStart = (clipStart + (0.49 * VAR("period")))
plot( tLeakageStart ?expr '( "tLeakageStart" ) )
tRiseEnd = cross(cVline (VAR("VDDL") + (0.9 * vDiff)) 1 "rising")
plot( tRiseEnd ?expr '( "tRiseEnd" ) )
tRiseSettleEnd = cross(cVline (0.95 * VAR("VDDH")) 1 "rising")
plot( tRiseSettleEnd ?expr '( "tRiseSettleEnd" ) )
tRiseSettleStart = xmax(intersect(cVH cVL))
plot( tRiseSettleStart ?expr '( "tRiseSettleStart" ) )
tRiseStart = cross(cVline (VAR("VDDL") + (0.1 * vDiff)) 1 "rising")
plot( tRiseStart ?expr '( "tRiseStart" ) )
tTPFallEnd = cross(cVline (VAR("VDDH") - (0.5 * vDiff)) 1 "falling")
plot( tTPFallEnd ?expr '( "tTPFallEnd" ) )
tTPRiseEnd = cross(cVline (VAR("VDDL") + (0.5 * vDiff)) 1 "rising")
plot( tTPRiseEnd ?expr '( "tTPRiseEnd" ) )
vDiff = (VAR("VDDH") - VAR("VDDL"))
plot( vDiff ?expr '( "vDiff" ) )
modelFile(
    '("/software/cadence/ncsu-FreePDK15/hspice_20nm_hp.include" "")
)
run()
selectResult( 'tran )
plot(getData("/ILine/src") getData("/IVDDH/src") getData("/IVDDL/dst") getData("/VH") getData("/VL") getData("/Vline") )
LeakageIntoVDDL = average(clip(i("/IVDDL/dst" ?result "tran") tLeakageStart tLeakageEnd))
plot( LeakageIntoVDDL ?expr '( "LeakageIntoVDDL" ) )
LeakageLine = average(clip(i("/ILine/src" ?result "tran") tLeakageStart tLeakageEnd))
plot( LeakageLine ?expr '( "LeakageLine" ) )
LeakageVDDH = average(clip(i("/IVDDH/src" ?result "tran") tLeakageStart tLeakageEnd))
plot( LeakageVDDH ?expr '( "LeakageVDDH" ) )
QFall_pVDDL = integ((i("/IVDDL/dst" ?result "tran") * v("/Vline" ?result "tran")) tFallSettleStart tFallSettleEnd)
plot( QFall_pVDDL ?expr '( "QFall_pVDDL" ) )
QRise_pVDDH = integ((i("/IVDDH/src" ?result "tran") * v("/Vline" ?result "tran")) tRiseSettleStart tRiseSettleEnd)
plot( QRise_pVDDH ?expr '( "QRise_pVDDH" ) )
TFall = (tFallEnd - tFallStart)
plot( TFall ?expr '( "TFall" ) )
TPFall = (tTPFallEnd - tFallSettleStart)
plot( TPFall ?expr '( "TPFall" ) )
TPRise = (tTPRiseEnd - tRiseSettleStart)
plot( TPRise ?expr '( "TPRise" ) )
TRise = (tRiseEnd - tRiseStart)
plot( TRise ?expr '( "TRise" ) )
TSettleFall = (tFallSettleEnd - tFallSettleStart)
plot( TSettleFall ?expr '( "TSettleFall" ) )
TSettleRise = (tRiseSettleEnd - tRiseSettleStart)
plot( TSettleRise ?expr '( "TSettleRise" ) )
cVH = clip(v("/VH" ?result "tran") clipStart (VAR("timeStop") - (0.75 * VAR("period"))))
plot( cVH ?expr '( "cVH" ) )
cVL = clip(v("/VL" ?result "tran") clipStart (VAR("timeStop") - (0.75 * VAR("period"))))
plot( cVL ?expr '( "cVL" ) )
cVline = clip(v("/Vline" ?result "tran") clipStart (VAR("timeStop") - (0.75 * VAR("period"))))
plot( cVline ?expr '( "cVline" ) )
clipStart = ((0.75 * VAR("period")) + VAR("startDelay"))
plot( clipStart ?expr '( "clipStart" ) )
tFallEnd = cross(cVline (VAR("VDDH") - (0.9 * vDiff)) 1 "falling")
plot( tFallEnd ?expr '( "tFallEnd" ) )
tFallSettleEnd = cross(cVline (1.05 * VAR("VDDL")) 1 "falling")
plot( tFallSettleEnd ?expr '( "tFallSettleEnd" ) )
tFallSettleStart = xmin(intersect(cVH cVL))
plot( tFallSettleStart ?expr '( "tFallSettleStart" ) )
tFallStart = cross(cVline (VAR("VDDH") - (0.1 * vDiff)) 1 "falling")
plot( tFallStart ?expr '( "tFallStart" ) )
tLeakageEnd = (clipStart + (0.51 * VAR("period")))
plot( tLeakageEnd ?expr '( "tLeakageEnd" ) )
tLeakageStart = (clipStart + (0.49 * VAR("period")))
plot( tLeakageStart ?expr '( "tLeakageStart" ) )
tRiseEnd = cross(cVline (VAR("VDDL") + (0.9 * vDiff)) 1 "rising")
plot( tRiseEnd ?expr '( "tRiseEnd" ) )
tRiseSettleEnd = cross(cVline (0.95 * VAR("VDDH")) 1 "rising")
plot( tRiseSettleEnd ?expr '( "tRiseSettleEnd" ) )
tRiseSettleStart = xmax(intersect(cVH cVL))
plot( tRiseSettleStart ?expr '( "tRiseSettleStart" ) )
tRiseStart = cross(cVline (VAR("VDDL") + (0.1 * vDiff)) 1 "rising")
plot( tRiseStart ?expr '( "tRiseStart" ) )
tTPFallEnd = cross(cVline (VAR("VDDH") - (0.5 * vDiff)) 1 "falling")
plot( tTPFallEnd ?expr '( "tTPFallEnd" ) )
tTPRiseEnd = cross(cVline (VAR("VDDL") + (0.5 * vDiff)) 1 "rising")
plot( tTPRiseEnd ?expr '( "tTPRiseEnd" ) )
vDiff = (VAR("VDDH") - VAR("VDDL"))
plot( vDiff ?expr '( "vDiff" ) )
modelFile(
    '("/software/cadence/ncsu-FreePDK15/hspice_20nm_hp.include" "")
)
desVar(	  "nfin" 12	)
run()
selectResult( 'tran )
plot(getData("/ILine/src") getData("/IVDDH/src") getData("/IVDDL/dst") getData("/VH") getData("/VL") getData("/Vline") )
LeakageIntoVDDL = average(clip(i("/IVDDL/dst" ?result "tran") tLeakageStart tLeakageEnd))
plot( LeakageIntoVDDL ?expr '( "LeakageIntoVDDL" ) )
LeakageLine = average(clip(i("/ILine/src" ?result "tran") tLeakageStart tLeakageEnd))
plot( LeakageLine ?expr '( "LeakageLine" ) )
LeakageVDDH = average(clip(i("/IVDDH/src" ?result "tran") tLeakageStart tLeakageEnd))
plot( LeakageVDDH ?expr '( "LeakageVDDH" ) )
QFall_pVDDL = integ((i("/IVDDL/dst" ?result "tran") * v("/Vline" ?result "tran")) tFallSettleStart tFallSettleEnd)
plot( QFall_pVDDL ?expr '( "QFall_pVDDL" ) )
QRise_pVDDH = integ((i("/IVDDH/src" ?result "tran") * v("/Vline" ?result "tran")) tRiseSettleStart tRiseSettleEnd)
plot( QRise_pVDDH ?expr '( "QRise_pVDDH" ) )
TFall = (tFallEnd - tFallStart)
plot( TFall ?expr '( "TFall" ) )
TPFall = (tTPFallEnd - tFallSettleStart)
plot( TPFall ?expr '( "TPFall" ) )
TPRise = (tTPRiseEnd - tRiseSettleStart)
plot( TPRise ?expr '( "TPRise" ) )
TRise = (tRiseEnd - tRiseStart)
plot( TRise ?expr '( "TRise" ) )
TSettleFall = (tFallSettleEnd - tFallSettleStart)
plot( TSettleFall ?expr '( "TSettleFall" ) )
TSettleRise = (tRiseSettleEnd - tRiseSettleStart)
plot( TSettleRise ?expr '( "TSettleRise" ) )
cVH = clip(v("/VH" ?result "tran") clipStart (VAR("timeStop") - (0.75 * VAR("period"))))
plot( cVH ?expr '( "cVH" ) )
cVL = clip(v("/VL" ?result "tran") clipStart (VAR("timeStop") - (0.75 * VAR("period"))))
plot( cVL ?expr '( "cVL" ) )
cVline = clip(v("/Vline" ?result "tran") clipStart (VAR("timeStop") - (0.75 * VAR("period"))))
plot( cVline ?expr '( "cVline" ) )
clipStart = ((0.75 * VAR("period")) + VAR("startDelay"))
plot( clipStart ?expr '( "clipStart" ) )
tFallEnd = cross(cVline (VAR("VDDH") - (0.9 * vDiff)) 1 "falling")
plot( tFallEnd ?expr '( "tFallEnd" ) )
tFallSettleEnd = cross(cVline (1.05 * VAR("VDDL")) 1 "falling")
plot( tFallSettleEnd ?expr '( "tFallSettleEnd" ) )
tFallSettleStart = xmin(intersect(cVH cVL))
plot( tFallSettleStart ?expr '( "tFallSettleStart" ) )
tFallStart = cross(cVline (VAR("VDDH") - (0.1 * vDiff)) 1 "falling")
plot( tFallStart ?expr '( "tFallStart" ) )
tLeakageEnd = (clipStart + (0.51 * VAR("period")))
plot( tLeakageEnd ?expr '( "tLeakageEnd" ) )
tLeakageStart = (clipStart + (0.49 * VAR("period")))
plot( tLeakageStart ?expr '( "tLeakageStart" ) )
tRiseEnd = cross(cVline (VAR("VDDL") + (0.9 * vDiff)) 1 "rising")
plot( tRiseEnd ?expr '( "tRiseEnd" ) )
tRiseSettleEnd = cross(cVline (0.95 * VAR("VDDH")) 1 "rising")
plot( tRiseSettleEnd ?expr '( "tRiseSettleEnd" ) )
tRiseSettleStart = xmax(intersect(cVH cVL))
plot( tRiseSettleStart ?expr '( "tRiseSettleStart" ) )
tRiseStart = cross(cVline (VAR("VDDL") + (0.1 * vDiff)) 1 "rising")
plot( tRiseStart ?expr '( "tRiseStart" ) )
tTPFallEnd = cross(cVline (VAR("VDDH") - (0.5 * vDiff)) 1 "falling")
plot( tTPFallEnd ?expr '( "tTPFallEnd" ) )
tTPRiseEnd = cross(cVline (VAR("VDDL") + (0.5 * vDiff)) 1 "rising")
plot( tTPRiseEnd ?expr '( "tTPRiseEnd" ) )
vDiff = (VAR("VDDH") - VAR("VDDL"))
plot( vDiff ?expr '( "vDiff" ) )
modelFile(
    '("/software/cadence/ncsu-FreePDK15/hspice_20nm_hp.include" "")
)
converge( 'ic "/I33/I7/I3/Q0" "0" )
converge( 'ic "/I33/I7/I3/Q1" "VDDL" )
run()
selectResult( 'tran )
plot(getData("/I33/I7/I3/Q0") getData("/I33/I7/I3/Q1") getData("/ILine/src") getData("/IVDDH/src") getData("/IVDDL/dst") getData("/VH") getData("/VL") getData("/Vline") )
LeakageIntoVDDL = average(clip(i("/IVDDL/dst" ?result "tran") tLeakageStart tLeakageEnd))
plot( LeakageIntoVDDL ?expr '( "LeakageIntoVDDL" ) )
LeakageLine = average(clip(i("/ILine/src" ?result "tran") tLeakageStart tLeakageEnd))
plot( LeakageLine ?expr '( "LeakageLine" ) )
LeakageVDDH = average(clip(i("/IVDDH/src" ?result "tran") tLeakageStart tLeakageEnd))
plot( LeakageVDDH ?expr '( "LeakageVDDH" ) )
QFall_pVDDL = integ((i("/IVDDL/dst" ?result "tran") * v("/Vline" ?result "tran")) tFallSettleStart tFallSettleEnd)
plot( QFall_pVDDL ?expr '( "QFall_pVDDL" ) )
QRise_pVDDH = integ((i("/IVDDH/src" ?result "tran") * v("/Vline" ?result "tran")) tRiseSettleStart tRiseSettleEnd)
plot( QRise_pVDDH ?expr '( "QRise_pVDDH" ) )
TFall = (tFallEnd - tFallStart)
plot( TFall ?expr '( "TFall" ) )
TPFall = (tTPFallEnd - tFallSettleStart)
plot( TPFall ?expr '( "TPFall" ) )
TPRise = (tTPRiseEnd - tRiseSettleStart)
plot( TPRise ?expr '( "TPRise" ) )
TRise = (tRiseEnd - tRiseStart)
plot( TRise ?expr '( "TRise" ) )
TSettleFall = (tFallSettleEnd - tFallSettleStart)
plot( TSettleFall ?expr '( "TSettleFall" ) )
TSettleRise = (tRiseSettleEnd - tRiseSettleStart)
plot( TSettleRise ?expr '( "TSettleRise" ) )
cVH = clip(v("/VH" ?result "tran") clipStart (VAR("timeStop") - (0.75 * VAR("period"))))
plot( cVH ?expr '( "cVH" ) )
cVL = clip(v("/VL" ?result "tran") clipStart (VAR("timeStop") - (0.75 * VAR("period"))))
plot( cVL ?expr '( "cVL" ) )
cVline = clip(v("/Vline" ?result "tran") clipStart (VAR("timeStop") - (0.75 * VAR("period"))))
plot( cVline ?expr '( "cVline" ) )
clipStart = ((0.75 * VAR("period")) + VAR("startDelay"))
plot( clipStart ?expr '( "clipStart" ) )
tFallEnd = cross(cVline (VAR("VDDH") - (0.9 * vDiff)) 1 "falling")
plot( tFallEnd ?expr '( "tFallEnd" ) )
tFallSettleEnd = cross(cVline (1.05 * VAR("VDDL")) 1 "falling")
plot( tFallSettleEnd ?expr '( "tFallSettleEnd" ) )
tFallSettleStart = xmin(intersect(cVH cVL))
plot( tFallSettleStart ?expr '( "tFallSettleStart" ) )
tFallStart = cross(cVline (VAR("VDDH") - (0.1 * vDiff)) 1 "falling")
plot( tFallStart ?expr '( "tFallStart" ) )
tLeakageEnd = (clipStart + (0.51 * VAR("period")))
plot( tLeakageEnd ?expr '( "tLeakageEnd" ) )
tLeakageStart = (clipStart + (0.49 * VAR("period")))
plot( tLeakageStart ?expr '( "tLeakageStart" ) )
tRiseEnd = cross(cVline (VAR("VDDL") + (0.9 * vDiff)) 1 "rising")
plot( tRiseEnd ?expr '( "tRiseEnd" ) )
tRiseSettleEnd = cross(cVline (0.95 * VAR("VDDH")) 1 "rising")
plot( tRiseSettleEnd ?expr '( "tRiseSettleEnd" ) )
tRiseSettleStart = xmax(intersect(cVH cVL))
plot( tRiseSettleStart ?expr '( "tRiseSettleStart" ) )
tRiseStart = cross(cVline (VAR("VDDL") + (0.1 * vDiff)) 1 "rising")
plot( tRiseStart ?expr '( "tRiseStart" ) )
tTPFallEnd = cross(cVline (VAR("VDDH") - (0.5 * vDiff)) 1 "falling")
plot( tTPFallEnd ?expr '( "tTPFallEnd" ) )
tTPRiseEnd = cross(cVline (VAR("VDDL") + (0.5 * vDiff)) 1 "rising")
plot( tTPRiseEnd ?expr '( "tTPRiseEnd" ) )
vDiff = (VAR("VDDH") - VAR("VDDL"))
plot( vDiff ?expr '( "vDiff" ) )
modelFile(
    '("/software/cadence/ncsu-FreePDK15/hspice_20nm_hp.include" "")
)
desVar(	  "C" 26.374f	)
run()
selectResult( 'tran )
plot(getData("/ILine/src") getData("/IVDDH/src") getData("/IVDDL/dst") getData("/VH") getData("/VL") getData("/Vline") getData("/I33/I7/I3/Q1") getData("/I33/I7/I3/Q0") )
LeakageIntoVDDL = average(clip(i("/IVDDL/dst" ?result "tran") tLeakageStart tLeakageEnd))
plot( LeakageIntoVDDL ?expr '( "LeakageIntoVDDL" ) )
LeakageLine = average(clip(i("/ILine/src" ?result "tran") tLeakageStart tLeakageEnd))
plot( LeakageLine ?expr '( "LeakageLine" ) )
LeakageVDDH = average(clip(i("/IVDDH/src" ?result "tran") tLeakageStart tLeakageEnd))
plot( LeakageVDDH ?expr '( "LeakageVDDH" ) )
QFall_pVDDL = integ((i("/IVDDL/dst" ?result "tran") * v("/Vline" ?result "tran")) tFallSettleStart tFallSettleEnd)
plot( QFall_pVDDL ?expr '( "QFall_pVDDL" ) )
QRise_pVDDH = integ((i("/IVDDH/src" ?result "tran") * v("/Vline" ?result "tran")) tRiseSettleStart tRiseSettleEnd)
plot( QRise_pVDDH ?expr '( "QRise_pVDDH" ) )
TFall = (tFallEnd - tFallStart)
plot( TFall ?expr '( "TFall" ) )
TPFall = (tTPFallEnd - tFallSettleStart)
plot( TPFall ?expr '( "TPFall" ) )
TPRise = (tTPRiseEnd - tRiseSettleStart)
plot( TPRise ?expr '( "TPRise" ) )
TRise = (tRiseEnd - tRiseStart)
plot( TRise ?expr '( "TRise" ) )
TSettleFall = (tFallSettleEnd - tFallSettleStart)
plot( TSettleFall ?expr '( "TSettleFall" ) )
TSettleRise = (tRiseSettleEnd - tRiseSettleStart)
plot( TSettleRise ?expr '( "TSettleRise" ) )
cVH = clip(v("/VH" ?result "tran") clipStart (VAR("timeStop") - (0.75 * VAR("period"))))
plot( cVH ?expr '( "cVH" ) )
cVL = clip(v("/VL" ?result "tran") clipStart (VAR("timeStop") - (0.75 * VAR("period"))))
plot( cVL ?expr '( "cVL" ) )
cVline = clip(v("/Vline" ?result "tran") clipStart (VAR("timeStop") - (0.75 * VAR("period"))))
plot( cVline ?expr '( "cVline" ) )
clipStart = ((0.75 * VAR("period")) + VAR("startDelay"))
plot( clipStart ?expr '( "clipStart" ) )
tFallEnd = cross(cVline (VAR("VDDH") - (0.9 * vDiff)) 1 "falling")
plot( tFallEnd ?expr '( "tFallEnd" ) )
tFallSettleEnd = cross(cVline (1.05 * VAR("VDDL")) 1 "falling")
plot( tFallSettleEnd ?expr '( "tFallSettleEnd" ) )
tFallSettleStart = xmin(intersect(cVH cVL))
plot( tFallSettleStart ?expr '( "tFallSettleStart" ) )
tFallStart = cross(cVline (VAR("VDDH") - (0.1 * vDiff)) 1 "falling")
plot( tFallStart ?expr '( "tFallStart" ) )
tLeakageEnd = (clipStart + (0.51 * VAR("period")))
plot( tLeakageEnd ?expr '( "tLeakageEnd" ) )
tLeakageStart = (clipStart + (0.49 * VAR("period")))
plot( tLeakageStart ?expr '( "tLeakageStart" ) )
tRiseEnd = cross(cVline (VAR("VDDL") + (0.9 * vDiff)) 1 "rising")
plot( tRiseEnd ?expr '( "tRiseEnd" ) )
tRiseSettleEnd = cross(cVline (0.95 * VAR("VDDH")) 1 "rising")
plot( tRiseSettleEnd ?expr '( "tRiseSettleEnd" ) )
tRiseSettleStart = xmax(intersect(cVH cVL))
plot( tRiseSettleStart ?expr '( "tRiseSettleStart" ) )
tRiseStart = cross(cVline (VAR("VDDL") + (0.1 * vDiff)) 1 "rising")
plot( tRiseStart ?expr '( "tRiseStart" ) )
tTPFallEnd = cross(cVline (VAR("VDDH") - (0.5 * vDiff)) 1 "falling")
plot( tTPFallEnd ?expr '( "tTPFallEnd" ) )
tTPRiseEnd = cross(cVline (VAR("VDDL") + (0.5 * vDiff)) 1 "rising")
plot( tTPRiseEnd ?expr '( "tTPRiseEnd" ) )
vDiff = (VAR("VDDH") - VAR("VDDL"))
plot( vDiff ?expr '( "vDiff" ) )
hostMode( 'distributed )
resultsDir( "/net/kafka/nfs/rstdenis/Cadence/simulation/Dual_Supply_Word_Test/spectre/schematic/distributed/job001" )
modelFile(
    '("/software/cadence/ncsu-FreePDK15/hspice_20nm_hp.include" "")
)
run( ?jobName "job" ?queue "c2107" )
selectResult( 'tran )
plot(getData("/Vline") getData("/VL") getData("/VH") getData("/IVDDL/dst") getData("/IVDDH/src") getData("/ILine/src") getData("/I33/I7/I3/Q1") getData("/I33/I7/I3/Q0") )
vDiff = (VAR("VDDH") - VAR("VDDL"))
plot( vDiff ?expr '( "vDiff" ) )
tTPRiseEnd = cross(cVline (VAR("VDDL") + (0.5 * vDiff)) 1 "rising")
plot( tTPRiseEnd ?expr '( "tTPRiseEnd" ) )
tTPFallEnd = cross(cVline (VAR("VDDH") - (0.5 * vDiff)) 1 "falling")
plot( tTPFallEnd ?expr '( "tTPFallEnd" ) )
tRiseStart = cross(cVline (VAR("VDDL") + (0.1 * vDiff)) 1 "rising")
plot( tRiseStart ?expr '( "tRiseStart" ) )
tRiseSettleStart = xmax(intersect(cVH cVL))
plot( tRiseSettleStart ?expr '( "tRiseSettleStart" ) )
tRiseSettleEnd = cross(cVline (0.95 * VAR("VDDH")) 1 "rising")
plot( tRiseSettleEnd ?expr '( "tRiseSettleEnd" ) )
tRiseEnd = cross(cVline (VAR("VDDL") + (0.9 * vDiff)) 1 "rising")
plot( tRiseEnd ?expr '( "tRiseEnd" ) )
tLeakageStart = (clipStart + (0.42 * VAR("period")))
plot( tLeakageStart ?expr '( "tLeakageStart" ) )
tLeakageEnd = (clipStart + (0.58 * VAR("period")))
plot( tLeakageEnd ?expr '( "tLeakageEnd" ) )
tFallStart = cross(cVline (VAR("VDDH") - (0.1 * vDiff)) 1 "falling")
plot( tFallStart ?expr '( "tFallStart" ) )
tFallSettleStart = xmax(intersect(cVH cVL))
plot( tFallSettleStart ?expr '( "tFallSettleStart" ) )
tFallSettleEnd = cross(cVline (1.05 * VAR("VDDL")) 1 "falling")
plot( tFallSettleEnd ?expr '( "tFallSettleEnd" ) )
tFallEnd = cross(cVline (VAR("VDDH") - (0.9 * vDiff)) 1 "falling")
plot( tFallEnd ?expr '( "tFallEnd" ) )
iPwr = (i("/IVDDL/dst" ?result "tran") * v("/Vline" ?result "tran"))
plot( iPwr ?expr '( "iPwr" ) )
clipStart = ((0.75 * VAR("period")) + VAR("startDelay"))
plot( clipStart ?expr '( "clipStart" ) )
cVline = clip(v("/Vline" ?result "tran") clipStart (VAR("timeStop") - (0.75 * VAR("period"))))
plot( cVline ?expr '( "cVline" ) )
cVL = clip(v("/VL" ?result "tran") clipStart (VAR("timeStop") - (0.75 * VAR("period"))))
plot( cVL ?expr '( "cVL" ) )
cVH = clip(v("/VH" ?result "tran") clipStart (VAR("timeStop") - (0.75 * VAR("period"))))
plot( cVH ?expr '( "cVH" ) )
TSettleRise = (tRiseSettleEnd - tRiseSettleStart)
plot( TSettleRise ?expr '( "TSettleRise" ) )
TSettleFall = (tFallSettleEnd - tFallSettleStart)
plot( TSettleFall ?expr '( "TSettleFall" ) )
TRise = (tRiseEnd - tRiseStart)
plot( TRise ?expr '( "TRise" ) )
TPRise = (tTPRiseEnd - tRiseSettleStart)
plot( TPRise ?expr '( "TPRise" ) )
TPFall = (tTPFallEnd - tFallSettleStart)
plot( TPFall ?expr '( "TPFall" ) )
TFall = (tFallEnd - tFallStart)
plot( TFall ?expr '( "TFall" ) )
QRise_pVDDH = integ((i("/IVDDH/src" ?result "tran") * v("/Vline" ?result "tran")) tRiseSettleStart tRiseSettleEnd)
plot( QRise_pVDDH ?expr '( "QRise_pVDDH" ) )
QFall_pVDDL = integ((i("/IVDDL/dst" ?result "tran") * v("/Vline" ?result "tran")) tFallSettleStart tFallSettleEnd)
plot( QFall_pVDDL ?expr '( "QFall_pVDDL" ) )
LeakageVDDH = average(clip(i("/IVDDH/src" ?result "tran") tLeakageStart tLeakageEnd))
plot( LeakageVDDH ?expr '( "LeakageVDDH" ) )
LeakageLine = average(clip(i("/ILine/src" ?result "tran") tLeakageStart tLeakageEnd))
plot( LeakageLine ?expr '( "LeakageLine" ) )
LeakageIntoVDDL = average(clip(i("/IVDDL/dst" ?result "tran") tLeakageStart tLeakageEnd))
plot( LeakageIntoVDDL ?expr '( "LeakageIntoVDDL" ) )
hostMode( 'local )
resultsDir( "/net/kafka/nfs/rstdenis/Cadence/simulation/Dual_Supply_Word_Test/spectre/schematic" )
modelFile(
    '("/software/cadence/ncsu-FreePDK15/hspice_20nm_hp.include" "")
)
run()
selectResult( 'tran )
plot(getData("/Vline") getData("/VL") getData("/VH") getData("/IVDDL/dst") getData("/IVDDH/src") getData("/ILine/src") getData("/I33/I7/I3/Q1") getData("/I33/I7/I3/Q0") )
vDiff = (VAR("VDDH") - VAR("VDDL"))
plot( vDiff ?expr '( "vDiff" ) )
tTPRiseEnd = cross(cVline (VAR("VDDL") + (0.5 * vDiff)) 1 "rising")
plot( tTPRiseEnd ?expr '( "tTPRiseEnd" ) )
tTPFallEnd = cross(cVline (VAR("VDDH") - (0.5 * vDiff)) 1 "falling")
plot( tTPFallEnd ?expr '( "tTPFallEnd" ) )
tRiseStart = cross(cVline (VAR("VDDL") + (0.1 * vDiff)) 1 "rising")
plot( tRiseStart ?expr '( "tRiseStart" ) )
tRiseSettleStart = xmax(intersect(cVH cVL))
plot( tRiseSettleStart ?expr '( "tRiseSettleStart" ) )
tRiseSettleEnd = cross(cVline (0.95 * VAR("VDDH")) 1 "rising")
plot( tRiseSettleEnd ?expr '( "tRiseSettleEnd" ) )
tRiseEnd = cross(cVline (VAR("VDDL") + (0.9 * vDiff)) 1 "rising")
plot( tRiseEnd ?expr '( "tRiseEnd" ) )
tLeakageStart = (clipStart + (0.42 * VAR("period")))
plot( tLeakageStart ?expr '( "tLeakageStart" ) )
tLeakageEnd = (clipStart + (0.58 * VAR("period")))
plot( tLeakageEnd ?expr '( "tLeakageEnd" ) )
tFallStart = cross(cVline (VAR("VDDH") - (0.1 * vDiff)) 1 "falling")
plot( tFallStart ?expr '( "tFallStart" ) )
tFallSettleStart = xmax(intersect(cVH cVL))
plot( tFallSettleStart ?expr '( "tFallSettleStart" ) )
tFallSettleEnd = cross(cVline (1.05 * VAR("VDDL")) 1 "falling")
plot( tFallSettleEnd ?expr '( "tFallSettleEnd" ) )
tFallEnd = cross(cVline (VAR("VDDH") - (0.9 * vDiff)) 1 "falling")
plot( tFallEnd ?expr '( "tFallEnd" ) )
iPwr = (i("/IVDDL/dst" ?result "tran") * v("/Vline" ?result "tran"))
plot( iPwr ?expr '( "iPwr" ) )
clipStart = ((0.75 * VAR("period")) + VAR("startDelay"))
plot( clipStart ?expr '( "clipStart" ) )
cVline = clip(v("/Vline" ?result "tran") clipStart (VAR("timeStop") - (0.75 * VAR("period"))))
plot( cVline ?expr '( "cVline" ) )
cVL = clip(v("/VL" ?result "tran") clipStart (VAR("timeStop") - (0.75 * VAR("period"))))
plot( cVL ?expr '( "cVL" ) )
cVH = clip(v("/VH" ?result "tran") clipStart (VAR("timeStop") - (0.75 * VAR("period"))))
plot( cVH ?expr '( "cVH" ) )
TSettleRise = (tRiseSettleEnd - tRiseSettleStart)
plot( TSettleRise ?expr '( "TSettleRise" ) )
TSettleFall = (tFallSettleEnd - tFallSettleStart)
plot( TSettleFall ?expr '( "TSettleFall" ) )
TRise = (tRiseEnd - tRiseStart)
plot( TRise ?expr '( "TRise" ) )
TPRise = (tTPRiseEnd - tRiseSettleStart)
plot( TPRise ?expr '( "TPRise" ) )
TPFall = (tTPFallEnd - tFallSettleStart)
plot( TPFall ?expr '( "TPFall" ) )
TFall = (tFallEnd - tFallStart)
plot( TFall ?expr '( "TFall" ) )
QRise_pVDDH = integ((i("/IVDDH/src" ?result "tran") * v("/Vline" ?result "tran")) tRiseSettleStart tRiseSettleEnd)
plot( QRise_pVDDH ?expr '( "QRise_pVDDH" ) )
QFall_pVDDL = integ((i("/IVDDL/dst" ?result "tran") * v("/Vline" ?result "tran")) tFallSettleStart tFallSettleEnd)
plot( QFall_pVDDL ?expr '( "QFall_pVDDL" ) )
LeakageVDDH = average(clip(i("/IVDDH/src" ?result "tran") tLeakageStart tLeakageEnd))
plot( LeakageVDDH ?expr '( "LeakageVDDH" ) )
LeakageLine = average(clip(i("/ILine/src" ?result "tran") tLeakageStart tLeakageEnd))
plot( LeakageLine ?expr '( "LeakageLine" ) )
LeakageIntoVDDL = average(clip(i("/IVDDL/dst" ?result "tran") tLeakageStart tLeakageEnd))
plot( LeakageIntoVDDL ?expr '( "LeakageIntoVDDL" ) )
modelFile(
    '("/software/cadence/ncsu-FreePDK15/hspice_20nm_hp.include" "")
)
run()
selectResult( 'tran )
plot(getData("/I33/I7/I2/Q0") getData("/I33/I7/I2/Q1") getData("/Vline") getData("/VL") getData("/VH") getData("/IVDDL/dst") getData("/IVDDH/src") getData("/ILine/src") )
vDiff = (VAR("VDDH") - VAR("VDDL"))
plot( vDiff ?expr '( "vDiff" ) )
tTPRiseEnd = cross(cVline (VAR("VDDL") + (0.5 * vDiff)) 1 "rising")
plot( tTPRiseEnd ?expr '( "tTPRiseEnd" ) )
tTPFallEnd = cross(cVline (VAR("VDDH") - (0.5 * vDiff)) 1 "falling")
plot( tTPFallEnd ?expr '( "tTPFallEnd" ) )
tRiseStart = cross(cVline (VAR("VDDL") + (0.1 * vDiff)) 1 "rising")
plot( tRiseStart ?expr '( "tRiseStart" ) )
tRiseSettleStart = xmax(intersect(cVH cVL))
plot( tRiseSettleStart ?expr '( "tRiseSettleStart" ) )
tRiseSettleEnd = cross(cVline (0.95 * VAR("VDDH")) 1 "rising")
plot( tRiseSettleEnd ?expr '( "tRiseSettleEnd" ) )
tRiseEnd = cross(cVline (VAR("VDDL") + (0.9 * vDiff)) 1 "rising")
plot( tRiseEnd ?expr '( "tRiseEnd" ) )
tLeakageStart = (clipStart + (0.42 * VAR("period")))
plot( tLeakageStart ?expr '( "tLeakageStart" ) )
tLeakageEnd = (clipStart + (0.58 * VAR("period")))
plot( tLeakageEnd ?expr '( "tLeakageEnd" ) )
tFallStart = cross(cVline (VAR("VDDH") - (0.1 * vDiff)) 1 "falling")
plot( tFallStart ?expr '( "tFallStart" ) )
tFallSettleStart = xmax(intersect(cVH cVL))
plot( tFallSettleStart ?expr '( "tFallSettleStart" ) )
tFallSettleEnd = cross(cVline (1.05 * VAR("VDDL")) 1 "falling")
plot( tFallSettleEnd ?expr '( "tFallSettleEnd" ) )
tFallEnd = cross(cVline (VAR("VDDH") - (0.9 * vDiff)) 1 "falling")
plot( tFallEnd ?expr '( "tFallEnd" ) )
iPwr = (i("/IVDDL/dst" ?result "tran") * v("/Vline" ?result "tran"))
plot( iPwr ?expr '( "iPwr" ) )
clipStart = ((0.75 * VAR("period")) + VAR("startDelay"))
plot( clipStart ?expr '( "clipStart" ) )
cVline = clip(v("/Vline" ?result "tran") clipStart (VAR("timeStop") - (0.75 * VAR("period"))))
plot( cVline ?expr '( "cVline" ) )
cVL = clip(v("/VL" ?result "tran") clipStart (VAR("timeStop") - (0.75 * VAR("period"))))
plot( cVL ?expr '( "cVL" ) )
cVH = clip(v("/VH" ?result "tran") clipStart (VAR("timeStop") - (0.75 * VAR("period"))))
plot( cVH ?expr '( "cVH" ) )
TSettleRise = (tRiseSettleEnd - tRiseSettleStart)
plot( TSettleRise ?expr '( "TSettleRise" ) )
TSettleFall = (tFallSettleEnd - tFallSettleStart)
plot( TSettleFall ?expr '( "TSettleFall" ) )
TRise = (tRiseEnd - tRiseStart)
plot( TRise ?expr '( "TRise" ) )
TPRise = (tTPRiseEnd - tRiseSettleStart)
plot( TPRise ?expr '( "TPRise" ) )
TPFall = (tTPFallEnd - tFallSettleStart)
plot( TPFall ?expr '( "TPFall" ) )
TFall = (tFallEnd - tFallStart)
plot( TFall ?expr '( "TFall" ) )
QRise_pVDDH = integ((i("/IVDDH/src" ?result "tran") * v("/Vline" ?result "tran")) tRiseSettleStart tRiseSettleEnd)
plot( QRise_pVDDH ?expr '( "QRise_pVDDH" ) )
QFall_pVDDL = integ((i("/IVDDL/dst" ?result "tran") * v("/Vline" ?result "tran")) tFallSettleStart tFallSettleEnd)
plot( QFall_pVDDL ?expr '( "QFall_pVDDL" ) )
LeakageVDDH = average(clip(i("/IVDDH/src" ?result "tran") tLeakageStart tLeakageEnd))
plot( LeakageVDDH ?expr '( "LeakageVDDH" ) )
LeakageLine = average(clip(i("/ILine/src" ?result "tran") tLeakageStart tLeakageEnd))
plot( LeakageLine ?expr '( "LeakageLine" ) )
LeakageIntoVDDL = average(clip(i("/IVDDL/dst" ?result "tran") tLeakageStart tLeakageEnd))
plot( LeakageIntoVDDL ?expr '( "LeakageIntoVDDL" ) )
hostMode( 'distributed )
resultsDir( "/net/kafka/nfs/rstdenis/Cadence/simulation/Dual_Supply_Word_Test/spectre/schematic/distributed/job001" )
modelFile(
    '("/software/cadence/ncsu-FreePDK15/hspice_20nm_hp.include" "")
)
desVar(	  "timeStop" 18n	)
desVar(	  "startDelay" 3n	)
desVar(	  "pulseWidth" 3n	)
converge( 'ic "/vcc!" "VDDL" )
converge( 'ic "/I33/I0/I0/Q1" "0" )
converge( 'ic "/I33/I0/I0/Q0" "VDDL" )
converge( 'ic "/I33/I0/I1/Q1" "0" )
converge( 'ic "/I33/I0/I1/Q0" "VDDL" )
converge( 'ic "/net032" "VDDL" )
converge( 'ic "/net029" "VDDL" )
converge( 'ic "/net033" "VDDL" )
converge( 'ic "/net030" "VDDL" )
converge( 'ic "/gnd!" "0" )
converge( 'ic "/B0P1" "VDDL" )
converge( 'ic "/B1P1" "VDDL" )
converge( 'ic "/B0P2" "VDDL" )
converge( 'ic "/B1P2" "VDDL" )
run( ?jobName "job" ?queue "c2107" )
selectResult( 'tran )
plot(getData("/Vline") getData("/VL") getData("/VH") getData("/IVDDL/dst") getData("/IVDDH/src") getData("/ILine/src") )
vDiff = (VAR("VDDH") - VAR("VDDL"))
plot( vDiff ?expr '( "vDiff" ) )
tTPRiseEnd = cross(cVline (VAR("VDDL") + (0.5 * vDiff)) 1 "rising")
plot( tTPRiseEnd ?expr '( "tTPRiseEnd" ) )
tTPFallEnd = cross(cVline (VAR("VDDH") - (0.5 * vDiff)) 1 "falling")
plot( tTPFallEnd ?expr '( "tTPFallEnd" ) )
tRiseStart = cross(cVline (VAR("VDDL") + (0.1 * vDiff)) 1 "rising")
plot( tRiseStart ?expr '( "tRiseStart" ) )
tRiseSettleStart = xmax(intersect(cVH cVL))
plot( tRiseSettleStart ?expr '( "tRiseSettleStart" ) )
tRiseSettleEnd = cross(cVline (0.95 * VAR("VDDH")) 1 "rising")
plot( tRiseSettleEnd ?expr '( "tRiseSettleEnd" ) )
tRiseEnd = cross(cVline (VAR("VDDL") + (0.9 * vDiff)) 1 "rising")
plot( tRiseEnd ?expr '( "tRiseEnd" ) )
tLeakageStart = (clipStart + (0.42 * VAR("period")))
plot( tLeakageStart ?expr '( "tLeakageStart" ) )
tLeakageEnd = (clipStart + (0.58 * VAR("period")))
plot( tLeakageEnd ?expr '( "tLeakageEnd" ) )
tFallStart = cross(cVline (VAR("VDDH") - (0.1 * vDiff)) 1 "falling")
plot( tFallStart ?expr '( "tFallStart" ) )
tFallSettleStart = xmax(intersect(cVH cVL))
plot( tFallSettleStart ?expr '( "tFallSettleStart" ) )
tFallSettleEnd = cross(cVline (1.05 * VAR("VDDL")) 1 "falling")
plot( tFallSettleEnd ?expr '( "tFallSettleEnd" ) )
tFallEnd = cross(cVline (VAR("VDDH") - (0.9 * vDiff)) 1 "falling")
plot( tFallEnd ?expr '( "tFallEnd" ) )
iPwr = (i("/IVDDL/dst" ?result "tran") * v("/Vline" ?result "tran"))
plot( iPwr ?expr '( "iPwr" ) )
clipStart = ((0.75 * VAR("period")) + VAR("startDelay"))
plot( clipStart ?expr '( "clipStart" ) )
cVline = clip(v("/Vline" ?result "tran") clipStart (VAR("timeStop") - (0.75 * VAR("period"))))
plot( cVline ?expr '( "cVline" ) )
cVL = clip(v("/VL" ?result "tran") clipStart (VAR("timeStop") - (0.75 * VAR("period"))))
plot( cVL ?expr '( "cVL" ) )
cVH = clip(v("/VH" ?result "tran") clipStart (VAR("timeStop") - (0.75 * VAR("period"))))
plot( cVH ?expr '( "cVH" ) )
TSettleRise = (tRiseSettleEnd - tRiseSettleStart)
plot( TSettleRise ?expr '( "TSettleRise" ) )
TSettleFall = (tFallSettleEnd - tFallSettleStart)
plot( TSettleFall ?expr '( "TSettleFall" ) )
TRise = (tRiseEnd - tRiseStart)
plot( TRise ?expr '( "TRise" ) )
TPRise = (tTPRiseEnd - tRiseSettleStart)
plot( TPRise ?expr '( "TPRise" ) )
TPFall = (tTPFallEnd - tFallSettleStart)
plot( TPFall ?expr '( "TPFall" ) )
TFall = (tFallEnd - tFallStart)
plot( TFall ?expr '( "TFall" ) )
ERise = ymax(iinteg(clip(iPwr tRiseSettleStart tRiseSettleEnd)))
plot( ERise ?expr '( "ERise" ) )
EFall = ymax(iinteg(clip(iPwr tFallSettleStart tFallSettleEnd)))
plot( EFall ?expr '( "EFall" ) )
LeakageVDDH = average(clip(i("/IVDDH/src" ?result "tran") tLeakageStart tLeakageEnd))
plot( LeakageVDDH ?expr '( "LeakageVDDH" ) )
LeakageLine = average(clip(i("/ILine/src" ?result "tran") tLeakageStart tLeakageEnd))
plot( LeakageLine ?expr '( "LeakageLine" ) )
LeakageIntoVDDL = average(clip(i("/IVDDL/dst" ?result "tran") tLeakageStart tLeakageEnd))
plot( LeakageIntoVDDL ?expr '( "LeakageIntoVDDL" ) )
