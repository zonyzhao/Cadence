simulator( 'spectre )
design(	 "/net/kafka/nfs/rstdenis/Cadence/simulation/inv_test/spectre/schematic/netlist/netlist")
resultsDir( "/net/kafka/nfs/rstdenis/Cadence/simulation/inv_test/spectre/schematic" )
modelFile(
    '("/root/Desktop/Cadence/ncsu-FreePDK15/hspice_16nm_lstp.include" "")
)
analysis('tran ?stop "10n"  ?errpreset "conservative"  )
desVar(	  "vdd" .850	)
envOption(
	'analysisOrder  list("tran" "ac")
)
temp( 27 )
run()
selectResult( 'tran )
plot(getData("/nvtc") getData("/Yvtc") )
modelFile(
    '("/root/Desktop/Cadence/ncsu-FreePDK15/hspice_16nm_lstp.include" "")
)
run()
selectResult( 'tran )
plot(getData("/nvtc") getData("/Yvtc") )
modelFile(
    '("/root/Desktop/Cadence/ncsu-FreePDK15/hspice_16nm_lstp.include" "")
)
run()
selectResult( 'tran )
plot(getData("/nvtc") getData("/Yvtc") )
modelFile(
    '("/root/Desktop/Cadence/ncsu-FreePDK15/hspice_16nm_lstp.include" "")
)
run()
selectResult( 'tran )
plot(getData("/nvtc") getData("/Yvtc") )
modelFile(
    '("/root/Desktop/Cadence/ncsu-FreePDK15/hspice_16nm_lstp.include" "")
)
run()
selectResult( 'tran )
plot(getData("/nvtc") getData("/Yvtc") )
