simulator( 'spectre )
design(	 "/net/kafka/nfs/rstdenis/Cadence/simulation/inv_test/spectre/schematic/netlist/netlist")
resultsDir( "/net/kafka/nfs/rstdenis/Cadence/simulation/inv_test/spectre/schematic" )
modelFile(
    '("/root/Desktop/Cadence/ncsu-FreePDK15/hspice_16nm_lstp.include" "")
)
analysis('tran ?stop "10n"  ?errpreset "conservative"  )
desVar(	  "vdd" .850	)
envOption(
	'analysisOrder  list("tran" "ac")
)
temp( 27 )
run()
selectResult( 'tran )
plot(getData("/Cout") getData("/nvtc") getData("/Yvtc") )
modelFile(
    '("/root/Desktop/Cadence/ncsu-FreePDK15/hspice_16nm_lstp.include" "")
)
run()
selectResult( 'tran )
plot(getData("/net7") getData("/net3") getData("/net2") getData("/Cout") getData("/nvtc") getData("/Yvtc") )
modelFile(
    '("/root/Desktop/Cadence/ncsu-FreePDK15/hspice_16nm_lstp.include" "")
)
run()
selectResult( 'tran )
plot(getData("/nvtc") getData("/Yvtc") getData("/Cout") getData("/net2") getData("/net3") getData("/net7") )
modelFile(
    '("/root/Desktop/Cadence/ncsu-FreePDK15/hspice_16nm_lstp.include" "")
)
run()
selectResult( 'tran )
plot(getData("/nvtc") getData("/Yvtc") getData("/Cout") getData("/net2") getData("/net3") getData("/net7") )
modelFile(
    '("/root/Desktop/Cadence/ncsu-FreePDK15/hspice_16nm_lstp.include" "")
)
run()
selectResult( 'tran )
plot(getData("/nvtc") getData("/Yvtc") getData("/Cout") getData("/net2") getData("/net3") getData("/net7") )
modelFile(
    '("/root/Desktop/Cadence/ncsu-FreePDK15/hspice_16nm_lstp.include" "")
)
run()
selectResult( 'tran )
plot(getData("/nvtc") getData("/Yvtc") getData("/Cout") getData("/net2") getData("/net3") getData("/net7") )
modelFile(
    '("/root/Desktop/Cadence/ncsu-FreePDK15/hspice_16nm_lstp.include" "")
)
analysis('tran ?stop "2n"  )
desVar(	  "delay" 100p	)
desVar(	  "timeS2" 600p	)
desVar(	  "timeS" 300p	)
desVar(	  "timeF2" 700p	)
desVar(	  "timeF" 400p	)
run()
selectResult( 'tran )
plot(getData("/nvtc") getData("/Yvtc") getData("/Cout") getData("/C-") getData("/B+") getData("/A") )
modelFile(
    '("/root/Desktop/Cadence/ncsu-FreePDK15/hspice_16nm_lstp.include" "")
)
run()
selectResult( 'tran )
plot(getData("/nvtc") getData("/Yvtc") getData("/Cout") getData("/C-") getData("/B+") getData("/A") )
modelFile(
    '("/root/Desktop/Cadence/ncsu-FreePDK15/hspice_16nm_lstp.include" "")
)
run()
selectResult( 'tran )
plot(getData("/nvtc") getData("/Yvtc") getData("/Cout") getData("/C-") getData("/B+") getData("/A") )
modelFile(
    '("/root/Desktop/Cadence/ncsu-FreePDK15/hspice_16nm_lstp.include" "")
)
run()
selectResult( 'tran )
plot(getData("/nvtc") getData("/Yvtc") getData("/Cout") getData("/C-") getData("/B+") getData("/A") )
modelFile(
    '("/root/Desktop/Cadence/ncsu-FreePDK15/hspice_16nm_lstp.include" "")
)
delete( 'desVar "s" )
run()
selectResult( 'tran )
plot(getData("/Cout") getData("/C-") getData("/B+") getData("/A") )
modelFile(
    '("/root/Desktop/Cadence/ncsu-FreePDK15/hspice_16nm_lstp.include" "")
)
run()
selectResult( 'tran )
plot(getData("/Cout") getData("/C-") getData("/B+") getData("/A") )
