// Design: 16nm_Tests/inv_test
simulator lang=spectre
global 0 vdd!
parameters timeF=400p timeF2=700p timeS=300p timeS2=600p vdd=.850 delay=100p
include "/root/Desktop/Cadence/ncsu-FreePDK15/hspice_16nm_lstp.include"

// 16nm/inv_1x/schematic
subckt inv_1x A Y
    M0 (Y A 0 0) nfet w=60n l=20n nfin=1 m=1 degradation=no
    M1 (Y A vdd! vdd!) pfet w=100n l=20n nfin=1 m=1 degradation=no
ends inv_1x

// 16nm/THaC/schematic
subckt THaC A B\+ C\- Y
    M6 (net7 net021 net11 net021) nfet w=120n l=20n nfin=1 m=1 degradation=no
    M5 (net7 A net33 A) nfet w=120n l=20n nfin=1 m=1 degradation=no
    M9 (net11 C\- 0 C\-) nfet w=120n l=20n nfin=1 m=1 degradation=no
    M8 (net11 A 0 A) nfet w=120n l=20n nfin=1 m=1 degradation=no
    M7 (net33 B\+ 0 B\+) nfet w=120n l=20n nfin=1 m=1 degradation=no
    I8 (net021 Y) inv_1x
    I2 (net7 net021) inv_1x
    M2 (net17 B\+ vdd! B\+) pfet w=100n l=20n nfin=1 m=1 degradation=yes
    M1 (net17 A vdd! A) pfet w=100n l=20n nfin=1 m=1 degradation=yes
    M0 (net32 A vdd! A) pfet w=100n l=20n nfin=1 m=1 degradation=yes
    M3 (net7 C\- net32 C\-) pfet w=100n l=20n nfin=1 m=1 degradation=yes
    M4 (net7 net021 net17 net021) pfet w=100n l=20n nfin=1 m=1 degradation=yes
ends THaC

// 16nm_Tests/inv_test/schematic
V0 (vdd! 0) vsource type=dc dc=vdd
V3 (C\- 0) vsource type=pwl mag=0 phase=0 wave=[ 0 0 (timeS +delay) 0 (timeF +delay) vdd (timeS2 +delay) vdd (timeF2 +delay) 0 ]
V2 (B\+ 0) vsource type=pwl mag=0 phase=0 wave=[ 0 0 (timeS +delay +delay) 0 (timeF +delay +delay) vdd (timeS2 +delay +delay +delay) vdd (timeF2 +delay +delay +delay) 0 ]
V6 (A 0) vsource type=pwl mag=0 phase=0 wave=[ 0 0 timeS 0 timeF vdd timeS2 vdd timeF2 0 ]
I7 (A B\+ C\- Cout) THaC
simulatorOptions options temp=27
tran tran stop=2n errpreset=conservative
