// Design: 16nm_Tests/inv_test
simulator lang=spectre
global 0 vdd!
parameters vdd=.850
include "/root/Desktop/Cadence/ncsu-FreePDK15/hspice_16nm_lstp.include"

// 16nm/inv_1x/schematic
subckt inv_1x A Y
    M0 (Y A 0 0) nfet w=60n l=20n nfin=1 m=1 degradation=no
    M1 (Y A vdd! vdd!) pfet w=100n l=20n nfin=1 m=1 degradation=no
ends inv_1x

// 16nm_Tests/inv_test/schematic
I0 (nvtc Yvtc) inv_1x
V0 (vdd! 0) vsource type=dc dc=vdd
V1 (nvtc 0) vsource type=pwl mag=850m wave=[ 0 0 10n vdd ]
simulatorOptions options temp=27
tran tran stop=10n errpreset=conservative
