simulator( 'spectre )
design(	 "/net/kafka/nfs/rstdenis/Cadence/simulation/Dual_Supply_Test/spectre/schematic/netlist/netlist")
resultsDir( "/net/kafka/nfs/rstdenis/Cadence/simulation/Dual_Supply_Test/spectre/schematic" )
modelFile(
    '("/root/Desktop/Cadence/ncsu-FreePDK15/PTM-MG/smodels.scs" "")
)
analysis('tran ?stop "VAR(\"timeStop\")"  ?errpreset "conservative"  )
desVar(	  "nfin" 12	)
desVar(	  "timeF" "5n+7n+7n+10p"	)
desVar(	  "timeE" "5n+7n+7n"	)
desVar(	  "timeD" "5n+7n+10p"	)
desVar(	  "timeC" "5n+7n"	)
desVar(	  "timeB" "5n+10p"	)
desVar(	  "timeA" 5n	)
desVar(	  "VDDL" .450	)
desVar(	  "VDDH" .600	)
desVar(	  "C" 500f	)
desVar(	  "timeStop" 33n	)
envOption(
	'cmd64bit  t
	'analysisOrder  list("tran")
)
option(	'multithread  "on"
)
save( 'v "/Vline" "/VL" "/VH" )
save( 'i "/IVDDH/src" "/IVDDL/dst" "/ILine/src" )
converge( 'ic "/VL" "0" )
converge( 'ic "/sH" "VDDH" )
converge( 'ic "/VH" "VDDH" )
converge( 'ic "/Vline" "VDDL" )
converge( 'ic "/I19/I0/I0/I7/I3/Q0" "0" )
converge( 'ic "/I19/I0/I0/I7/I3/Q1" "VDDL" )
temp( 27 )
run()
selectResult( 'tran )
plot(getData("/Vline") getData("/VL") getData("/VH") getData("/IVDDH/src") getData("/IVDDL/dst") getData("/ILine/src") )
TSettleRise = (tRiseSettleEnd - tRiseSettleStart)
plot( TSettleRise ?expr '( "TSettleRise" ) )
TSettleFall = (tFallSettleEnd - tFallSettleStart)
plot( TSettleFall ?expr '( "TSettleFall" ) )
LeakageLine = average(clip(i("/ILine/src" ?result "tran") tLeakageStart tLeakageEnd))
plot( LeakageLine ?expr '( "LeakageLine" ) )
LeakageIntoVDDL = average(clip(i("/IVDDL/dst" ?result "tran") tLeakageStart tLeakageEnd))
plot( LeakageIntoVDDL ?expr '( "LeakageIntoVDDL" ) )
LeakageVDDH = average(clip(i("/IVDDH/src" ?result "tran") tLeakageStart tLeakageEnd))
plot( LeakageVDDH ?expr '( "LeakageVDDH" ) )
tRiseSettleStart = cross(v("/VH" ?result "tran") (0.5 * VAR("VDDH")) 2 "falling")
plot( tRiseSettleStart ?expr '( "tRiseSettleStart" ) )
tRiseSettleEnd = cross(v("/Vline" ?result "tran") (0.99 * VAR("VDDH")) 2 "rising")
plot( tRiseSettleEnd ?expr '( "tRiseSettleEnd" ) )
tFallSettleEnd = cross(v("/Vline" ?result "tran") (1.005 * VAR("VDDL")) 1 "falling")
plot( tFallSettleEnd ?expr '( "tFallSettleEnd" ) )
tFallSettleStart = cross(v("/VH" ?result "tran") (0.5 * VAR("VDDH")) 1 "rising")
plot( tFallSettleStart ?expr '( "tFallSettleStart" ) )
QRise_pVDDH = ymax(iinteg(clip(i("/IVDDH/src" ?result "tran") tRiseSettleStart tRiseSettleEnd)))
plot( QRise_pVDDH ?expr '( "QRise_pVDDH" ) )
QFall_pVDDL = ymax(iinteg(clip(i("/IVDDL/dst" ?result "tran") tFallSettleStart tFallSettleEnd)))
plot( QFall_pVDDL ?expr '( "QFall_pVDDL" ) )
tLeakageStart = (VAR("timeB") + (0.49 * (VAR("timeC") - VAR("timeB"))))
plot( tLeakageStart ?expr '( "tLeakageStart" ) )
tLeakageEnd = (VAR("timeC") - (0.49 * (VAR("timeC") - VAR("timeB"))))
plot( tLeakageEnd ?expr '( "tLeakageEnd" ) )
tRiseStart = cross(v("/Vline" ?result "tran") (VAR("VDDL") + (0.1 * vDiff)) 2 "rising")
plot( tRiseStart ?expr '( "tRiseStart" ) )
tFallStart = cross(v("/Vline" ?result "tran") (VAR("VDDH") - (0.1 * vDiff)) 1 "falling")
plot( tFallStart ?expr '( "tFallStart" ) )
tRiseEnd = cross(v("/Vline" ?result "tran") (VAR("VDDL") + (0.9 * vDiff)) 2 "rising")
plot( tRiseEnd ?expr '( "tRiseEnd" ) )
vDiff = (VAR("VDDH") - VAR("VDDL"))
plot( vDiff ?expr '( "vDiff" ) )
tFallEnd = cross(v("/Vline" ?result "tran") (VAR("VDDH") - (0.9 * vDiff)) 1 "falling")
plot( tFallEnd ?expr '( "tFallEnd" ) )
modelFile(
    '("/root/Desktop/Cadence/ncsu-FreePDK15/PTM-MG/smodels.scs" "")
)
desVar(	  "C" 300f	)
run()
selectResult( 'tran )
plot(getData("/Vline") getData("/VL") getData("/VH") getData("/IVDDH/src") getData("/IVDDL/dst") getData("/ILine/src") )
TSettleRise = (tRiseSettleEnd - tRiseSettleStart)
plot( TSettleRise ?expr '( "TSettleRise" ) )
TSettleFall = (tFallSettleEnd - tFallSettleStart)
plot( TSettleFall ?expr '( "TSettleFall" ) )
LeakageLine = average(clip(i("/ILine/src" ?result "tran") tLeakageStart tLeakageEnd))
plot( LeakageLine ?expr '( "LeakageLine" ) )
LeakageIntoVDDL = average(clip(i("/IVDDL/dst" ?result "tran") tLeakageStart tLeakageEnd))
plot( LeakageIntoVDDL ?expr '( "LeakageIntoVDDL" ) )
LeakageVDDH = average(clip(i("/IVDDH/src" ?result "tran") tLeakageStart tLeakageEnd))
plot( LeakageVDDH ?expr '( "LeakageVDDH" ) )
tRiseSettleStart = cross(v("/VH" ?result "tran") (0.5 * VAR("VDDH")) 2 "falling")
plot( tRiseSettleStart ?expr '( "tRiseSettleStart" ) )
tRiseSettleEnd = cross(v("/Vline" ?result "tran") (0.99 * VAR("VDDH")) 2 "rising")
plot( tRiseSettleEnd ?expr '( "tRiseSettleEnd" ) )
tFallSettleEnd = cross(v("/Vline" ?result "tran") (1.005 * VAR("VDDL")) 1 "falling")
plot( tFallSettleEnd ?expr '( "tFallSettleEnd" ) )
tFallSettleStart = cross(v("/VH" ?result "tran") (0.5 * VAR("VDDH")) 1 "rising")
plot( tFallSettleStart ?expr '( "tFallSettleStart" ) )
QRise_pVDDH = ymax(iinteg(clip(i("/IVDDH/src" ?result "tran") tRiseSettleStart tRiseSettleEnd)))
plot( QRise_pVDDH ?expr '( "QRise_pVDDH" ) )
QFall_pVDDL = ymax(iinteg(clip(i("/IVDDL/dst" ?result "tran") tFallSettleStart tFallSettleEnd)))
plot( QFall_pVDDL ?expr '( "QFall_pVDDL" ) )
tLeakageStart = (VAR("timeB") + (0.49 * (VAR("timeC") - VAR("timeB"))))
plot( tLeakageStart ?expr '( "tLeakageStart" ) )
tLeakageEnd = (VAR("timeC") - (0.49 * (VAR("timeC") - VAR("timeB"))))
plot( tLeakageEnd ?expr '( "tLeakageEnd" ) )
tRiseStart = cross(v("/Vline" ?result "tran") (VAR("VDDL") + (0.1 * vDiff)) 2 "rising")
plot( tRiseStart ?expr '( "tRiseStart" ) )
tFallStart = cross(v("/Vline" ?result "tran") (VAR("VDDH") - (0.1 * vDiff)) 1 "falling")
plot( tFallStart ?expr '( "tFallStart" ) )
tRiseEnd = cross(v("/Vline" ?result "tran") (VAR("VDDL") + (0.9 * vDiff)) 2 "rising")
plot( tRiseEnd ?expr '( "tRiseEnd" ) )
vDiff = (VAR("VDDH") - VAR("VDDL"))
plot( vDiff ?expr '( "vDiff" ) )
tFallEnd = cross(v("/Vline" ?result "tran") (VAR("VDDH") - (0.9 * vDiff)) 1 "falling")
plot( tFallEnd ?expr '( "tFallEnd" ) )
modelFile(
    '("/root/Desktop/Cadence/ncsu-FreePDK15/PTM-MG/smodels.scs" "")
)
desVar(	  "timeStop" 28n	)
run()
selectResult( 'tran )
plot(getData("/Vline") getData("/VL") getData("/VH") getData("/IVDDH/src") getData("/IVDDL/dst") getData("/ILine/src") )
TSettleRise = (tRiseSettleEnd - tRiseSettleStart)
plot( TSettleRise ?expr '( "TSettleRise" ) )
TSettleFall = (tFallSettleEnd - tFallSettleStart)
plot( TSettleFall ?expr '( "TSettleFall" ) )
LeakageLine = average(clip(i("/ILine/src" ?result "tran") tLeakageStart tLeakageEnd))
plot( LeakageLine ?expr '( "LeakageLine" ) )
LeakageIntoVDDL = average(clip(i("/IVDDL/dst" ?result "tran") tLeakageStart tLeakageEnd))
plot( LeakageIntoVDDL ?expr '( "LeakageIntoVDDL" ) )
LeakageVDDH = average(clip(i("/IVDDH/src" ?result "tran") tLeakageStart tLeakageEnd))
plot( LeakageVDDH ?expr '( "LeakageVDDH" ) )
tRiseSettleStart = cross(v("/VH" ?result "tran") (0.5 * VAR("VDDH")) 2 "falling")
plot( tRiseSettleStart ?expr '( "tRiseSettleStart" ) )
tRiseSettleEnd = cross(v("/Vline" ?result "tran") (0.99 * VAR("VDDH")) 2 "rising")
plot( tRiseSettleEnd ?expr '( "tRiseSettleEnd" ) )
tFallSettleEnd = cross(v("/Vline" ?result "tran") (1.005 * VAR("VDDL")) 1 "falling")
plot( tFallSettleEnd ?expr '( "tFallSettleEnd" ) )
tFallSettleStart = cross(v("/VH" ?result "tran") (0.5 * VAR("VDDH")) 1 "rising")
plot( tFallSettleStart ?expr '( "tFallSettleStart" ) )
QRise_pVDDH = ymax(iinteg(clip(i("/IVDDH/src" ?result "tran") tRiseSettleStart tRiseSettleEnd)))
plot( QRise_pVDDH ?expr '( "QRise_pVDDH" ) )
QFall_pVDDL = ymax(iinteg(clip(i("/IVDDL/dst" ?result "tran") tFallSettleStart tFallSettleEnd)))
plot( QFall_pVDDL ?expr '( "QFall_pVDDL" ) )
tLeakageStart = (VAR("timeB") + (0.49 * (VAR("timeC") - VAR("timeB"))))
plot( tLeakageStart ?expr '( "tLeakageStart" ) )
tLeakageEnd = (VAR("timeC") - (0.49 * (VAR("timeC") - VAR("timeB"))))
plot( tLeakageEnd ?expr '( "tLeakageEnd" ) )
tRiseStart = cross(v("/Vline" ?result "tran") (VAR("VDDL") + (0.1 * vDiff)) 2 "rising")
plot( tRiseStart ?expr '( "tRiseStart" ) )
tFallStart = cross(v("/Vline" ?result "tran") (VAR("VDDH") - (0.1 * vDiff)) 1 "falling")
plot( tFallStart ?expr '( "tFallStart" ) )
tRiseEnd = cross(v("/Vline" ?result "tran") (VAR("VDDL") + (0.9 * vDiff)) 2 "rising")
plot( tRiseEnd ?expr '( "tRiseEnd" ) )
vDiff = (VAR("VDDH") - VAR("VDDL"))
plot( vDiff ?expr '( "vDiff" ) )
tFallEnd = cross(v("/Vline" ?result "tran") (VAR("VDDH") - (0.9 * vDiff)) 1 "falling")
plot( tFallEnd ?expr '( "tFallEnd" ) )
modelFile(
    '("/root/Desktop/Cadence/ncsu-FreePDK15/PTM-MG/smodels.scs" "")
)
desVar(	  "C" 26.3f	)
run()
selectResult( 'tran )
plot(getData("/Vline") getData("/VL") getData("/VH") getData("/IVDDH/src") getData("/IVDDL/dst") getData("/ILine/src") )
TSettleRise = (tRiseSettleEnd - tRiseSettleStart)
plot( TSettleRise ?expr '( "TSettleRise" ) )
TSettleFall = (tFallSettleEnd - tFallSettleStart)
plot( TSettleFall ?expr '( "TSettleFall" ) )
LeakageLine = average(clip(i("/ILine/src" ?result "tran") tLeakageStart tLeakageEnd))
plot( LeakageLine ?expr '( "LeakageLine" ) )
LeakageIntoVDDL = average(clip(i("/IVDDL/dst" ?result "tran") tLeakageStart tLeakageEnd))
plot( LeakageIntoVDDL ?expr '( "LeakageIntoVDDL" ) )
LeakageVDDH = average(clip(i("/IVDDH/src" ?result "tran") tLeakageStart tLeakageEnd))
plot( LeakageVDDH ?expr '( "LeakageVDDH" ) )
tRiseSettleStart = cross(v("/VH" ?result "tran") (0.5 * VAR("VDDH")) 2 "falling")
plot( tRiseSettleStart ?expr '( "tRiseSettleStart" ) )
tRiseSettleEnd = cross(v("/Vline" ?result "tran") (0.99 * VAR("VDDH")) 2 "rising")
plot( tRiseSettleEnd ?expr '( "tRiseSettleEnd" ) )
tFallSettleEnd = cross(v("/Vline" ?result "tran") (1.005 * VAR("VDDL")) 1 "falling")
plot( tFallSettleEnd ?expr '( "tFallSettleEnd" ) )
tFallSettleStart = cross(v("/VH" ?result "tran") (0.5 * VAR("VDDH")) 1 "rising")
plot( tFallSettleStart ?expr '( "tFallSettleStart" ) )
QRise_pVDDH = ymax(iinteg(clip(i("/IVDDH/src" ?result "tran") tRiseSettleStart tRiseSettleEnd)))
plot( QRise_pVDDH ?expr '( "QRise_pVDDH" ) )
QFall_pVDDL = ymax(iinteg(clip(i("/IVDDL/dst" ?result "tran") tFallSettleStart tFallSettleEnd)))
plot( QFall_pVDDL ?expr '( "QFall_pVDDL" ) )
tLeakageStart = (VAR("timeB") + (0.49 * (VAR("timeC") - VAR("timeB"))))
plot( tLeakageStart ?expr '( "tLeakageStart" ) )
tLeakageEnd = (VAR("timeC") - (0.49 * (VAR("timeC") - VAR("timeB"))))
plot( tLeakageEnd ?expr '( "tLeakageEnd" ) )
tRiseStart = cross(v("/Vline" ?result "tran") (VAR("VDDL") + (0.1 * vDiff)) 2 "rising")
plot( tRiseStart ?expr '( "tRiseStart" ) )
tFallStart = cross(v("/Vline" ?result "tran") (VAR("VDDH") - (0.1 * vDiff)) 1 "falling")
plot( tFallStart ?expr '( "tFallStart" ) )
tRiseEnd = cross(v("/Vline" ?result "tran") (VAR("VDDL") + (0.9 * vDiff)) 2 "rising")
plot( tRiseEnd ?expr '( "tRiseEnd" ) )
vDiff = (VAR("VDDH") - VAR("VDDL"))
plot( vDiff ?expr '( "vDiff" ) )
tFallEnd = cross(v("/Vline" ?result "tran") (VAR("VDDH") - (0.9 * vDiff)) 1 "falling")
plot( tFallEnd ?expr '( "tFallEnd" ) )
modelFile(
    '("/root/Desktop/Cadence/ncsu-FreePDK15/PTM-MG/smodels.scs" "")
)
desVar(	  "C" 300f	)
run()
selectResult( 'tran )
plot(getData("/Vline") getData("/VL") getData("/VH") getData("/IVDDH/src") getData("/IVDDL/dst") getData("/ILine/src") )
TSettleRise = (tRiseSettleEnd - tRiseSettleStart)
plot( TSettleRise ?expr '( "TSettleRise" ) )
TSettleFall = (tFallSettleEnd - tFallSettleStart)
plot( TSettleFall ?expr '( "TSettleFall" ) )
LeakageLine = average(clip(i("/ILine/src" ?result "tran") tLeakageStart tLeakageEnd))
plot( LeakageLine ?expr '( "LeakageLine" ) )
LeakageIntoVDDL = average(clip(i("/IVDDL/dst" ?result "tran") tLeakageStart tLeakageEnd))
plot( LeakageIntoVDDL ?expr '( "LeakageIntoVDDL" ) )
LeakageVDDH = average(clip(i("/IVDDH/src" ?result "tran") tLeakageStart tLeakageEnd))
plot( LeakageVDDH ?expr '( "LeakageVDDH" ) )
tRiseSettleStart = cross(v("/VH" ?result "tran") (0.5 * VAR("VDDH")) 2 "falling")
plot( tRiseSettleStart ?expr '( "tRiseSettleStart" ) )
tRiseSettleEnd = cross(v("/Vline" ?result "tran") (0.99 * VAR("VDDH")) 2 "rising")
plot( tRiseSettleEnd ?expr '( "tRiseSettleEnd" ) )
tFallSettleEnd = cross(v("/Vline" ?result "tran") (1.005 * VAR("VDDL")) 1 "falling")
plot( tFallSettleEnd ?expr '( "tFallSettleEnd" ) )
tFallSettleStart = cross(v("/VH" ?result "tran") (0.5 * VAR("VDDH")) 1 "rising")
plot( tFallSettleStart ?expr '( "tFallSettleStart" ) )
QRise_pVDDH = ymax(iinteg(clip(i("/IVDDH/src" ?result "tran") tRiseSettleStart tRiseSettleEnd)))
plot( QRise_pVDDH ?expr '( "QRise_pVDDH" ) )
QFall_pVDDL = ymax(iinteg(clip(i("/IVDDL/dst" ?result "tran") tFallSettleStart tFallSettleEnd)))
plot( QFall_pVDDL ?expr '( "QFall_pVDDL" ) )
tLeakageStart = (VAR("timeB") + (0.49 * (VAR("timeC") - VAR("timeB"))))
plot( tLeakageStart ?expr '( "tLeakageStart" ) )
tLeakageEnd = (VAR("timeC") - (0.49 * (VAR("timeC") - VAR("timeB"))))
plot( tLeakageEnd ?expr '( "tLeakageEnd" ) )
tRiseStart = cross(v("/Vline" ?result "tran") (VAR("VDDL") + (0.1 * vDiff)) 2 "rising")
plot( tRiseStart ?expr '( "tRiseStart" ) )
tFallStart = cross(v("/Vline" ?result "tran") (VAR("VDDH") - (0.1 * vDiff)) 1 "falling")
plot( tFallStart ?expr '( "tFallStart" ) )
tRiseEnd = cross(v("/Vline" ?result "tran") (VAR("VDDL") + (0.9 * vDiff)) 2 "rising")
plot( tRiseEnd ?expr '( "tRiseEnd" ) )
vDiff = (VAR("VDDH") - VAR("VDDL"))
plot( vDiff ?expr '( "vDiff" ) )
tFallEnd = cross(v("/Vline" ?result "tran") (VAR("VDDH") - (0.9 * vDiff)) 1 "falling")
plot( tFallEnd ?expr '( "tFallEnd" ) )
modelFile(
    '("/root/Desktop/Cadence/ncsu-FreePDK15/PTM-MG/smodels.scs" "")
)
desVar(	  "timeB" "timeA+timerf"	)
desVar(	  "timerf" 10p	)
run()
selectResult( 'tran )
plot(getData("/Vline") getData("/VL") getData("/VH") getData("/IVDDH/src") getData("/IVDDL/dst") getData("/ILine/src") )
TSettleRise = (tRiseSettleEnd - tRiseSettleStart)
plot( TSettleRise ?expr '( "TSettleRise" ) )
TSettleFall = (tFallSettleEnd - tFallSettleStart)
plot( TSettleFall ?expr '( "TSettleFall" ) )
LeakageLine = average(clip(i("/ILine/src" ?result "tran") tLeakageStart tLeakageEnd))
plot( LeakageLine ?expr '( "LeakageLine" ) )
LeakageIntoVDDL = average(clip(i("/IVDDL/dst" ?result "tran") tLeakageStart tLeakageEnd))
plot( LeakageIntoVDDL ?expr '( "LeakageIntoVDDL" ) )
LeakageVDDH = average(clip(i("/IVDDH/src" ?result "tran") tLeakageStart tLeakageEnd))
plot( LeakageVDDH ?expr '( "LeakageVDDH" ) )
tRiseSettleStart = cross(v("/VH" ?result "tran") (0.5 * VAR("VDDH")) 2 "falling")
plot( tRiseSettleStart ?expr '( "tRiseSettleStart" ) )
tRiseSettleEnd = cross(v("/Vline" ?result "tran") (0.99 * VAR("VDDH")) 2 "rising")
plot( tRiseSettleEnd ?expr '( "tRiseSettleEnd" ) )
tFallSettleEnd = cross(v("/Vline" ?result "tran") (1.005 * VAR("VDDL")) 1 "falling")
plot( tFallSettleEnd ?expr '( "tFallSettleEnd" ) )
tFallSettleStart = cross(v("/VH" ?result "tran") (0.5 * VAR("VDDH")) 1 "rising")
plot( tFallSettleStart ?expr '( "tFallSettleStart" ) )
QRise_pVDDH = ymax(iinteg(clip(i("/IVDDH/src" ?result "tran") tRiseSettleStart tRiseSettleEnd)))
plot( QRise_pVDDH ?expr '( "QRise_pVDDH" ) )
QFall_pVDDL = ymax(iinteg(clip(i("/IVDDL/dst" ?result "tran") tFallSettleStart tFallSettleEnd)))
plot( QFall_pVDDL ?expr '( "QFall_pVDDL" ) )
tLeakageStart = (VAR("timeB") + (0.49 * (VAR("timeC") - VAR("timeB"))))
plot( tLeakageStart ?expr '( "tLeakageStart" ) )
tLeakageEnd = (VAR("timeC") - (0.49 * (VAR("timeC") - VAR("timeB"))))
plot( tLeakageEnd ?expr '( "tLeakageEnd" ) )
tRiseStart = cross(v("/Vline" ?result "tran") (VAR("VDDL") + (0.1 * vDiff)) 2 "rising")
plot( tRiseStart ?expr '( "tRiseStart" ) )
tFallStart = cross(v("/Vline" ?result "tran") (VAR("VDDH") - (0.1 * vDiff)) 1 "falling")
plot( tFallStart ?expr '( "tFallStart" ) )
tRiseEnd = cross(v("/Vline" ?result "tran") (VAR("VDDL") + (0.9 * vDiff)) 2 "rising")
plot( tRiseEnd ?expr '( "tRiseEnd" ) )
vDiff = (VAR("VDDH") - VAR("VDDL"))
plot( vDiff ?expr '( "vDiff" ) )
tFallEnd = cross(v("/Vline" ?result "tran") (VAR("VDDH") - (0.9 * vDiff)) 1 "falling")
plot( tFallEnd ?expr '( "tFallEnd" ) )
modelFile(
    '("/root/Desktop/Cadence/ncsu-FreePDK15/PTM-MG/smodels.scs" "")
)
desVar(	  "timeF" "timeE+timerf"	)
desVar(	  "timeD" "timeC+timerf"	)
desVar(	  "timeE" "timeC+timeWait"	)
desVar(	  "timeC" "timeA+timeWait"	)
desVar(	  "timeWait" 7n	)
run()
selectResult( 'tran )
plot(getData("/Vline") getData("/VL") getData("/VH") getData("/IVDDH/src") getData("/IVDDL/dst") getData("/ILine/src") )
TSettleRise = (tRiseSettleEnd - tRiseSettleStart)
plot( TSettleRise ?expr '( "TSettleRise" ) )
TSettleFall = (tFallSettleEnd - tFallSettleStart)
plot( TSettleFall ?expr '( "TSettleFall" ) )
LeakageLine = average(clip(i("/ILine/src" ?result "tran") tLeakageStart tLeakageEnd))
plot( LeakageLine ?expr '( "LeakageLine" ) )
LeakageIntoVDDL = average(clip(i("/IVDDL/dst" ?result "tran") tLeakageStart tLeakageEnd))
plot( LeakageIntoVDDL ?expr '( "LeakageIntoVDDL" ) )
LeakageVDDH = average(clip(i("/IVDDH/src" ?result "tran") tLeakageStart tLeakageEnd))
plot( LeakageVDDH ?expr '( "LeakageVDDH" ) )
tRiseSettleStart = cross(v("/VH" ?result "tran") (0.5 * VAR("VDDH")) 2 "falling")
plot( tRiseSettleStart ?expr '( "tRiseSettleStart" ) )
tRiseSettleEnd = cross(v("/Vline" ?result "tran") (0.99 * VAR("VDDH")) 2 "rising")
plot( tRiseSettleEnd ?expr '( "tRiseSettleEnd" ) )
tFallSettleEnd = cross(v("/Vline" ?result "tran") (1.005 * VAR("VDDL")) 1 "falling")
plot( tFallSettleEnd ?expr '( "tFallSettleEnd" ) )
tFallSettleStart = cross(v("/VH" ?result "tran") (0.5 * VAR("VDDH")) 1 "rising")
plot( tFallSettleStart ?expr '( "tFallSettleStart" ) )
QRise_pVDDH = ymax(iinteg(clip(i("/IVDDH/src" ?result "tran") tRiseSettleStart tRiseSettleEnd)))
plot( QRise_pVDDH ?expr '( "QRise_pVDDH" ) )
QFall_pVDDL = ymax(iinteg(clip(i("/IVDDL/dst" ?result "tran") tFallSettleStart tFallSettleEnd)))
plot( QFall_pVDDL ?expr '( "QFall_pVDDL" ) )
tLeakageStart = (VAR("timeB") + (0.49 * (VAR("timeC") - VAR("timeB"))))
plot( tLeakageStart ?expr '( "tLeakageStart" ) )
tLeakageEnd = (VAR("timeC") - (0.49 * (VAR("timeC") - VAR("timeB"))))
plot( tLeakageEnd ?expr '( "tLeakageEnd" ) )
tRiseStart = cross(v("/Vline" ?result "tran") (VAR("VDDL") + (0.1 * vDiff)) 2 "rising")
plot( tRiseStart ?expr '( "tRiseStart" ) )
tFallStart = cross(v("/Vline" ?result "tran") (VAR("VDDH") - (0.1 * vDiff)) 1 "falling")
plot( tFallStart ?expr '( "tFallStart" ) )
tRiseEnd = cross(v("/Vline" ?result "tran") (VAR("VDDL") + (0.9 * vDiff)) 2 "rising")
plot( tRiseEnd ?expr '( "tRiseEnd" ) )
vDiff = (VAR("VDDH") - VAR("VDDL"))
plot( vDiff ?expr '( "vDiff" ) )
tFallEnd = cross(v("/Vline" ?result "tran") (VAR("VDDH") - (0.9 * vDiff)) 1 "falling")
plot( tFallEnd ?expr '( "tFallEnd" ) )
modelFile(
    '("/root/Desktop/Cadence/ncsu-FreePDK15/PTM-MG/smodels.scs" "")
)
desVar(	  "timeStop" "timeE+timeWait"	)
desVar(	  "C" .59631p	)
run()
selectResult( 'tran )
plot(getData("/Vline") getData("/VL") getData("/VH") getData("/IVDDH/src") getData("/IVDDL/dst") getData("/ILine/src") )
TSettleRise = (tRiseSettleEnd - tRiseSettleStart)
plot( TSettleRise ?expr '( "TSettleRise" ) )
TSettleFall = (tFallSettleEnd - tFallSettleStart)
plot( TSettleFall ?expr '( "TSettleFall" ) )
LeakageLine = average(clip(i("/ILine/src" ?result "tran") tLeakageStart tLeakageEnd))
plot( LeakageLine ?expr '( "LeakageLine" ) )
LeakageIntoVDDL = average(clip(i("/IVDDL/dst" ?result "tran") tLeakageStart tLeakageEnd))
plot( LeakageIntoVDDL ?expr '( "LeakageIntoVDDL" ) )
LeakageVDDH = average(clip(i("/IVDDH/src" ?result "tran") tLeakageStart tLeakageEnd))
plot( LeakageVDDH ?expr '( "LeakageVDDH" ) )
tRiseSettleStart = cross(v("/VH" ?result "tran") (0.5 * VAR("VDDH")) 2 "falling")
plot( tRiseSettleStart ?expr '( "tRiseSettleStart" ) )
tRiseSettleEnd = cross(v("/Vline" ?result "tran") (0.99 * VAR("VDDH")) 2 "rising")
plot( tRiseSettleEnd ?expr '( "tRiseSettleEnd" ) )
tFallSettleEnd = cross(v("/Vline" ?result "tran") (1.005 * VAR("VDDL")) 1 "falling")
plot( tFallSettleEnd ?expr '( "tFallSettleEnd" ) )
tFallSettleStart = cross(v("/VH" ?result "tran") (0.5 * VAR("VDDH")) 1 "rising")
plot( tFallSettleStart ?expr '( "tFallSettleStart" ) )
QRise_pVDDH = ymax(iinteg(clip(i("/IVDDH/src" ?result "tran") tRiseSettleStart tRiseSettleEnd)))
plot( QRise_pVDDH ?expr '( "QRise_pVDDH" ) )
QFall_pVDDL = ymax(iinteg(clip(i("/IVDDL/dst" ?result "tran") tFallSettleStart tFallSettleEnd)))
plot( QFall_pVDDL ?expr '( "QFall_pVDDL" ) )
tLeakageStart = (VAR("timeB") + (0.49 * (VAR("timeC") - VAR("timeB"))))
plot( tLeakageStart ?expr '( "tLeakageStart" ) )
tLeakageEnd = (VAR("timeC") - (0.49 * (VAR("timeC") - VAR("timeB"))))
plot( tLeakageEnd ?expr '( "tLeakageEnd" ) )
tRiseStart = cross(v("/Vline" ?result "tran") (VAR("VDDL") + (0.1 * vDiff)) 2 "rising")
plot( tRiseStart ?expr '( "tRiseStart" ) )
tFallStart = cross(v("/Vline" ?result "tran") (VAR("VDDH") - (0.1 * vDiff)) 1 "falling")
plot( tFallStart ?expr '( "tFallStart" ) )
tRiseEnd = cross(v("/Vline" ?result "tran") (VAR("VDDL") + (0.9 * vDiff)) 2 "rising")
plot( tRiseEnd ?expr '( "tRiseEnd" ) )
vDiff = (VAR("VDDH") - VAR("VDDL"))
plot( vDiff ?expr '( "vDiff" ) )
tFallEnd = cross(v("/Vline" ?result "tran") (VAR("VDDH") - (0.9 * vDiff)) 1 "falling")
plot( tFallEnd ?expr '( "tFallEnd" ) )
modelFile(
    '("/root/Desktop/Cadence/ncsu-FreePDK15/PTM-MG/smodels.scs" "")
)
desVar(	  "timeB" "VAR(\"timeA\")+VAR(\"timerf\")"	)
desVar(	  "timeC" "VAR(\"timeA\")+VAR(\"timeWait\")"	)
run()
selectResult( 'tran )
plot(getData("/Vline") getData("/VL") getData("/VH") getData("/IVDDH/src") getData("/IVDDL/dst") getData("/ILine/src") )
TSettleRise = (tRiseSettleEnd - tRiseSettleStart)
plot( TSettleRise ?expr '( "TSettleRise" ) )
TSettleFall = (tFallSettleEnd - tFallSettleStart)
plot( TSettleFall ?expr '( "TSettleFall" ) )
LeakageLine = average(clip(i("/ILine/src" ?result "tran") tLeakageStart tLeakageEnd))
plot( LeakageLine ?expr '( "LeakageLine" ) )
LeakageIntoVDDL = average(clip(i("/IVDDL/dst" ?result "tran") tLeakageStart tLeakageEnd))
plot( LeakageIntoVDDL ?expr '( "LeakageIntoVDDL" ) )
LeakageVDDH = average(clip(i("/IVDDH/src" ?result "tran") tLeakageStart tLeakageEnd))
plot( LeakageVDDH ?expr '( "LeakageVDDH" ) )
tRiseSettleStart = cross(v("/VH" ?result "tran") (0.5 * VAR("VDDH")) 2 "falling")
plot( tRiseSettleStart ?expr '( "tRiseSettleStart" ) )
tRiseSettleEnd = cross(v("/Vline" ?result "tran") (0.99 * VAR("VDDH")) 2 "rising")
plot( tRiseSettleEnd ?expr '( "tRiseSettleEnd" ) )
tFallSettleEnd = cross(v("/Vline" ?result "tran") (1.005 * VAR("VDDL")) 1 "falling")
plot( tFallSettleEnd ?expr '( "tFallSettleEnd" ) )
tFallSettleStart = cross(v("/VH" ?result "tran") (0.5 * VAR("VDDH")) 1 "rising")
plot( tFallSettleStart ?expr '( "tFallSettleStart" ) )
QRise_pVDDH = ymax(iinteg(clip(i("/IVDDH/src" ?result "tran") tRiseSettleStart tRiseSettleEnd)))
plot( QRise_pVDDH ?expr '( "QRise_pVDDH" ) )
QFall_pVDDL = ymax(iinteg(clip(i("/IVDDL/dst" ?result "tran") tFallSettleStart tFallSettleEnd)))
plot( QFall_pVDDL ?expr '( "QFall_pVDDL" ) )
tLeakageStart = (VAR("timeB") + (0.49 * (VAR("timeC") - VAR("timeB"))))
plot( tLeakageStart ?expr '( "tLeakageStart" ) )
tLeakageEnd = (VAR("timeC") - (0.49 * (VAR("timeC") - VAR("timeB"))))
plot( tLeakageEnd ?expr '( "tLeakageEnd" ) )
tRiseStart = cross(v("/Vline" ?result "tran") (VAR("VDDL") + (0.1 * vDiff)) 2 "rising")
plot( tRiseStart ?expr '( "tRiseStart" ) )
tFallStart = cross(v("/Vline" ?result "tran") (VAR("VDDH") - (0.1 * vDiff)) 1 "falling")
plot( tFallStart ?expr '( "tFallStart" ) )
tRiseEnd = cross(v("/Vline" ?result "tran") (VAR("VDDL") + (0.9 * vDiff)) 2 "rising")
plot( tRiseEnd ?expr '( "tRiseEnd" ) )
vDiff = (VAR("VDDH") - VAR("VDDL"))
plot( vDiff ?expr '( "vDiff" ) )
tFallEnd = cross(v("/Vline" ?result "tran") (VAR("VDDH") - (0.9 * vDiff)) 1 "falling")
plot( tFallEnd ?expr '( "tFallEnd" ) )
modelFile(
    '("/root/Desktop/Cadence/ncsu-FreePDK15/PTM-MG/smodels.scs" "")
)
run()
selectResult( 'tran )
plot(getData("/Vline") getData("/VL") getData("/VH") getData("/IVDDH/src") getData("/IVDDL/dst") getData("/ILine/src") )
TSettleRise = (tRiseSettleEnd - tRiseSettleStart)
plot( TSettleRise ?expr '( "TSettleRise" ) )
TSettleFall = (tFallSettleEnd - tFallSettleStart)
plot( TSettleFall ?expr '( "TSettleFall" ) )
LeakageLine = average(clip(i("/ILine/src" ?result "tran") tLeakageStart tLeakageEnd))
plot( LeakageLine ?expr '( "LeakageLine" ) )
LeakageIntoVDDL = average(clip(i("/IVDDL/dst" ?result "tran") tLeakageStart tLeakageEnd))
plot( LeakageIntoVDDL ?expr '( "LeakageIntoVDDL" ) )
LeakageVDDH = average(clip(i("/IVDDH/src" ?result "tran") tLeakageStart tLeakageEnd))
plot( LeakageVDDH ?expr '( "LeakageVDDH" ) )
tRiseSettleStart = cross(v("/VH" ?result "tran") (0.5 * VAR("VDDH")) 2 "falling")
plot( tRiseSettleStart ?expr '( "tRiseSettleStart" ) )
tRiseSettleEnd = cross(v("/Vline" ?result "tran") (0.99 * VAR("VDDH")) 2 "rising")
plot( tRiseSettleEnd ?expr '( "tRiseSettleEnd" ) )
tFallSettleEnd = cross(v("/Vline" ?result "tran") (1.005 * VAR("VDDL")) 1 "falling")
plot( tFallSettleEnd ?expr '( "tFallSettleEnd" ) )
tFallSettleStart = cross(v("/VH" ?result "tran") (0.5 * VAR("VDDH")) 1 "rising")
plot( tFallSettleStart ?expr '( "tFallSettleStart" ) )
QRise_pVDDH = ymax(iinteg(clip(i("/IVDDH/src" ?result "tran") tRiseSettleStart tRiseSettleEnd)))
plot( QRise_pVDDH ?expr '( "QRise_pVDDH" ) )
QFall_pVDDL = ymax(iinteg(clip(i("/IVDDL/dst" ?result "tran") tFallSettleStart tFallSettleEnd)))
plot( QFall_pVDDL ?expr '( "QFall_pVDDL" ) )
tLeakageStart = (VAR("timeB") + (0.49 * (VAR("timeC") - VAR("timeB"))))
plot( tLeakageStart ?expr '( "tLeakageStart" ) )
tLeakageEnd = (VAR("timeC") - (0.49 * (VAR("timeC") - VAR("timeB"))))
plot( tLeakageEnd ?expr '( "tLeakageEnd" ) )
tRiseStart = cross(v("/Vline" ?result "tran") (VAR("VDDL") + (0.1 * vDiff)) 2 "rising")
plot( tRiseStart ?expr '( "tRiseStart" ) )
tFallStart = cross(v("/Vline" ?result "tran") (VAR("VDDH") - (0.1 * vDiff)) 1 "falling")
plot( tFallStart ?expr '( "tFallStart" ) )
tRiseEnd = cross(v("/Vline" ?result "tran") (VAR("VDDL") + (0.9 * vDiff)) 2 "rising")
plot( tRiseEnd ?expr '( "tRiseEnd" ) )
vDiff = (VAR("VDDH") - VAR("VDDL"))
plot( vDiff ?expr '( "vDiff" ) )
tFallEnd = cross(v("/Vline" ?result "tran") (VAR("VDDH") - (0.9 * vDiff)) 1 "falling")
plot( tFallEnd ?expr '( "tFallEnd" ) )
modelFile(
    '("/root/Desktop/Cadence/ncsu-FreePDK15/PTM-MG/smodels.scs" "")
)
desVar(	  "timeC" "timeA+timeWait"	)
desVar(	  "timeB" "timeA+timerf"	)
run()
selectResult( 'tran )
plot(getData("/Vline") getData("/VL") getData("/VH") getData("/IVDDH/src") getData("/IVDDL/dst") getData("/ILine/src") )
TSettleRise = (tRiseSettleEnd - tRiseSettleStart)
plot( TSettleRise ?expr '( "TSettleRise" ) )
TSettleFall = (tFallSettleEnd - tFallSettleStart)
plot( TSettleFall ?expr '( "TSettleFall" ) )
LeakageLine = average(clip(i("/ILine/src" ?result "tran") tLeakageStart tLeakageEnd))
plot( LeakageLine ?expr '( "LeakageLine" ) )
LeakageIntoVDDL = average(clip(i("/IVDDL/dst" ?result "tran") tLeakageStart tLeakageEnd))
plot( LeakageIntoVDDL ?expr '( "LeakageIntoVDDL" ) )
LeakageVDDH = average(clip(i("/IVDDH/src" ?result "tran") tLeakageStart tLeakageEnd))
plot( LeakageVDDH ?expr '( "LeakageVDDH" ) )
tRiseSettleStart = cross(v("/VH" ?result "tran") (0.5 * VAR("VDDH")) 2 "falling")
plot( tRiseSettleStart ?expr '( "tRiseSettleStart" ) )
tRiseSettleEnd = cross(v("/Vline" ?result "tran") (0.99 * VAR("VDDH")) 2 "rising")
plot( tRiseSettleEnd ?expr '( "tRiseSettleEnd" ) )
tFallSettleEnd = cross(v("/Vline" ?result "tran") (1.005 * VAR("VDDL")) 1 "falling")
plot( tFallSettleEnd ?expr '( "tFallSettleEnd" ) )
tFallSettleStart = cross(v("/VH" ?result "tran") (0.5 * VAR("VDDH")) 1 "rising")
plot( tFallSettleStart ?expr '( "tFallSettleStart" ) )
QRise_pVDDH = ymax(iinteg(clip(i("/IVDDH/src" ?result "tran") tRiseSettleStart tRiseSettleEnd)))
plot( QRise_pVDDH ?expr '( "QRise_pVDDH" ) )
QFall_pVDDL = ymax(iinteg(clip(i("/IVDDL/dst" ?result "tran") tFallSettleStart tFallSettleEnd)))
plot( QFall_pVDDL ?expr '( "QFall_pVDDL" ) )
tLeakageStart = (VAR("timeB") + (0.49 * (VAR("timeC") - VAR("timeB"))))
plot( tLeakageStart ?expr '( "tLeakageStart" ) )
tLeakageEnd = (VAR("timeC") - (0.49 * (VAR("timeC") - VAR("timeB"))))
plot( tLeakageEnd ?expr '( "tLeakageEnd" ) )
tRiseStart = cross(v("/Vline" ?result "tran") (VAR("VDDL") + (0.1 * vDiff)) 2 "rising")
plot( tRiseStart ?expr '( "tRiseStart" ) )
tFallStart = cross(v("/Vline" ?result "tran") (VAR("VDDH") - (0.1 * vDiff)) 1 "falling")
plot( tFallStart ?expr '( "tFallStart" ) )
tRiseEnd = cross(v("/Vline" ?result "tran") (VAR("VDDL") + (0.9 * vDiff)) 2 "rising")
plot( tRiseEnd ?expr '( "tRiseEnd" ) )
vDiff = (VAR("VDDH") - VAR("VDDL"))
plot( vDiff ?expr '( "vDiff" ) )
tFallEnd = cross(v("/Vline" ?result "tran") (VAR("VDDH") - (0.9 * vDiff)) 1 "falling")
plot( tFallEnd ?expr '( "tFallEnd" ) )
modelFile(
    '("/root/Desktop/Cadence/ncsu-FreePDK15/PTM-MG/smodels.scs" "")
)
desVar(	  "timeStop" 26n	)
desVar(	  "timeF" 19.01n	)
desVar(	  "timeE" 19n	)
desVar(	  "timeD" 12.01n	)
desVar(	  "timeC" 12n	)
desVar(	  "timeB" 5.01n	)
delete( 'desVar "timeWait" )
delete( 'desVar "timerf" )
run()
selectResult( 'tran )
plot(getData("/Vline") getData("/VL") getData("/VH") getData("/IVDDH/src") getData("/IVDDL/dst") getData("/ILine/src") )
TSettleRise = (tRiseSettleEnd - tRiseSettleStart)
plot( TSettleRise ?expr '( "TSettleRise" ) )
TSettleFall = (tFallSettleEnd - tFallSettleStart)
plot( TSettleFall ?expr '( "TSettleFall" ) )
LeakageLine = average(clip(i("/ILine/src" ?result "tran") tLeakageStart tLeakageEnd))
plot( LeakageLine ?expr '( "LeakageLine" ) )
LeakageIntoVDDL = average(clip(i("/IVDDL/dst" ?result "tran") tLeakageStart tLeakageEnd))
plot( LeakageIntoVDDL ?expr '( "LeakageIntoVDDL" ) )
LeakageVDDH = average(clip(i("/IVDDH/src" ?result "tran") tLeakageStart tLeakageEnd))
plot( LeakageVDDH ?expr '( "LeakageVDDH" ) )
tRiseSettleStart = cross(v("/VH" ?result "tran") (0.5 * VAR("VDDH")) 2 "falling")
plot( tRiseSettleStart ?expr '( "tRiseSettleStart" ) )
tRiseSettleEnd = cross(v("/Vline" ?result "tran") (0.99 * VAR("VDDH")) 2 "rising")
plot( tRiseSettleEnd ?expr '( "tRiseSettleEnd" ) )
tFallSettleEnd = cross(v("/Vline" ?result "tran") (1.005 * VAR("VDDL")) 1 "falling")
plot( tFallSettleEnd ?expr '( "tFallSettleEnd" ) )
tFallSettleStart = cross(v("/VH" ?result "tran") (0.5 * VAR("VDDH")) 1 "rising")
plot( tFallSettleStart ?expr '( "tFallSettleStart" ) )
QRise_pVDDH = ymax(iinteg(clip(i("/IVDDH/src" ?result "tran") tRiseSettleStart tRiseSettleEnd)))
plot( QRise_pVDDH ?expr '( "QRise_pVDDH" ) )
QFall_pVDDL = ymax(iinteg(clip(i("/IVDDL/dst" ?result "tran") tFallSettleStart tFallSettleEnd)))
plot( QFall_pVDDL ?expr '( "QFall_pVDDL" ) )
tLeakageStart = (VAR("timeB") + (0.49 * (VAR("timeC") - VAR("timeB"))))
plot( tLeakageStart ?expr '( "tLeakageStart" ) )
tLeakageEnd = (VAR("timeC") - (0.49 * (VAR("timeC") - VAR("timeB"))))
plot( tLeakageEnd ?expr '( "tLeakageEnd" ) )
tRiseStart = cross(v("/Vline" ?result "tran") (VAR("VDDL") + (0.1 * vDiff)) 2 "rising")
plot( tRiseStart ?expr '( "tRiseStart" ) )
tFallStart = cross(v("/Vline" ?result "tran") (VAR("VDDH") - (0.1 * vDiff)) 1 "falling")
plot( tFallStart ?expr '( "tFallStart" ) )
tRiseEnd = cross(v("/Vline" ?result "tran") (VAR("VDDL") + (0.9 * vDiff)) 2 "rising")
plot( tRiseEnd ?expr '( "tRiseEnd" ) )
vDiff = (VAR("VDDH") - VAR("VDDL"))
plot( vDiff ?expr '( "vDiff" ) )
tFallEnd = cross(v("/Vline" ?result "tran") (VAR("VDDH") - (0.9 * vDiff)) 1 "falling")
plot( tFallEnd ?expr '( "tFallEnd" ) )
hostMode( 'distributed )
resultsDir( "/net/kafka/nfs/rstdenis/Cadence/simulation/Dual_Supply_Test/spectre/schematic/distributed/job003" )
modelFile(
    '("/software/cadence/ncsu-FreePDK15/hspice_16nm_hp.include" "")
)
desVar(	  "nfin" 60	)
run( ?jobName "job" ?queue "c2107" )
selectResult( 'tran )
plot(getData("/Vline") getData("/VL") getData("/VH") getData("/IVDDH/src") getData("/IVDDL/dst") getData("/ILine/src") )
TSettleRise = (tRiseSettleEnd - tRiseSettleStart)
plot( TSettleRise ?expr '( "TSettleRise" ) )
TSettleFall = (tFallSettleEnd - tFallSettleStart)
plot( TSettleFall ?expr '( "TSettleFall" ) )
LeakageLine = average(clip(i("/ILine/src" ?result "tran") tLeakageStart tLeakageEnd))
plot( LeakageLine ?expr '( "LeakageLine" ) )
LeakageIntoVDDL = average(clip(i("/IVDDL/dst" ?result "tran") tLeakageStart tLeakageEnd))
plot( LeakageIntoVDDL ?expr '( "LeakageIntoVDDL" ) )
LeakageVDDH = average(clip(i("/IVDDH/src" ?result "tran") tLeakageStart tLeakageEnd))
plot( LeakageVDDH ?expr '( "LeakageVDDH" ) )
tRiseSettleStart = cross(v("/VH" ?result "tran") (0.5 * VAR("VDDH")) 2 "falling")
plot( tRiseSettleStart ?expr '( "tRiseSettleStart" ) )
tRiseSettleEnd = cross(v("/Vline" ?result "tran") (0.99 * VAR("VDDH")) 2 "rising")
plot( tRiseSettleEnd ?expr '( "tRiseSettleEnd" ) )
tFallSettleEnd = cross(v("/Vline" ?result "tran") (1.005 * VAR("VDDL")) 1 "falling")
plot( tFallSettleEnd ?expr '( "tFallSettleEnd" ) )
tFallSettleStart = cross(v("/VH" ?result "tran") (0.5 * VAR("VDDH")) 1 "rising")
plot( tFallSettleStart ?expr '( "tFallSettleStart" ) )
QRise_pVDDH = ymax(iinteg(clip(i("/IVDDH/src" ?result "tran") tRiseSettleStart tRiseSettleEnd)))
plot( QRise_pVDDH ?expr '( "QRise_pVDDH" ) )
QFall_pVDDL = ymax(iinteg(clip(i("/IVDDL/dst" ?result "tran") tFallSettleStart tFallSettleEnd)))
plot( QFall_pVDDL ?expr '( "QFall_pVDDL" ) )
tLeakageStart = (VAR("timeB") + (0.49 * (VAR("timeC") - VAR("timeB"))))
plot( tLeakageStart ?expr '( "tLeakageStart" ) )
tLeakageEnd = (VAR("timeC") - (0.49 * (VAR("timeC") - VAR("timeB"))))
plot( tLeakageEnd ?expr '( "tLeakageEnd" ) )
tRiseStart = cross(v("/Vline" ?result "tran") (VAR("VDDL") + (0.1 * vDiff)) 2 "rising")
plot( tRiseStart ?expr '( "tRiseStart" ) )
tFallStart = cross(v("/Vline" ?result "tran") (VAR("VDDH") - (0.1 * vDiff)) 1 "falling")
plot( tFallStart ?expr '( "tFallStart" ) )
tRiseEnd = cross(v("/Vline" ?result "tran") (VAR("VDDL") + (0.9 * vDiff)) 2 "rising")
plot( tRiseEnd ?expr '( "tRiseEnd" ) )
vDiff = (VAR("VDDH") - VAR("VDDL"))
plot( vDiff ?expr '( "vDiff" ) )
tFallEnd = cross(v("/Vline" ?result "tran") (VAR("VDDH") - (0.9 * vDiff)) 1 "falling")
plot( tFallEnd ?expr '( "tFallEnd" ) )
resultsDir( "/net/kafka/nfs/rstdenis/Cadence/simulation/Dual_Supply_Test/spectre/schematic/distributed/job001" )
modelFile(
    '("/software/cadence/ncsu-FreePDK15/hspice_16nm_hp.include" "")
)
run( ?jobName "job" ?queue "c2107" )
selectResult( 'tran )
plot(getData("/Vline") getData("/VL") getData("/VH") getData("/IVDDH/src") getData("/IVDDL/dst") getData("/ILine/src") )
TSettleRise = (tRiseSettleEnd - tRiseSettleStart)
plot( TSettleRise ?expr '( "TSettleRise" ) )
TSettleFall = (tFallSettleEnd - tFallSettleStart)
plot( TSettleFall ?expr '( "TSettleFall" ) )
LeakageLine = average(clip(i("/ILine/src" ?result "tran") tLeakageStart tLeakageEnd))
plot( LeakageLine ?expr '( "LeakageLine" ) )
LeakageIntoVDDL = average(clip(i("/IVDDL/dst" ?result "tran") tLeakageStart tLeakageEnd))
plot( LeakageIntoVDDL ?expr '( "LeakageIntoVDDL" ) )
LeakageVDDH = average(clip(i("/IVDDH/src" ?result "tran") tLeakageStart tLeakageEnd))
plot( LeakageVDDH ?expr '( "LeakageVDDH" ) )
tRiseSettleStart = cross(v("/VH" ?result "tran") (0.5 * VAR("VDDH")) 2 "falling")
plot( tRiseSettleStart ?expr '( "tRiseSettleStart" ) )
tRiseSettleEnd = cross(v("/Vline" ?result "tran") (0.99 * VAR("VDDH")) 2 "rising")
plot( tRiseSettleEnd ?expr '( "tRiseSettleEnd" ) )
tFallSettleEnd = cross(v("/Vline" ?result "tran") (1.005 * VAR("VDDL")) 1 "falling")
plot( tFallSettleEnd ?expr '( "tFallSettleEnd" ) )
tFallSettleStart = cross(v("/VH" ?result "tran") (0.5 * VAR("VDDH")) 1 "rising")
plot( tFallSettleStart ?expr '( "tFallSettleStart" ) )
QRise_pVDDH = ymax(iinteg(clip(i("/IVDDH/src" ?result "tran") tRiseSettleStart tRiseSettleEnd)))
plot( QRise_pVDDH ?expr '( "QRise_pVDDH" ) )
QFall_pVDDL = ymax(iinteg(clip(i("/IVDDL/dst" ?result "tran") tFallSettleStart tFallSettleEnd)))
plot( QFall_pVDDL ?expr '( "QFall_pVDDL" ) )
tLeakageStart = (VAR("timeB") + (0.49 * (VAR("timeC") - VAR("timeB"))))
plot( tLeakageStart ?expr '( "tLeakageStart" ) )
tLeakageEnd = (VAR("timeC") - (0.49 * (VAR("timeC") - VAR("timeB"))))
plot( tLeakageEnd ?expr '( "tLeakageEnd" ) )
tRiseStart = cross(v("/Vline" ?result "tran") (VAR("VDDL") + (0.1 * vDiff)) 2 "rising")
plot( tRiseStart ?expr '( "tRiseStart" ) )
tFallStart = cross(v("/Vline" ?result "tran") (VAR("VDDH") - (0.1 * vDiff)) 1 "falling")
plot( tFallStart ?expr '( "tFallStart" ) )
tRiseEnd = cross(v("/Vline" ?result "tran") (VAR("VDDL") + (0.9 * vDiff)) 2 "rising")
plot( tRiseEnd ?expr '( "tRiseEnd" ) )
vDiff = (VAR("VDDH") - VAR("VDDL"))
plot( vDiff ?expr '( "vDiff" ) )
tFallEnd = cross(v("/Vline" ?result "tran") (VAR("VDDH") - (0.9 * vDiff)) 1 "falling")
plot( tFallEnd ?expr '( "tFallEnd" ) )
hostMode( 'local )
resultsDir( "/net/kafka/nfs/rstdenis/Cadence/simulation/Dual_Supply_Test/spectre/schematic" )
modelFile(
    '("/software/cadence/ncsu-FreePDK15/hspice_16nm_hp.include" "")
)
run()
selectResult( 'tran )
plot(getData("/Vline") getData("/VL") getData("/VH") getData("/IVDDH/src") getData("/IVDDL/dst") getData("/ILine/src") )
TSettleRise = (tRiseSettleEnd - tRiseSettleStart)
plot( TSettleRise ?expr '( "TSettleRise" ) )
TSettleFall = (tFallSettleEnd - tFallSettleStart)
plot( TSettleFall ?expr '( "TSettleFall" ) )
LeakageLine = average(clip(i("/ILine/src" ?result "tran") tLeakageStart tLeakageEnd))
plot( LeakageLine ?expr '( "LeakageLine" ) )
LeakageIntoVDDL = average(clip(i("/IVDDL/dst" ?result "tran") tLeakageStart tLeakageEnd))
plot( LeakageIntoVDDL ?expr '( "LeakageIntoVDDL" ) )
LeakageVDDH = average(clip(i("/IVDDH/src" ?result "tran") tLeakageStart tLeakageEnd))
plot( LeakageVDDH ?expr '( "LeakageVDDH" ) )
tRiseSettleStart = cross(v("/VH" ?result "tran") (0.5 * VAR("VDDH")) 2 "falling")
plot( tRiseSettleStart ?expr '( "tRiseSettleStart" ) )
tRiseSettleEnd = cross(v("/Vline" ?result "tran") (0.99 * VAR("VDDH")) 2 "rising")
plot( tRiseSettleEnd ?expr '( "tRiseSettleEnd" ) )
tFallSettleEnd = cross(v("/Vline" ?result "tran") (1.005 * VAR("VDDL")) 1 "falling")
plot( tFallSettleEnd ?expr '( "tFallSettleEnd" ) )
tFallSettleStart = cross(v("/VH" ?result "tran") (0.5 * VAR("VDDH")) 1 "rising")
plot( tFallSettleStart ?expr '( "tFallSettleStart" ) )
QRise_pVDDH = ymax(iinteg(clip(i("/IVDDH/src" ?result "tran") tRiseSettleStart tRiseSettleEnd)))
plot( QRise_pVDDH ?expr '( "QRise_pVDDH" ) )
QFall_pVDDL = ymax(iinteg(clip(i("/IVDDL/dst" ?result "tran") tFallSettleStart tFallSettleEnd)))
plot( QFall_pVDDL ?expr '( "QFall_pVDDL" ) )
tLeakageStart = (VAR("timeB") + (0.49 * (VAR("timeC") - VAR("timeB"))))
plot( tLeakageStart ?expr '( "tLeakageStart" ) )
tLeakageEnd = (VAR("timeC") - (0.49 * (VAR("timeC") - VAR("timeB"))))
plot( tLeakageEnd ?expr '( "tLeakageEnd" ) )
tRiseStart = cross(v("/Vline" ?result "tran") (VAR("VDDL") + (0.1 * vDiff)) 2 "rising")
plot( tRiseStart ?expr '( "tRiseStart" ) )
tFallStart = cross(v("/Vline" ?result "tran") (VAR("VDDH") - (0.1 * vDiff)) 1 "falling")
plot( tFallStart ?expr '( "tFallStart" ) )
tRiseEnd = cross(v("/Vline" ?result "tran") (VAR("VDDL") + (0.9 * vDiff)) 2 "rising")
plot( tRiseEnd ?expr '( "tRiseEnd" ) )
vDiff = (VAR("VDDH") - VAR("VDDL"))
plot( vDiff ?expr '( "vDiff" ) )
tFallEnd = cross(v("/Vline" ?result "tran") (VAR("VDDH") - (0.9 * vDiff)) 1 "falling")
plot( tFallEnd ?expr '( "tFallEnd" ) )
modelFile(
    '("/software/cadence/ncsu-FreePDK15/hspice_16nm_hp.include" "")
)
run()
selectResult( 'tran )
plot(getData("/Vline") getData("/VL") getData("/VH") getData("/IVDDH/src") getData("/IVDDL/dst") getData("/ILine/src") )
TSettleRise = (tRiseSettleEnd - tRiseSettleStart)
plot( TSettleRise ?expr '( "TSettleRise" ) )
TSettleFall = (tFallSettleEnd - tFallSettleStart)
plot( TSettleFall ?expr '( "TSettleFall" ) )
LeakageLine = average(clip(i("/ILine/src" ?result "tran") tLeakageStart tLeakageEnd))
plot( LeakageLine ?expr '( "LeakageLine" ) )
LeakageIntoVDDL = average(clip(i("/IVDDL/dst" ?result "tran") tLeakageStart tLeakageEnd))
plot( LeakageIntoVDDL ?expr '( "LeakageIntoVDDL" ) )
LeakageVDDH = average(clip(i("/IVDDH/src" ?result "tran") tLeakageStart tLeakageEnd))
plot( LeakageVDDH ?expr '( "LeakageVDDH" ) )
tRiseSettleStart = cross(v("/VH" ?result "tran") (0.5 * VAR("VDDH")) 2 "falling")
plot( tRiseSettleStart ?expr '( "tRiseSettleStart" ) )
tRiseSettleEnd = cross(v("/Vline" ?result "tran") (0.99 * VAR("VDDH")) 2 "rising")
plot( tRiseSettleEnd ?expr '( "tRiseSettleEnd" ) )
tFallSettleEnd = cross(v("/Vline" ?result "tran") (1.005 * VAR("VDDL")) 1 "falling")
plot( tFallSettleEnd ?expr '( "tFallSettleEnd" ) )
tFallSettleStart = cross(v("/VH" ?result "tran") (0.5 * VAR("VDDH")) 1 "rising")
plot( tFallSettleStart ?expr '( "tFallSettleStart" ) )
QRise_pVDDH = ymax(iinteg(clip(i("/IVDDH/src" ?result "tran") tRiseSettleStart tRiseSettleEnd)))
plot( QRise_pVDDH ?expr '( "QRise_pVDDH" ) )
QFall_pVDDL = ymax(iinteg(clip(i("/IVDDL/dst" ?result "tran") tFallSettleStart tFallSettleEnd)))
plot( QFall_pVDDL ?expr '( "QFall_pVDDL" ) )
tLeakageStart = (VAR("timeB") + (0.49 * (VAR("timeC") - VAR("timeB"))))
plot( tLeakageStart ?expr '( "tLeakageStart" ) )
tLeakageEnd = (VAR("timeC") - (0.49 * (VAR("timeC") - VAR("timeB"))))
plot( tLeakageEnd ?expr '( "tLeakageEnd" ) )
tRiseStart = cross(v("/Vline" ?result "tran") (VAR("VDDL") + (0.1 * vDiff)) 2 "rising")
plot( tRiseStart ?expr '( "tRiseStart" ) )
tFallStart = cross(v("/Vline" ?result "tran") (VAR("VDDH") - (0.1 * vDiff)) 1 "falling")
plot( tFallStart ?expr '( "tFallStart" ) )
tRiseEnd = cross(v("/Vline" ?result "tran") (VAR("VDDL") + (0.9 * vDiff)) 2 "rising")
plot( tRiseEnd ?expr '( "tRiseEnd" ) )
vDiff = (VAR("VDDH") - VAR("VDDL"))
plot( vDiff ?expr '( "vDiff" ) )
tFallEnd = cross(v("/Vline" ?result "tran") (VAR("VDDH") - (0.9 * vDiff)) 1 "falling")
plot( tFallEnd ?expr '( "tFallEnd" ) )
modelFile(
    '("/software/cadence/ncsu-FreePDK15/hspice_16nm_hp.include" "")
)
save( 'i "/V0/MINUS" "/V0/PLUS" )
run()
selectResult( 'tran )
plot(getData("/Vline") getData("/VL") getData("/VH") getData("/IVDDH/src") getData("/IVDDL/dst") getData("/ILine/src") getData("/V0/MINUS") getData("/V0/PLUS") )
TSettleRise = (tRiseSettleEnd - tRiseSettleStart)
plot( TSettleRise ?expr '( "TSettleRise" ) )
TSettleFall = (tFallSettleEnd - tFallSettleStart)
plot( TSettleFall ?expr '( "TSettleFall" ) )
LeakageLine = average(clip(i("/ILine/src" ?result "tran") tLeakageStart tLeakageEnd))
plot( LeakageLine ?expr '( "LeakageLine" ) )
LeakageIntoVDDL = average(clip(i("/IVDDL/dst" ?result "tran") tLeakageStart tLeakageEnd))
plot( LeakageIntoVDDL ?expr '( "LeakageIntoVDDL" ) )
LeakageVDDH = average(clip(i("/IVDDH/src" ?result "tran") tLeakageStart tLeakageEnd))
plot( LeakageVDDH ?expr '( "LeakageVDDH" ) )
tRiseSettleStart = cross(v("/VH" ?result "tran") (0.5 * VAR("VDDH")) 2 "falling")
plot( tRiseSettleStart ?expr '( "tRiseSettleStart" ) )
tRiseSettleEnd = cross(v("/Vline" ?result "tran") (0.99 * VAR("VDDH")) 2 "rising")
plot( tRiseSettleEnd ?expr '( "tRiseSettleEnd" ) )
tFallSettleEnd = cross(v("/Vline" ?result "tran") (1.005 * VAR("VDDL")) 1 "falling")
plot( tFallSettleEnd ?expr '( "tFallSettleEnd" ) )
tFallSettleStart = cross(v("/VH" ?result "tran") (0.5 * VAR("VDDH")) 1 "rising")
plot( tFallSettleStart ?expr '( "tFallSettleStart" ) )
QRise_pVDDH = ymax(iinteg(clip(i("/IVDDH/src" ?result "tran") tRiseSettleStart tRiseSettleEnd)))
plot( QRise_pVDDH ?expr '( "QRise_pVDDH" ) )
QFall_pVDDL = ymax(iinteg(clip(i("/IVDDL/dst" ?result "tran") tFallSettleStart tFallSettleEnd)))
plot( QFall_pVDDL ?expr '( "QFall_pVDDL" ) )
tLeakageStart = (VAR("timeB") + (0.49 * (VAR("timeC") - VAR("timeB"))))
plot( tLeakageStart ?expr '( "tLeakageStart" ) )
tLeakageEnd = (VAR("timeC") - (0.49 * (VAR("timeC") - VAR("timeB"))))
plot( tLeakageEnd ?expr '( "tLeakageEnd" ) )
tRiseStart = cross(v("/Vline" ?result "tran") (VAR("VDDL") + (0.1 * vDiff)) 2 "rising")
plot( tRiseStart ?expr '( "tRiseStart" ) )
tFallStart = cross(v("/Vline" ?result "tran") (VAR("VDDH") - (0.1 * vDiff)) 1 "falling")
plot( tFallStart ?expr '( "tFallStart" ) )
tRiseEnd = cross(v("/Vline" ?result "tran") (VAR("VDDL") + (0.9 * vDiff)) 2 "rising")
plot( tRiseEnd ?expr '( "tRiseEnd" ) )
vDiff = (VAR("VDDH") - VAR("VDDL"))
plot( vDiff ?expr '( "vDiff" ) )
tFallEnd = cross(v("/Vline" ?result "tran") (VAR("VDDH") - (0.9 * vDiff)) 1 "falling")
plot( tFallEnd ?expr '( "tFallEnd" ) )
modelFile(
    '("/software/cadence/ncsu-FreePDK15/hspice_16nm_hp.include" "")
)
desVar(	  "timeStop" 40n	)
desVar(	  "timeA" "startDelay"	)
delete( 'desVar "timeF" )
delete( 'desVar "timeE" )
delete( 'desVar "timeD" )
delete( 'desVar "timeC" )
delete( 'desVar "timeB" )
run()
selectResult( 'tran )
plot(getData("/Vline") getData("/VL") getData("/VH") getData("/IVDDH/src") getData("/IVDDL/dst") getData("/ILine/src") getData("/V0/MINUS") getData("/V0/PLUS") )
TSettleRise = (tRiseSettleEnd - tRiseSettleStart)
plot( TSettleRise ?expr '( "TSettleRise" ) )
TSettleFall = (tFallSettleEnd - tFallSettleStart)
plot( TSettleFall ?expr '( "TSettleFall" ) )
LeakageLine = average(clip(i("/ILine/src" ?result "tran") tLeakageStart tLeakageEnd))
plot( LeakageLine ?expr '( "LeakageLine" ) )
LeakageIntoVDDL = average(clip(i("/IVDDL/dst" ?result "tran") tLeakageStart tLeakageEnd))
plot( LeakageIntoVDDL ?expr '( "LeakageIntoVDDL" ) )
LeakageVDDH = average(clip(i("/IVDDH/src" ?result "tran") tLeakageStart tLeakageEnd))
plot( LeakageVDDH ?expr '( "LeakageVDDH" ) )
tRiseSettleStart = cross(v("/VH" ?result "tran") (0.5 * VAR("VDDH")) 2 "falling")
plot( tRiseSettleStart ?expr '( "tRiseSettleStart" ) )
tRiseSettleEnd = cross(v("/Vline" ?result "tran") (0.99 * VAR("VDDH")) 2 "rising")
plot( tRiseSettleEnd ?expr '( "tRiseSettleEnd" ) )
tFallSettleEnd = cross(v("/Vline" ?result "tran") (1.005 * VAR("VDDL")) 1 "falling")
plot( tFallSettleEnd ?expr '( "tFallSettleEnd" ) )
tFallSettleStart = cross(v("/VH" ?result "tran") (0.5 * VAR("VDDH")) 1 "rising")
plot( tFallSettleStart ?expr '( "tFallSettleStart" ) )
QRise_pVDDH = ymax(iinteg(clip(i("/IVDDH/src" ?result "tran") tRiseSettleStart tRiseSettleEnd)))
plot( QRise_pVDDH ?expr '( "QRise_pVDDH" ) )
QFall_pVDDL = ymax(iinteg(clip(i("/IVDDL/dst" ?result "tran") tFallSettleStart tFallSettleEnd)))
plot( QFall_pVDDL ?expr '( "QFall_pVDDL" ) )
tLeakageStart = (VAR("timeB") + (0.49 * (VAR("timeC") - VAR("timeB"))))
plot( tLeakageStart ?expr '( "tLeakageStart" ) )
tLeakageEnd = (VAR("timeC") - (0.49 * (VAR("timeC") - VAR("timeB"))))
plot( tLeakageEnd ?expr '( "tLeakageEnd" ) )
tRiseStart = cross(v("/Vline" ?result "tran") (VAR("VDDL") + (0.1 * vDiff)) 2 "rising")
plot( tRiseStart ?expr '( "tRiseStart" ) )
tFallStart = cross(v("/Vline" ?result "tran") (VAR("VDDH") - (0.1 * vDiff)) 1 "falling")
plot( tFallStart ?expr '( "tFallStart" ) )
tRiseEnd = cross(v("/Vline" ?result "tran") (VAR("VDDL") + (0.9 * vDiff)) 2 "rising")
plot( tRiseEnd ?expr '( "tRiseEnd" ) )
vDiff = (VAR("VDDH") - VAR("VDDL"))
plot( vDiff ?expr '( "vDiff" ) )
tFallEnd = cross(v("/Vline" ?result "tran") (VAR("VDDH") - (0.9 * vDiff)) 1 "falling")
plot( tFallEnd ?expr '( "tFallEnd" ) )
modelFile(
    '("/software/cadence/ncsu-FreePDK15/hspice_16nm_hp.include" "")
)
desVar(	  "timeStop" 32n	)
converge( 'ic "/net035" "0" )
run()
selectResult( 'tran )
plot(getData("/Vline") getData("/VL") getData("/VH") getData("/IVDDH/src") getData("/IVDDL/dst") getData("/ILine/src") getData("/V0/MINUS") getData("/V0/PLUS") )
LeakageLine = average(clip(i("/ILine/src" ?result "tran") tLeakageStart tLeakageEnd))
plot( LeakageLine ?expr '( "LeakageLine" ) )
LeakageIntoVDDL = average(clip(i("/IVDDL/dst" ?result "tran") tLeakageStart tLeakageEnd))
plot( LeakageIntoVDDL ?expr '( "LeakageIntoVDDL" ) )
LeakageVDDH = average(clip(i("/IVDDH/src" ?result "tran") tLeakageStart tLeakageEnd))
plot( LeakageVDDH ?expr '( "LeakageVDDH" ) )
tLeakageStart = (VAR("timeB") + (0.49 * (VAR("timeC") - VAR("timeB"))))
plot( tLeakageStart ?expr '( "tLeakageStart" ) )
tLeakageEnd = (VAR("timeC") - (0.49 * (VAR("timeC") - VAR("timeB"))))
plot( tLeakageEnd ?expr '( "tLeakageEnd" ) )
vDiff = (VAR("VDDH") - VAR("VDDL"))
plot( vDiff ?expr '( "vDiff" ) )
tRiseSettleEnd = cross(v("/Vline" ?result "tran") (0.99 * VAR("VDDH")) 2 "rising")
plot( tRiseSettleEnd ?expr '( "tRiseSettleEnd" ) )
tRiseEnd = cross(v("/Vline" ?result "tran") (VAR("VDDL") + (0.9 * vDiff)) 2 "rising")
plot( tRiseEnd ?expr '( "tRiseEnd" ) )
tFallStart = cross(v("/Vline" ?result "tran") (VAR("VDDH") - (0.1 * vDiff)) 2 "falling")
plot( tFallStart ?expr '( "tFallStart" ) )
tRiseStart = cross(v("/Vline" ?result "tran") (VAR("VDDL") + (0.1 * vDiff)) 2 "rising")
plot( tRiseStart ?expr '( "tRiseStart" ) )
tRiseSettleStart = cross(v("/VH" ?result "tran") (0.5 * VAR("VDDH")) 2 "falling")
plot( tRiseSettleStart ?expr '( "tRiseSettleStart" ) )
TSettleRise = (tRiseSettleEnd - tRiseSettleStart)
plot( TSettleRise ?expr '( "TSettleRise" ) )
tFallSettleEnd = cross(v("/Vline" ?result "tran") (1.005 * VAR("VDDL")) 2 "falling")
plot( tFallSettleEnd ?expr '( "tFallSettleEnd" ) )
tFallEnd = cross(v("/Vline" ?result "tran") (VAR("VDDH") - (0.9 * vDiff)) 2 "falling")
plot( tFallEnd ?expr '( "tFallEnd" ) )
tFallSettleStart = cross(v("/VH" ?result "tran") (0.5 * VAR("VDDH")) 2 "rising")
plot( tFallSettleStart ?expr '( "tFallSettleStart" ) )
TSettleFall = (tFallSettleEnd - tFallSettleStart)
plot( TSettleFall ?expr '( "TSettleFall" ) )
QRise_pVDDH = ymax(iinteg(clip(i("/IVDDH/src" ?result "tran") tRiseSettleStart tRiseSettleEnd)))
plot( QRise_pVDDH ?expr '( "QRise_pVDDH" ) )
QFall_pVDDL = ymax(iinteg(clip(i("/IVDDL/dst" ?result "tran") tFallSettleStart tFallSettleEnd)))
plot( QFall_pVDDL ?expr '( "QFall_pVDDL" ) )
modelFile(
    '("/software/cadence/ncsu-FreePDK15/hspice_16nm_hp.include" "")
)
delete( 'desVar "timeA" )
desVar(	  "startDelay" 5n	)
desVar(	  "period" 14n	)
desVar(	  "pulseWidth" ""	)
run()
selectResult( 'tran )
plot(getData("/Vline") getData("/VL") getData("/VH") getData("/IVDDH/src") getData("/IVDDL/dst") getData("/ILine/src") getData("/V0/MINUS") getData("/V0/PLUS") )
LeakageLine = average(clip(i("/ILine/src" ?result "tran") tLeakageStart tLeakageEnd))
plot( LeakageLine ?expr '( "LeakageLine" ) )
LeakageIntoVDDL = average(clip(i("/IVDDL/dst" ?result "tran") tLeakageStart tLeakageEnd))
plot( LeakageIntoVDDL ?expr '( "LeakageIntoVDDL" ) )
LeakageVDDH = average(clip(i("/IVDDH/src" ?result "tran") tLeakageStart tLeakageEnd))
plot( LeakageVDDH ?expr '( "LeakageVDDH" ) )
tLeakageStart = (VAR("timeB") + (0.49 * (VAR("timeC") - VAR("timeB"))))
plot( tLeakageStart ?expr '( "tLeakageStart" ) )
tLeakageEnd = (VAR("timeC") - (0.49 * (VAR("timeC") - VAR("timeB"))))
plot( tLeakageEnd ?expr '( "tLeakageEnd" ) )
tRiseSettleEnd = cross(clip(v("/Vline" ?result "tran") clipStart VAR("timeStop")) (0.99 * VAR("VDDH")) 1 "rising")
plot( tRiseSettleEnd ?expr '( "tRiseSettleEnd" ) )
tRiseEnd = cross(clip(v("/Vline" ?result "tran") clipStart VAR("timeStop")) (VAR("VDDL") + (0.9 * vDiff)) 1 "rising")
plot( tRiseEnd ?expr '( "tRiseEnd" ) )
tFallStart = cross(clip(v("/Vline" ?result "tran") clipStart VAR("timeStop")) (VAR("VDDH") - (0.1 * vDiff)) 1 "falling")
plot( tFallStart ?expr '( "tFallStart" ) )
TSettleRise = (tRiseSettleEnd - tRiseSettleStart)
plot( TSettleRise ?expr '( "TSettleRise" ) )
vDiff = (VAR("VDDH") - VAR("VDDL"))
plot( vDiff ?expr '( "vDiff" ) )
tFallSettleEnd = cross(clip(v("/Vline" ?result "tran") clipStart VAR("timeStop")) (1.005 * VAR("VDDL")) "falling")
plot( tFallSettleEnd ?expr '( "tFallSettleEnd" ) )
tFallEnd = cross((cilp v("/Vline" ?result "tran") clipStart VAR("timeStop")) (VAR("VDDH") - (0.9 * vDiff)) 1 "falling")
plot( tFallEnd ?expr '( "tFallEnd" ) )
tFallSettleStart = cross(clip(v("/VH" ?result "tran") clipStart VAR("timeStop")) (0.5 * VAR("VDDH")) 1 "rising")
plot( tFallSettleStart ?expr '( "tFallSettleStart" ) )
tRiseStart = cross(clip(v("/Vline" ?result "tran") clipStart VAR("timeStop")) (VAR("VDDL") + (0.1 * vDiff)) 1 "rising")
plot( tRiseStart ?expr '( "tRiseStart" ) )
tRiseSettleStart = cross(clip(v("/VH" ?result "tran") clipStart VAR("timeStop")) (0.5 * VAR("VDDH")) 1 "falling")
plot( tRiseSettleStart ?expr '( "tRiseSettleStart" ) )
TSettleFall = (tFallSettleEnd - tFallSettleStart)
plot( TSettleFall ?expr '( "TSettleFall" ) )
QRise_pVDDH = ymax(iinteg(clip(i("/IVDDH/src" ?result "tran") tRiseSettleStart tRiseSettleEnd)))
plot( QRise_pVDDH ?expr '( "QRise_pVDDH" ) )
QFall_pVDDL = ymax(iinteg(clip(i("/IVDDL/dst" ?result "tran") tFallSettleStart tFallSettleEnd)))
plot( QFall_pVDDL ?expr '( "QFall_pVDDL" ) )
clipStart = (1.5 * VAR("period"))
plot( clipStart ?expr '( "clipStart" ) )
plot( cross(clip(v("/VH" ?result "tran") clipStart VAR("timeStop")) (0.5 * VAR("VDDH")) 1 "rising") )
modelFile(
    '("/software/cadence/ncsu-FreePDK15/hspice_16nm_hp.include" "")
)
run()
selectResult( 'tran )
plot(getData("/Vline") getData("/VL") getData("/VH") getData("/IVDDH/src") getData("/IVDDL/dst") getData("/ILine/src") getData("/V0/MINUS") getData("/V0/PLUS") )
LeakageLine = average(clip(i("/ILine/src" ?result "tran") tLeakageStart tLeakageEnd))
plot( LeakageLine ?expr '( "LeakageLine" ) )
LeakageIntoVDDL = average(clip(i("/IVDDL/dst" ?result "tran") tLeakageStart tLeakageEnd))
plot( LeakageIntoVDDL ?expr '( "LeakageIntoVDDL" ) )
LeakageVDDH = average(clip(i("/IVDDH/src" ?result "tran") tLeakageStart tLeakageEnd))
plot( LeakageVDDH ?expr '( "LeakageVDDH" ) )
tLeakageStart = (VAR("timeB") + (0.49 * (VAR("timeC") - VAR("timeB"))))
plot( tLeakageStart ?expr '( "tLeakageStart" ) )
tLeakageEnd = (VAR("timeC") - (0.49 * (VAR("timeC") - VAR("timeB"))))
plot( tLeakageEnd ?expr '( "tLeakageEnd" ) )
tRiseSettleEnd = cross(clip(v("/Vline" ?result "tran") clipStart VAR("timeStop")) (0.99 * VAR("VDDH")) 1 "rising")
plot( tRiseSettleEnd ?expr '( "tRiseSettleEnd" ) )
tRiseEnd = cross(clip(v("/Vline" ?result "tran") clipStart VAR("timeStop")) (VAR("VDDL") + (0.9 * vDiff)) 1 "rising")
plot( tRiseEnd ?expr '( "tRiseEnd" ) )
tFallStart = cross(clip(v("/Vline" ?result "tran") clipStart VAR("timeStop")) (VAR("VDDH") - (0.1 * vDiff)) 1 "falling")
plot( tFallStart ?expr '( "tFallStart" ) )
TSettleRise = (tRiseSettleEnd - tRiseSettleStart)
plot( TSettleRise ?expr '( "TSettleRise" ) )
vDiff = (VAR("VDDH") - VAR("VDDL"))
plot( vDiff ?expr '( "vDiff" ) )
tFallSettleEnd = cross(clip(v("/Vline" ?result "tran") clipStart VAR("timeStop")) (1.005 * VAR("VDDL")) "falling")
plot( tFallSettleEnd ?expr '( "tFallSettleEnd" ) )
tFallEnd = cross((cilp v("/Vline" ?result "tran") clipStart VAR("timeStop")) (VAR("VDDH") - (0.9 * vDiff)) 1 "falling")
plot( tFallEnd ?expr '( "tFallEnd" ) )
tFallSettleStart = cross(clip(v("/VH" ?result "tran") clipStart VAR("timeStop")) (0.5 * VAR("VDDH")) 1 "rising")
plot( tFallSettleStart ?expr '( "tFallSettleStart" ) )
tRiseStart = cross(clip(v("/Vline" ?result "tran") clipStart VAR("timeStop")) (VAR("VDDL") + (0.1 * vDiff)) 1 "rising")
plot( tRiseStart ?expr '( "tRiseStart" ) )
tRiseSettleStart = cross(clip(v("/VH" ?result "tran") clipStart VAR("timeStop")) (0.5 * VAR("VDDH")) 1 "falling")
plot( tRiseSettleStart ?expr '( "tRiseSettleStart" ) )
TSettleFall = (tFallSettleEnd - tFallSettleStart)
plot( TSettleFall ?expr '( "TSettleFall" ) )
QRise_pVDDH = ymax(iinteg(clip(i("/IVDDH/src" ?result "tran") tRiseSettleStart tRiseSettleEnd)))
plot( QRise_pVDDH ?expr '( "QRise_pVDDH" ) )
QFall_pVDDL = ymax(iinteg(clip(i("/IVDDL/dst" ?result "tran") tFallSettleStart tFallSettleEnd)))
plot( QFall_pVDDL ?expr '( "QFall_pVDDL" ) )
clipStart = (1.5 * VAR("period"))
plot( clipStart ?expr '( "clipStart" ) )
plot( cross(clip(v("/VH" ?result "tran") clipStart VAR("timeStop")) (0.5 * VAR("VDDH")) 1 "rising") )
modelFile(
    '("/software/cadence/ncsu-FreePDK15/hspice_16nm_hp.include" "")
)
desVar(	  "pulseWidth" 7n	)
run()
selectResult( 'tran )
plot(getData("/Vline") getData("/VL") getData("/VH") getData("/IVDDH/src") getData("/IVDDL/dst") getData("/ILine/src") getData("/V0/MINUS") getData("/V0/PLUS") )
LeakageLine = average(clip(i("/ILine/src" ?result "tran") tLeakageStart tLeakageEnd))
plot( LeakageLine ?expr '( "LeakageLine" ) )
LeakageIntoVDDL = average(clip(i("/IVDDL/dst" ?result "tran") tLeakageStart tLeakageEnd))
plot( LeakageIntoVDDL ?expr '( "LeakageIntoVDDL" ) )
LeakageVDDH = average(clip(i("/IVDDH/src" ?result "tran") tLeakageStart tLeakageEnd))
plot( LeakageVDDH ?expr '( "LeakageVDDH" ) )
tLeakageStart = (VAR("timeB") + (0.49 * (VAR("timeC") - VAR("timeB"))))
plot( tLeakageStart ?expr '( "tLeakageStart" ) )
tLeakageEnd = (VAR("timeC") - (0.49 * (VAR("timeC") - VAR("timeB"))))
plot( tLeakageEnd ?expr '( "tLeakageEnd" ) )
tRiseSettleEnd = cross(clip(v("/Vline" ?result "tran") clipStart VAR("timeStop")) (0.99 * VAR("VDDH")) 1 "rising")
plot( tRiseSettleEnd ?expr '( "tRiseSettleEnd" ) )
tRiseEnd = cross(clip(v("/Vline" ?result "tran") clipStart VAR("timeStop")) (VAR("VDDL") + (0.9 * vDiff)) 1 "rising")
plot( tRiseEnd ?expr '( "tRiseEnd" ) )
tFallStart = cross(clip(v("/Vline" ?result "tran") clipStart VAR("timeStop")) (VAR("VDDH") - (0.1 * vDiff)) 1 "falling")
plot( tFallStart ?expr '( "tFallStart" ) )
TSettleRise = (tRiseSettleEnd - tRiseSettleStart)
plot( TSettleRise ?expr '( "TSettleRise" ) )
vDiff = (VAR("VDDH") - VAR("VDDL"))
plot( vDiff ?expr '( "vDiff" ) )
tFallSettleEnd = cross(clip(v("/Vline" ?result "tran") clipStart VAR("timeStop")) (1.005 * VAR("VDDL")) "falling")
plot( tFallSettleEnd ?expr '( "tFallSettleEnd" ) )
tFallEnd = cross((cilp v("/Vline" ?result "tran") clipStart VAR("timeStop")) (VAR("VDDH") - (0.9 * vDiff)) 1 "falling")
plot( tFallEnd ?expr '( "tFallEnd" ) )
tFallSettleStart = cross(clip(v("/VH" ?result "tran") clipStart VAR("timeStop")) (0.5 * VAR("VDDH")) 1 "rising")
plot( tFallSettleStart ?expr '( "tFallSettleStart" ) )
tRiseStart = cross(clip(v("/Vline" ?result "tran") clipStart VAR("timeStop")) (VAR("VDDL") + (0.1 * vDiff)) 1 "rising")
plot( tRiseStart ?expr '( "tRiseStart" ) )
tRiseSettleStart = cross(clip(v("/VH" ?result "tran") clipStart VAR("timeStop")) (0.5 * VAR("VDDH")) 1 "falling")
plot( tRiseSettleStart ?expr '( "tRiseSettleStart" ) )
TSettleFall = (tFallSettleEnd - tFallSettleStart)
plot( TSettleFall ?expr '( "TSettleFall" ) )
QRise_pVDDH = ymax(iinteg(clip(i("/IVDDH/src" ?result "tran") tRiseSettleStart tRiseSettleEnd)))
plot( QRise_pVDDH ?expr '( "QRise_pVDDH" ) )
QFall_pVDDL = ymax(iinteg(clip(i("/IVDDL/dst" ?result "tran") tFallSettleStart tFallSettleEnd)))
plot( QFall_pVDDL ?expr '( "QFall_pVDDL" ) )
clipStart = (1.5 * VAR("period"))
plot( clipStart ?expr '( "clipStart" ) )
plot( cross(clip(v("/VH" ?result "tran") clipStart VAR("timeStop")) (0.5 * VAR("VDDH")) 1 "rising") )
modelFile(
    '("/software/cadence/ncsu-FreePDK15/hspice_16nm_hp.include" "")
)
run()
selectResult( 'tran )
plot(getData("/Vline") getData("/VL") getData("/VH") getData("/IVDDH/src") getData("/IVDDL/dst") getData("/ILine/src") getData("/V0/MINUS") getData("/V0/PLUS") )
LeakageLine = average(clip(i("/ILine/src" ?result "tran") tLeakageStart tLeakageEnd))
plot( LeakageLine ?expr '( "LeakageLine" ) )
LeakageIntoVDDL = average(clip(i("/IVDDL/dst" ?result "tran") tLeakageStart tLeakageEnd))
plot( LeakageIntoVDDL ?expr '( "LeakageIntoVDDL" ) )
LeakageVDDH = average(clip(i("/IVDDH/src" ?result "tran") tLeakageStart tLeakageEnd))
plot( LeakageVDDH ?expr '( "LeakageVDDH" ) )
tLeakageStart = (VAR("timeB") + (0.49 * (VAR("timeC") - VAR("timeB"))))
plot( tLeakageStart ?expr '( "tLeakageStart" ) )
tLeakageEnd = (VAR("timeC") - (0.49 * (VAR("timeC") - VAR("timeB"))))
plot( tLeakageEnd ?expr '( "tLeakageEnd" ) )
tRiseSettleEnd = cross(clip(v("/Vline" ?result "tran") clipStart VAR("timeStop")) (0.99 * VAR("VDDH")) 1 "rising")
plot( tRiseSettleEnd ?expr '( "tRiseSettleEnd" ) )
tRiseEnd = cross(clip(v("/Vline" ?result "tran") clipStart VAR("timeStop")) (VAR("VDDL") + (0.9 * vDiff)) 1 "rising")
plot( tRiseEnd ?expr '( "tRiseEnd" ) )
TSettleRise = (tRiseSettleEnd - tRiseSettleStart)
plot( TSettleRise ?expr '( "TSettleRise" ) )
tFallSettleEnd = cross(clip(v("/Vline" ?result "tran") clipStart VAR("timeStop")) (1.005 * VAR("VDDL")) "falling")
plot( tFallSettleEnd ?expr '( "tFallSettleEnd" ) )
tFallEnd = cross((cilp v("/Vline" ?result "tran") clipStart VAR("timeStop")) (VAR("VDDH") - (0.9 * vDiff)) 1 "falling")
plot( tFallEnd ?expr '( "tFallEnd" ) )
tRiseStart = cross(clip(v("/Vline" ?result "tran") clipStart VAR("timeStop")) (VAR("VDDL") + (0.1 * vDiff)) 1 "rising")
plot( tRiseStart ?expr '( "tRiseStart" ) )
tRiseSettleStart = cross(clip(v("/VH" ?result "tran") clipStart VAR("timeStop")) (0.5 * VAR("VDDH")) 1 "falling")
plot( tRiseSettleStart ?expr '( "tRiseSettleStart" ) )
TSettleFall = (tFallSettleEnd - tFallSettleStart)
plot( TSettleFall ?expr '( "TSettleFall" ) )
QFall_pVDDL = ymax(iinteg(clip(i("/IVDDL/dst" ?result "tran") tFallSettleStart tFallSettleEnd)))
plot( QFall_pVDDL ?expr '( "QFall_pVDDL" ) )
vDiff = (VAR("VDDH") - VAR("VDDL"))
plot( vDiff ?expr '( "vDiff" ) )
tFallStart = cross(clip(v("/Vline" ?result "tran") clipStart VAR("timeStop")) (VAR("VDDH") - (0.1 * vDiff)) 1 "falling")
plot( tFallStart ?expr '( "tFallStart" ) )
tFallSettleStart = cross(clip(v("/VH" ?result "tran") clipStart VAR("timeStop")) (0.5 * VAR("VDDH")) 1 "rising")
plot( tFallSettleStart ?expr '( "tFallSettleStart" ) )
plot( cross(clip(v("/VH" ?result "tran") clipStart VAR("timeStop")) (0.5 * VAR("VDDH")) 1 "rising") )
clipStart = (1.25 * VAR("period"))
plot( clipStart ?expr '( "clipStart" ) )
QRise_pVDDH = ymax(iinteg(clip(i("/IVDDH/src" ?result "tran") tRiseSettleStart tRiseSettleEnd)))
plot( QRise_pVDDH ?expr '( "QRise_pVDDH" ) )
modelFile(
    '("/software/cadence/ncsu-FreePDK15/hspice_16nm_hp.include" "")
)
run()
selectResult( 'tran )
plot(getData("/Vline") getData("/VL") getData("/VH") getData("/IVDDH/src") getData("/IVDDL/dst") getData("/ILine/src") getData("/V0/MINUS") getData("/V0/PLUS") )
LeakageLine = average(clip(i("/ILine/src" ?result "tran") tLeakageStart tLeakageEnd))
plot( LeakageLine ?expr '( "LeakageLine" ) )
LeakageIntoVDDL = average(clip(i("/IVDDL/dst" ?result "tran") tLeakageStart tLeakageEnd))
plot( LeakageIntoVDDL ?expr '( "LeakageIntoVDDL" ) )
LeakageVDDH = average(clip(i("/IVDDH/src" ?result "tran") tLeakageStart tLeakageEnd))
plot( LeakageVDDH ?expr '( "LeakageVDDH" ) )
tLeakageStart = (VAR("timeB") + (0.49 * (VAR("timeC") - VAR("timeB"))))
plot( tLeakageStart ?expr '( "tLeakageStart" ) )
tLeakageEnd = (VAR("timeC") - (0.49 * (VAR("timeC") - VAR("timeB"))))
plot( tLeakageEnd ?expr '( "tLeakageEnd" ) )
tFallSettleEnd = cross(clip(v("/Vline" ?result "tran") clipStart VAR("timeStop")) (1.005 * VAR("VDDL")) 1 "falling")
plot( tFallSettleEnd ?expr '( "tFallSettleEnd" ) )
tFallEnd = cross(cilp (v("/Vline" ?result "tran") clipStart VAR("timeStop")) (VAR("VDDH") - (0.9 * vDiff)) 1 "falling")
plot( tFallEnd ?expr '( "tFallEnd" ) )
TSettleFall = (tFallSettleEnd - tFallSettleStart)
plot( TSettleFall ?expr '( "TSettleFall" ) )
QFall_pVDDL = ymax(iinteg(clip(i("/IVDDL/dst" ?result "tran") tFallSettleStart tFallSettleEnd)))
plot( QFall_pVDDL ?expr '( "QFall_pVDDL" ) )
vDiff = (VAR("VDDH") - VAR("VDDL"))
plot( vDiff ?expr '( "vDiff" ) )
tFallStart = cross(clip(v("/Vline" ?result "tran") clipStart VAR("timeStop")) (VAR("VDDH") - (0.1 * vDiff)) 1 "falling")
plot( tFallStart ?expr '( "tFallStart" ) )
tFallSettleStart = cross(clip(v("/VH" ?result "tran") clipStart VAR("timeStop")) (0.5 * VAR("VDDH")) 1 "rising")
plot( tFallSettleStart ?expr '( "tFallSettleStart" ) )
plot( cross(clip(v("/VH" ?result "tran") clipStart VAR("timeStop")) (0.5 * VAR("VDDH")) 1 "rising") )
tRiseSettleEnd = cross(clip(v("/Vline" ?result "tran") clipStart VAR("timeStop")) (0.99 * VAR("VDDH")) 1 "rising")
plot( tRiseSettleEnd ?expr '( "tRiseSettleEnd" ) )
tRiseEnd = cross(clip(v("/Vline" ?result "tran") clipStart VAR("timeStop")) (VAR("VDDL") + (0.9 * vDiff)) 1 "rising")
plot( tRiseEnd ?expr '( "tRiseEnd" ) )
tRiseStart = cross(clip(v("/Vline" ?result "tran") clipStart VAR("timeStop")) (VAR("VDDL") + (0.1 * vDiff)) 1 "rising")
plot( tRiseStart ?expr '( "tRiseStart" ) )
tRiseSettleStart = cross(clip(v("/VH" ?result "tran") clipStart VAR("timeStop")) (0.5 * VAR("VDDH")) 1 "falling")
plot( tRiseSettleStart ?expr '( "tRiseSettleStart" ) )
clipStart = (1.25 * VAR("period"))
plot( clipStart ?expr '( "clipStart" ) )
TSettleRise = (tRiseSettleEnd - tRiseSettleStart)
plot( TSettleRise ?expr '( "TSettleRise" ) )
QRise_pVDDH = ymax(iinteg(clip(i("/IVDDH/src" ?result "tran") tRiseSettleStart tRiseSettleEnd)))
plot( QRise_pVDDH ?expr '( "QRise_pVDDH" ) )
modelFile(
    '("/software/cadence/ncsu-FreePDK15/hspice_16nm_hp.include" "")
)
run()
selectResult( 'tran )
plot(getData("/ILine/src") getData("/IVDDH/src") getData("/IVDDL/dst") getData("/V0/MINUS") getData("/V0/PLUS") getData("/VH") getData("/VL") getData("/Vline") )
LeakageIntoVDDL = average(clip(i("/IVDDL/dst" ?result "tran") tLeakageStart tLeakageEnd))
plot( LeakageIntoVDDL ?expr '( "LeakageIntoVDDL" ) )
LeakageLine = average(clip(i("/ILine/src" ?result "tran") tLeakageStart tLeakageEnd))
plot( LeakageLine ?expr '( "LeakageLine" ) )
LeakageVDDH = average(clip(i("/IVDDH/src" ?result "tran") tLeakageStart tLeakageEnd))
plot( LeakageVDDH ?expr '( "LeakageVDDH" ) )
QFall_pVDDL = ymax(iinteg(clip(i("/IVDDL/dst" ?result "tran") tFallSettleStart tFallSettleEnd)))
plot( QFall_pVDDL ?expr '( "QFall_pVDDL" ) )
QRise_pVDDH = ymax(iinteg(clip(i("/IVDDH/src" ?result "tran") tRiseSettleStart tRiseSettleEnd)))
plot( QRise_pVDDH ?expr '( "QRise_pVDDH" ) )
TSettleFall = (tFallSettleEnd - tFallSettleStart)
plot( TSettleFall ?expr '( "TSettleFall" ) )
TSettleRise = (tRiseSettleEnd - tRiseSettleStart)
plot( TSettleRise ?expr '( "TSettleRise" ) )
clipStart = (1.25 * VAR("period"))
plot( clipStart ?expr '( "clipStart" ) )
plot( cross(clip(v("/VH" ?result "tran") clipStart VAR("timeStop")) (0.5 * VAR("VDDH")) 1 "rising") )
tFallEnd = cross(cilp (v("/Vline" ?result "tran") clipStart VAR("timeStop")) (VAR("VDDH") - (0.9 * vDiff)) 1 "falling")
plot( tFallEnd ?expr '( "tFallEnd" ) )
tFallSettleEnd = cross(clip(v("/Vline" ?result "tran") clipStart VAR("timeStop")) (1.005 * VAR("VDDL")) 1 "falling")
plot( tFallSettleEnd ?expr '( "tFallSettleEnd" ) )
tFallSettleStart = cross(clip(v("/VH" ?result "tran") clipStart VAR("timeStop")) (0.5 * VAR("VDDH")) 1 "rising")
plot( tFallSettleStart ?expr '( "tFallSettleStart" ) )
tFallStart = cross(clip(v("/Vline" ?result "tran") clipStart VAR("timeStop")) (VAR("VDDH") - (0.1 * vDiff)) 1 "falling")
plot( tFallStart ?expr '( "tFallStart" ) )
tLeakageEnd = (clipStart + (0.51 * VAR("period")))
plot( tLeakageEnd ?expr '( "tLeakageEnd" ) )
tLeakageStart = (clipStart + (0.49 * VAR("period")))
plot( tLeakageStart ?expr '( "tLeakageStart" ) )
tRiseEnd = cross(clip(v("/Vline" ?result "tran") clipStart VAR("timeStop")) (VAR("VDDL") + (0.9 * vDiff)) 1 "rising")
plot( tRiseEnd ?expr '( "tRiseEnd" ) )
tRiseSettleEnd = cross(clip(v("/Vline" ?result "tran") clipStart VAR("timeStop")) (0.99 * VAR("VDDH")) 1 "rising")
plot( tRiseSettleEnd ?expr '( "tRiseSettleEnd" ) )
tRiseSettleStart = cross(clip(v("/VH" ?result "tran") clipStart VAR("timeStop")) (0.5 * VAR("VDDH")) 1 "falling")
plot( tRiseSettleStart ?expr '( "tRiseSettleStart" ) )
tRiseStart = cross(clip(v("/Vline" ?result "tran") clipStart VAR("timeStop")) (VAR("VDDL") + (0.1 * vDiff)) 1 "rising")
plot( tRiseStart ?expr '( "tRiseStart" ) )
vDiff = (VAR("VDDH") - VAR("VDDL"))
plot( vDiff ?expr '( "vDiff" ) )
modelFile(
    '("/software/cadence/ncsu-FreePDK15/hspice_16nm_hp.include" "")
)
run()
selectResult( 'tran )
plot(getData("/ILine/src") getData("/IVDDH/src") getData("/IVDDL/dst") getData("/V0/MINUS") getData("/V0/PLUS") getData("/VH") getData("/VL") getData("/Vline") )
tFallEnd = cross(clip(v("/Vline" ?result "tran") clipStart VAR("timeStop")) (VAR("VDDH") - (0.9 * vDiff)) 1 "falling")
plot( tFallEnd ?expr '( "tFallEnd" ) )
vDiff = (VAR("VDDH") - VAR("VDDL"))
plot( vDiff ?expr '( "vDiff" ) )
LeakageVDDH = average(clip(i("/IVDDH/src" ?result "tran") tLeakageStart tLeakageEnd))
plot( LeakageVDDH ?expr '( "LeakageVDDH" ) )
LeakageLine = average(clip(i("/ILine/src" ?result "tran") tLeakageStart tLeakageEnd))
plot( LeakageLine ?expr '( "LeakageLine" ) )
LeakageIntoVDDL = average(clip(i("/IVDDL/dst" ?result "tran") tLeakageStart tLeakageEnd))
plot( LeakageIntoVDDL ?expr '( "LeakageIntoVDDL" ) )
tFallSettleEnd = cross(clip(v("/Vline" ?result "tran") clipStart VAR("timeStop")) (1.005 * VAR("VDDL")) 1 "falling")
plot( tFallSettleEnd ?expr '( "tFallSettleEnd" ) )
plot( cross(clip(v("/VH" ?result "tran") clipStart VAR("timeStop")) (0.5 * VAR("VDDH")) 1 "rising") )
tFallSettleStart = cross(clip(v("/VH" ?result "tran") clipStart VAR("timeStop")) (0.5 * VAR("VDDH")) 1 "rising")
plot( tFallSettleStart ?expr '( "tFallSettleStart" ) )
tFallStart = cross(clip(v("/Vline" ?result "tran") clipStart VAR("timeStop")) (VAR("VDDH") - (0.1 * vDiff)) 1 "falling")
plot( tFallStart ?expr '( "tFallStart" ) )
tLeakageEnd = (clipStart + (0.51 * VAR("period")))
plot( tLeakageEnd ?expr '( "tLeakageEnd" ) )
tLeakageStart = (clipStart + (0.49 * VAR("period")))
plot( tLeakageStart ?expr '( "tLeakageStart" ) )
tRiseSettleEnd = cross(clip(v("/Vline" ?result "tran") clipStart VAR("timeStop")) (0.99 * VAR("VDDH")) 1 "rising")
plot( tRiseSettleEnd ?expr '( "tRiseSettleEnd" ) )
tRiseEnd = cross(clip(v("/Vline" ?result "tran") clipStart VAR("timeStop")) (VAR("VDDL") + (0.9 * vDiff)) 1 "rising")
plot( tRiseEnd ?expr '( "tRiseEnd" ) )
tRiseStart = cross(clip(v("/Vline" ?result "tran") clipStart VAR("timeStop")) (VAR("VDDL") + (0.1 * vDiff)) 1 "rising")
plot( tRiseStart ?expr '( "tRiseStart" ) )
tRiseSettleStart = cross(clip(v("/VH" ?result "tran") clipStart VAR("timeStop")) (0.5 * VAR("VDDH")) 1 "falling")
plot( tRiseSettleStart ?expr '( "tRiseSettleStart" ) )
clipStart = (1.25 * VAR("period"))
plot( clipStart ?expr '( "clipStart" ) )
TSettleFall = (tFallSettleEnd - tFallSettleStart)
plot( TSettleFall ?expr '( "TSettleFall" ) )
TSettleRise = (tRiseSettleEnd - tRiseSettleStart)
plot( TSettleRise ?expr '( "TSettleRise" ) )
QRise_pVDDH = ymax(iinteg(clip(i("/IVDDH/src" ?result "tran") tRiseSettleStart tRiseSettleEnd)))
plot( QRise_pVDDH ?expr '( "QRise_pVDDH" ) )
QFall_pVDDL = ymax(iinteg(clip(i("/IVDDL/dst" ?result "tran") tFallSettleStart tFallSettleEnd)))
plot( QFall_pVDDL ?expr '( "QFall_pVDDL" ) )
modelFile(
    '("/software/cadence/ncsu-FreePDK15/hspice_16nm_hp.include" "")
)
desVar(	  "C2" 26.4f	)
run()
selectResult( 'tran )
plot(getData("/ILine/src") getData("/IVDDH/src") getData("/IVDDL/dst") getData("/V0/MINUS") getData("/V0/PLUS") getData("/VH") getData("/VL") getData("/Vline") )
tFallEnd = cross(clip(v("/Vline" ?result "tran") clipStart VAR("timeStop")) (VAR("VDDH") - (0.9 * vDiff)) 1 "falling")
plot( tFallEnd ?expr '( "tFallEnd" ) )
vDiff = (VAR("VDDH") - VAR("VDDL"))
plot( vDiff ?expr '( "vDiff" ) )
LeakageVDDH = average(clip(i("/IVDDH/src" ?result "tran") tLeakageStart tLeakageEnd))
plot( LeakageVDDH ?expr '( "LeakageVDDH" ) )
LeakageLine = average(clip(i("/ILine/src" ?result "tran") tLeakageStart tLeakageEnd))
plot( LeakageLine ?expr '( "LeakageLine" ) )
LeakageIntoVDDL = average(clip(i("/IVDDL/dst" ?result "tran") tLeakageStart tLeakageEnd))
plot( LeakageIntoVDDL ?expr '( "LeakageIntoVDDL" ) )
tFallSettleEnd = cross(clip(v("/Vline" ?result "tran") clipStart VAR("timeStop")) (1.005 * VAR("VDDL")) 1 "falling")
plot( tFallSettleEnd ?expr '( "tFallSettleEnd" ) )
tFallSettleStart = cross(clip(v("/VH" ?result "tran") clipStart VAR("timeStop")) (0.5 * VAR("VDDH")) 1 "rising")
plot( tFallSettleStart ?expr '( "tFallSettleStart" ) )
tFallStart = cross(clip(v("/Vline" ?result "tran") clipStart VAR("timeStop")) (VAR("VDDH") - (0.1 * vDiff)) 1 "falling")
plot( tFallStart ?expr '( "tFallStart" ) )
tLeakageEnd = (clipStart + (0.51 * VAR("period")))
plot( tLeakageEnd ?expr '( "tLeakageEnd" ) )
tLeakageStart = (clipStart + (0.49 * VAR("period")))
plot( tLeakageStart ?expr '( "tLeakageStart" ) )
tRiseSettleEnd = cross(clip(v("/Vline" ?result "tran") clipStart VAR("timeStop")) (0.99 * VAR("VDDH")) 1 "rising")
plot( tRiseSettleEnd ?expr '( "tRiseSettleEnd" ) )
tRiseEnd = cross(clip(v("/Vline" ?result "tran") clipStart VAR("timeStop")) (VAR("VDDL") + (0.9 * vDiff)) 1 "rising")
plot( tRiseEnd ?expr '( "tRiseEnd" ) )
tRiseStart = cross(clip(v("/Vline" ?result "tran") clipStart VAR("timeStop")) (VAR("VDDL") + (0.1 * vDiff)) 1 "rising")
plot( tRiseStart ?expr '( "tRiseStart" ) )
tRiseSettleStart = cross(clip(v("/VH" ?result "tran") clipStart VAR("timeStop")) (0.5 * VAR("VDDH")) 1 "falling")
plot( tRiseSettleStart ?expr '( "tRiseSettleStart" ) )
clipStart = (1.25 * VAR("period"))
plot( clipStart ?expr '( "clipStart" ) )
TSettleFall = (tFallSettleEnd - tFallSettleStart)
plot( TSettleFall ?expr '( "TSettleFall" ) )
TSettleRise = (tRiseSettleEnd - tRiseSettleStart)
plot( TSettleRise ?expr '( "TSettleRise" ) )
QRise_pVDDH = ymax(iinteg(clip(i("/IVDDH/src" ?result "tran") tRiseSettleStart tRiseSettleEnd)))
plot( QRise_pVDDH ?expr '( "QRise_pVDDH" ) )
QFall_pVDDL = ymax(iinteg(clip(i("/IVDDL/dst" ?result "tran") tFallSettleStart tFallSettleEnd)))
plot( QFall_pVDDL ?expr '( "QFall_pVDDL" ) )
hostMode( 'distributed )
resultsDir( "/net/kafka/nfs/rstdenis/Cadence/simulation/Dual_Supply_Test/spectre/schematic/distributed/job001" )
modelFile(
    '("/software/cadence/ncsu-FreePDK15/hspice_16nm_hp.include" "")
)
delete( 'desVar "C2" )
save( 'i /V0/MINUS /V0/PLUS )
run( ?jobName "job" ?queue "c2107" )
selectResult( 'tran )
plot(getData("/ILine/src") getData("/IVDDH/src") getData("/IVDDL/dst") getData("/VH") getData("/VL") getData("/Vline") )
LeakageIntoVDDL = average(clip(i("/IVDDL/dst" ?result "tran") tLeakageStart tLeakageEnd))
plot( LeakageIntoVDDL ?expr '( "LeakageIntoVDDL" ) )
LeakageLine = average(clip(i("/ILine/src" ?result "tran") tLeakageStart tLeakageEnd))
plot( LeakageLine ?expr '( "LeakageLine" ) )
LeakageVDDH = average(clip(i("/IVDDH/src" ?result "tran") tLeakageStart tLeakageEnd))
plot( LeakageVDDH ?expr '( "LeakageVDDH" ) )
QFall_pVDDL = ymax(iinteg(clip(i("/IVDDL/dst" ?result "tran") tFallSettleStart tFallSettleEnd)))
plot( QFall_pVDDL ?expr '( "QFall_pVDDL" ) )
QRise_pVDDH = ymax(iinteg(clip(i("/IVDDH/src" ?result "tran") tRiseSettleStart tRiseSettleEnd)))
plot( QRise_pVDDH ?expr '( "QRise_pVDDH" ) )
TSettleFall = (tFallSettleEnd - tFallSettleStart)
plot( TSettleFall ?expr '( "TSettleFall" ) )
TSettleRise = (tRiseSettleEnd - tRiseSettleStart)
plot( TSettleRise ?expr '( "TSettleRise" ) )
clipStart = (1.25 * VAR("period"))
plot( clipStart ?expr '( "clipStart" ) )
tFallEnd = cross(clip(v("/Vline" ?result "tran") clipStart VAR("timeStop")) (VAR("VDDH") - (0.9 * vDiff)) 1 "falling")
plot( tFallEnd ?expr '( "tFallEnd" ) )
tFallSettleEnd = cross(clip(v("/Vline" ?result "tran") clipStart VAR("timeStop")) (1.005 * VAR("VDDL")) 1 "falling")
plot( tFallSettleEnd ?expr '( "tFallSettleEnd" ) )
tFallSettleStart = cross(clip(v("/VH" ?result "tran") clipStart VAR("timeStop")) (0.5 * VAR("VDDH")) 1 "rising")
plot( tFallSettleStart ?expr '( "tFallSettleStart" ) )
tFallStart = cross(clip(v("/Vline" ?result "tran") clipStart VAR("timeStop")) (VAR("VDDH") - (0.1 * vDiff)) 1 "falling")
plot( tFallStart ?expr '( "tFallStart" ) )
tLeakageEnd = (clipStart + (0.51 * VAR("period")))
plot( tLeakageEnd ?expr '( "tLeakageEnd" ) )
tLeakageStart = (clipStart + (0.49 * VAR("period")))
plot( tLeakageStart ?expr '( "tLeakageStart" ) )
tRiseEnd = cross(clip(v("/Vline" ?result "tran") clipStart VAR("timeStop")) (VAR("VDDL") + (0.9 * vDiff)) 1 "rising")
plot( tRiseEnd ?expr '( "tRiseEnd" ) )
tRiseSettleEnd = cross(clip(v("/Vline" ?result "tran") clipStart VAR("timeStop")) (0.99 * VAR("VDDH")) 1 "rising")
plot( tRiseSettleEnd ?expr '( "tRiseSettleEnd" ) )
tRiseSettleStart = cross(clip(v("/VH" ?result "tran") clipStart VAR("timeStop")) (0.5 * VAR("VDDH")) 1 "falling")
plot( tRiseSettleStart ?expr '( "tRiseSettleStart" ) )
tRiseStart = cross(clip(v("/Vline" ?result "tran") clipStart VAR("timeStop")) (VAR("VDDL") + (0.1 * vDiff)) 1 "rising")
plot( tRiseStart ?expr '( "tRiseStart" ) )
vDiff = (VAR("VDDH") - VAR("VDDL"))
plot( vDiff ?expr '( "vDiff" ) )
hostMode( 'local )
resultsDir( "/net/kafka/nfs/rstdenis/Cadence/simulation/Dual_Supply_Test/spectre/schematic" )
modelFile(
    '("/software/cadence/ncsu-FreePDK15/hspice_16nm_hp.include" "")
)
run()
selectResult( 'tran )
plot(getData("/ILine/src") getData("/IVDDH/src") getData("/IVDDL/dst") getData("/VH") getData("/VL") getData("/Vline") )
vDiff = (VAR("VDDH") - VAR("VDDL"))
plot( vDiff ?expr '( "vDiff" ) )
tRiseStart = cross(clip(v("/Vline" ?result "tran") clipStart VAR("timeStop")) (VAR("VDDL") + (0.1 * vDiff)) 1 "rising")
plot( tRiseStart ?expr '( "tRiseStart" ) )
tRiseSettleStart = cross(clip(v("/VH" ?result "tran") clipStart VAR("timeStop")) (0.5 * VAR("VDDH")) 1 "falling")
plot( tRiseSettleStart ?expr '( "tRiseSettleStart" ) )
tRiseSettleEnd = cross(clip(v("/Vline" ?result "tran") clipStart VAR("timeStop")) (0.99 * VAR("VDDH")) 1 "rising")
plot( tRiseSettleEnd ?expr '( "tRiseSettleEnd" ) )
tRiseEnd = cross(clip(v("/Vline" ?result "tran") clipStart VAR("timeStop")) (VAR("VDDL") + (0.9 * vDiff)) 1 "rising")
plot( tRiseEnd ?expr '( "tRiseEnd" ) )
tLeakageStart = (clipStart + (0.49 * VAR("period")))
plot( tLeakageStart ?expr '( "tLeakageStart" ) )
tLeakageEnd = (clipStart + (0.51 * VAR("period")))
plot( tLeakageEnd ?expr '( "tLeakageEnd" ) )
tFallStart = cross(clip(v("/Vline" ?result "tran") clipStart VAR("timeStop")) (VAR("VDDH") - (0.1 * vDiff)) 1 "falling")
plot( tFallStart ?expr '( "tFallStart" ) )
tFallSettleStart = cross(clip(v("/VH" ?result "tran") clipStart VAR("timeStop")) (0.5 * VAR("VDDH")) 1 "rising")
plot( tFallSettleStart ?expr '( "tFallSettleStart" ) )
tFallSettleEnd = cross(clip(v("/Vline" ?result "tran") clipStart VAR("timeStop")) (1.005 * VAR("VDDL")) 1 "falling")
plot( tFallSettleEnd ?expr '( "tFallSettleEnd" ) )
tFallEnd = cross(clip(v("/Vline" ?result "tran") clipStart VAR("timeStop")) (VAR("VDDH") - (0.9 * vDiff)) 1 "falling")
plot( tFallEnd ?expr '( "tFallEnd" ) )
clipStart = (1.25 * VAR("period"))
plot( clipStart ?expr '( "clipStart" ) )
TSettleRise = (tRiseSettleEnd - tRiseSettleStart)
plot( TSettleRise ?expr '( "TSettleRise" ) )
TSettleFall = (tFallSettleEnd - tFallSettleStart)
plot( TSettleFall ?expr '( "TSettleFall" ) )
QRise_pVDDH = ymax(iinteg(clip(i("/IVDDH/src" ?result "tran") tRiseSettleStart tRiseSettleEnd)))
plot( QRise_pVDDH ?expr '( "QRise_pVDDH" ) )
QFall_pVDDL = ymax(iinteg(clip(i("/IVDDL/dst" ?result "tran") tFallSettleStart tFallSettleEnd)))
plot( QFall_pVDDL ?expr '( "QFall_pVDDL" ) )
LeakageVDDH = average(clip(i("/IVDDH/src" ?result "tran") tLeakageStart tLeakageEnd))
plot( LeakageVDDH ?expr '( "LeakageVDDH" ) )
LeakageLine = average(clip(i("/ILine/src" ?result "tran") tLeakageStart tLeakageEnd))
plot( LeakageLine ?expr '( "LeakageLine" ) )
LeakageIntoVDDL = average(clip(i("/IVDDL/dst" ?result "tran") tLeakageStart tLeakageEnd))
plot( LeakageIntoVDDL ?expr '( "LeakageIntoVDDL" ) )
modelFile(
    '("/software/cadence/ncsu-FreePDK15/hspice_16nm_hp.include" "")
)
run()
selectResult( 'tran )
plot(getData("/ILine/src") getData("/IVDDH/src") getData("/IVDDL/dst") getData("/VH") getData("/VL") getData("/Vline") )
clipStart = (1.25 * VAR("period"))
plot( clipStart ?expr '( "clipStart" ) )
tFallSettleEnd = cross(clip(v("/Vline" ?result "tran") clipStart VAR("timeStop")) (1.005 * VAR("VDDL")) 1 "falling")
plot( tFallSettleEnd ?expr '( "tFallSettleEnd" ) )
tFallSettleStart = cross(clip(v("/VH" ?result "tran") clipStart VAR("timeStop")) (0.5 * VAR("VDDH")) 1 "rising")
plot( tFallSettleStart ?expr '( "tFallSettleStart" ) )
TSettleFall = (tFallSettleEnd - tFallSettleStart)
plot( TSettleFall ?expr '( "TSettleFall" ) )
tLeakageStart = (clipStart + (0.49 * VAR("period")))
plot( tLeakageStart ?expr '( "tLeakageStart" ) )
tLeakageEnd = (clipStart + (0.51 * VAR("period")))
plot( tLeakageEnd ?expr '( "tLeakageEnd" ) )
LeakageLine = average(clip(i("/ILine/src" ?result "tran") tLeakageStart tLeakageEnd))
plot( LeakageLine ?expr '( "LeakageLine" ) )
tRiseSettleEnd = cross(clip(v("/Vline" ?result "tran") clipStart VAR("timeStop")) (0.99 * VAR("VDDH")) 1 "rising")
plot( tRiseSettleEnd ?expr '( "tRiseSettleEnd" ) )
tRiseSettleStart = cross(clip(v("/VH" ?result "tran") clipStart VAR("timeStop")) (0.5 * VAR("VDDH")) 1 "falling")
plot( tRiseSettleStart ?expr '( "tRiseSettleStart" ) )
TSettleRise = (tRiseSettleEnd - tRiseSettleStart)
plot( TSettleRise ?expr '( "TSettleRise" ) )
vDiff = (VAR("VDDH") - VAR("VDDL"))
plot( vDiff ?expr '( "vDiff" ) )
tRiseStart = cross(clip(v("/Vline" ?result "tran") clipStart VAR("timeStop")) (VAR("VDDL") + (0.1 * vDiff)) 1 "rising")
plot( tRiseStart ?expr '( "tRiseStart" ) )
LeakageIntoVDDL = average(clip(i("/IVDDL/dst" ?result "tran") tLeakageStart tLeakageEnd))
plot( LeakageIntoVDDL ?expr '( "LeakageIntoVDDL" ) )
tFallStart = cross(clip(v("/Vline" ?result "tran") clipStart VAR("timeStop")) (VAR("VDDH") - (0.1 * vDiff)) 1 "falling")
plot( tFallStart ?expr '( "tFallStart" ) )
tRiseEnd = cross(clip(v("/Vline" ?result "tran") clipStart VAR("timeStop")) (VAR("VDDL") + (0.9 * vDiff)) 1 "rising")
plot( tRiseEnd ?expr '( "tRiseEnd" ) )
QRise_pVDDH = ymax(iinteg(clip(i("/IVDDH/src" ?result "tran") tRiseSettleStart tRiseSettleEnd)))
plot( QRise_pVDDH ?expr '( "QRise_pVDDH" ) )
tFallEnd = cross(clip(v("/Vline" ?result "tran") clipStart VAR("timeStop")) (VAR("VDDH") - (0.9 * vDiff)) 1 "falling")
plot( tFallEnd ?expr '( "tFallEnd" ) )
LeakageVDDH = average(clip(i("/IVDDH/src" ?result "tran") tLeakageStart tLeakageEnd))
plot( LeakageVDDH ?expr '( "LeakageVDDH" ) )
QFall_pVDDL = ymax(iinteg(clip(i("/IVDDL/dst" ?result "tran") tFallSettleStart tFallSettleEnd)))
plot( QFall_pVDDL ?expr '( "QFall_pVDDL" ) )
modelFile(
    '("/software/cadence/ncsu-FreePDK15/hspice_16nm_hp.include" "")
)
desVar(	  "nfin" 12	)
run()
selectResult( 'tran )
plot(getData("/Vline") getData("/VL") getData("/VH") getData("/IVDDL/dst") getData("/IVDDH/src") getData("/ILine/src") )
vDiff = (VAR("VDDH") - VAR("VDDL"))
plot( vDiff ?expr '( "vDiff" ) )
tRiseStart = cross(clip(v("/Vline" ?result "tran") clipStart VAR("timeStop")) (VAR("VDDL") + (0.1 * vDiff)) 1 "rising")
plot( tRiseStart ?expr '( "tRiseStart" ) )
tRiseSettleStart = cross(clip(v("/VH" ?result "tran") clipStart VAR("timeStop")) (0.5 * VAR("VDDH")) 1 "falling")
plot( tRiseSettleStart ?expr '( "tRiseSettleStart" ) )
tRiseSettleEnd = cross(clip(v("/Vline" ?result "tran") clipStart VAR("timeStop")) (0.99 * VAR("VDDH")) 1 "rising")
plot( tRiseSettleEnd ?expr '( "tRiseSettleEnd" ) )
tRiseEnd = cross(clip(v("/Vline" ?result "tran") clipStart VAR("timeStop")) (VAR("VDDL") + (0.9 * vDiff)) 1 "rising")
plot( tRiseEnd ?expr '( "tRiseEnd" ) )
tLeakageStart = (clipStart + (0.49 * VAR("period")))
plot( tLeakageStart ?expr '( "tLeakageStart" ) )
tLeakageEnd = (clipStart + (0.51 * VAR("period")))
plot( tLeakageEnd ?expr '( "tLeakageEnd" ) )
tFallStart = cross(clip(v("/Vline" ?result "tran") clipStart VAR("timeStop")) (VAR("VDDH") - (0.1 * vDiff)) 1 "falling")
plot( tFallStart ?expr '( "tFallStart" ) )
tFallSettleStart = cross(clip(v("/VH" ?result "tran") clipStart VAR("timeStop")) (0.5 * VAR("VDDH")) 1 "rising")
plot( tFallSettleStart ?expr '( "tFallSettleStart" ) )
tFallSettleEnd = cross(clip(v("/Vline" ?result "tran") clipStart VAR("timeStop")) (1.005 * VAR("VDDL")) 1 "falling")
plot( tFallSettleEnd ?expr '( "tFallSettleEnd" ) )
tFallEnd = cross(clip(v("/Vline" ?result "tran") clipStart VAR("timeStop")) (VAR("VDDH") - (0.9 * vDiff)) 1 "falling")
plot( tFallEnd ?expr '( "tFallEnd" ) )
clipStart = (1.25 * VAR("period"))
plot( clipStart ?expr '( "clipStart" ) )
TSettleRise = (tRiseSettleEnd - tRiseSettleStart)
plot( TSettleRise ?expr '( "TSettleRise" ) )
TSettleFall = (tFallSettleEnd - tFallSettleStart)
plot( TSettleFall ?expr '( "TSettleFall" ) )
QRise_pVDDH = ymax(iinteg(clip(i("/IVDDH/src" ?result "tran") tRiseSettleStart tRiseSettleEnd)))
plot( QRise_pVDDH ?expr '( "QRise_pVDDH" ) )
QFall_pVDDL = ymax(iinteg(clip(i("/IVDDL/dst" ?result "tran") tFallSettleStart tFallSettleEnd)))
plot( QFall_pVDDL ?expr '( "QFall_pVDDL" ) )
LeakageVDDH = average(clip(i("/IVDDH/src" ?result "tran") tLeakageStart tLeakageEnd))
plot( LeakageVDDH ?expr '( "LeakageVDDH" ) )
LeakageLine = average(clip(i("/ILine/src" ?result "tran") tLeakageStart tLeakageEnd))
plot( LeakageLine ?expr '( "LeakageLine" ) )
LeakageIntoVDDL = average(clip(i("/IVDDL/dst" ?result "tran") tLeakageStart tLeakageEnd))
plot( LeakageIntoVDDL ?expr '( "LeakageIntoVDDL" ) )
modelFile(
    '("/software/cadence/ncsu-FreePDK15/hspice_16nm_hp.include" "")
)
desVar(	  "C" 29.6f	)
run()
selectResult( 'tran )
plot(getData("/Vline") getData("/VL") getData("/VH") getData("/IVDDL/dst") getData("/IVDDH/src") getData("/ILine/src") )
vDiff = (VAR("VDDH") - VAR("VDDL"))
plot( vDiff ?expr '( "vDiff" ) )
tRiseStart = cross(clip(v("/Vline" ?result "tran") clipStart VAR("timeStop")) (VAR("VDDL") + (0.1 * vDiff)) 1 "rising")
plot( tRiseStart ?expr '( "tRiseStart" ) )
tRiseSettleStart = cross(clip(v("/VH" ?result "tran") clipStart VAR("timeStop")) (0.5 * VAR("VDDH")) 1 "falling")
plot( tRiseSettleStart ?expr '( "tRiseSettleStart" ) )
tRiseSettleEnd = cross(clip(v("/Vline" ?result "tran") clipStart VAR("timeStop")) (0.99 * VAR("VDDH")) 1 "rising")
plot( tRiseSettleEnd ?expr '( "tRiseSettleEnd" ) )
tRiseEnd = cross(clip(v("/Vline" ?result "tran") clipStart VAR("timeStop")) (VAR("VDDL") + (0.9 * vDiff)) 1 "rising")
plot( tRiseEnd ?expr '( "tRiseEnd" ) )
tLeakageStart = (clipStart + (0.49 * VAR("period")))
plot( tLeakageStart ?expr '( "tLeakageStart" ) )
tLeakageEnd = (clipStart + (0.51 * VAR("period")))
plot( tLeakageEnd ?expr '( "tLeakageEnd" ) )
tFallStart = cross(clip(v("/Vline" ?result "tran") clipStart VAR("timeStop")) (VAR("VDDH") - (0.1 * vDiff)) 1 "falling")
plot( tFallStart ?expr '( "tFallStart" ) )
tFallSettleStart = cross(clip(v("/VH" ?result "tran") clipStart VAR("timeStop")) (0.5 * VAR("VDDH")) 1 "rising")
plot( tFallSettleStart ?expr '( "tFallSettleStart" ) )
tFallSettleEnd = cross(clip(v("/Vline" ?result "tran") clipStart VAR("timeStop")) (1.005 * VAR("VDDL")) 1 "falling")
plot( tFallSettleEnd ?expr '( "tFallSettleEnd" ) )
tFallEnd = cross(clip(v("/Vline" ?result "tran") clipStart VAR("timeStop")) (VAR("VDDH") - (0.9 * vDiff)) 1 "falling")
plot( tFallEnd ?expr '( "tFallEnd" ) )
clipStart = (1.25 * VAR("period"))
plot( clipStart ?expr '( "clipStart" ) )
TSettleRise = (tRiseSettleEnd - tRiseSettleStart)
plot( TSettleRise ?expr '( "TSettleRise" ) )
TSettleFall = (tFallSettleEnd - tFallSettleStart)
plot( TSettleFall ?expr '( "TSettleFall" ) )
QRise_pVDDH = ymax(iinteg(clip(i("/IVDDH/src" ?result "tran") tRiseSettleStart tRiseSettleEnd)))
plot( QRise_pVDDH ?expr '( "QRise_pVDDH" ) )
QFall_pVDDL = ymax(iinteg(clip(i("/IVDDL/dst" ?result "tran") tFallSettleStart tFallSettleEnd)))
plot( QFall_pVDDL ?expr '( "QFall_pVDDL" ) )
LeakageVDDH = average(clip(i("/IVDDH/src" ?result "tran") tLeakageStart tLeakageEnd))
plot( LeakageVDDH ?expr '( "LeakageVDDH" ) )
LeakageLine = average(clip(i("/ILine/src" ?result "tran") tLeakageStart tLeakageEnd))
plot( LeakageLine ?expr '( "LeakageLine" ) )
LeakageIntoVDDL = average(clip(i("/IVDDL/dst" ?result "tran") tLeakageStart tLeakageEnd))
plot( LeakageIntoVDDL ?expr '( "LeakageIntoVDDL" ) )
hostMode( 'distributed )
resultsDir( "/net/kafka/nfs/rstdenis/Cadence/simulation/Dual_Supply_Test/spectre/schematic/distributed/job001" )
modelFile(
    '("/software/cadence/ncsu-FreePDK15/hspice_16nm_hp.include" "")
)
run( ?jobName "job" ?queue "c2107" )
selectResult( 'tran )
plot(getData("/Vline") getData("/VL") getData("/VH") getData("/IVDDL/dst") getData("/IVDDH/src") getData("/ILine/src") )
LeakageIntoVDDL = average(clip(i("/IVDDL/dst" ?result "tran") tLeakageStart tLeakageEnd))
plot( LeakageIntoVDDL ?expr '( "LeakageIntoVDDL" ) )
LeakageLine = average(clip(i("/ILine/src" ?result "tran") tLeakageStart tLeakageEnd))
plot( LeakageLine ?expr '( "LeakageLine" ) )
LeakageVDDH = average(clip(i("/IVDDH/src" ?result "tran") tLeakageStart tLeakageEnd))
plot( LeakageVDDH ?expr '( "LeakageVDDH" ) )
QFall_pVDDL = ymax(iinteg(clip(i("/IVDDL/dst" ?result "tran") tFallSettleStart tFallSettleEnd)))
plot( QFall_pVDDL ?expr '( "QFall_pVDDL" ) )
QRise_pVDDH = ymax(iinteg(clip(i("/IVDDH/src" ?result "tran") tRiseSettleStart tRiseSettleEnd)))
plot( QRise_pVDDH ?expr '( "QRise_pVDDH" ) )
TSettleFall = (tFallSettleEnd - tFallSettleStart)
plot( TSettleFall ?expr '( "TSettleFall" ) )
TSettleRise = (tRiseSettleEnd - tRiseSettleStart)
plot( TSettleRise ?expr '( "TSettleRise" ) )
clipStart = (1.25 * VAR("period"))
plot( clipStart ?expr '( "clipStart" ) )
tFallEnd = cross(clip(v("/Vline" ?result "tran") clipStart VAR("timeStop")) (VAR("VDDH") - (0.9 * vDiff)) 1 "falling")
plot( tFallEnd ?expr '( "tFallEnd" ) )
tFallSettleEnd = cross(clip(v("/Vline" ?result "tran") clipStart VAR("timeStop")) (1.005 * VAR("VDDL")) 1 "falling")
plot( tFallSettleEnd ?expr '( "tFallSettleEnd" ) )
tFallSettleStart = cross(clip(v("/VH" ?result "tran") clipStart VAR("timeStop")) (0.5 * VAR("VDDH")) 1 "rising")
plot( tFallSettleStart ?expr '( "tFallSettleStart" ) )
tFallStart = cross(clip(v("/Vline" ?result "tran") clipStart VAR("timeStop")) (VAR("VDDH") - (0.1 * vDiff)) 1 "falling")
plot( tFallStart ?expr '( "tFallStart" ) )
tLeakageEnd = (clipStart + (0.51 * VAR("period")))
plot( tLeakageEnd ?expr '( "tLeakageEnd" ) )
tLeakageStart = (clipStart + (0.49 * VAR("period")))
plot( tLeakageStart ?expr '( "tLeakageStart" ) )
tRiseEnd = cross(clip(v("/Vline" ?result "tran") clipStart VAR("timeStop")) (VAR("VDDL") + (0.9 * vDiff)) 1 "rising")
plot( tRiseEnd ?expr '( "tRiseEnd" ) )
tRiseSettleEnd = cross(clip(v("/Vline" ?result "tran") clipStart VAR("timeStop")) (0.99 * VAR("VDDH")) 1 "rising")
plot( tRiseSettleEnd ?expr '( "tRiseSettleEnd" ) )
tRiseSettleStart = cross(clip(v("/VH" ?result "tran") clipStart VAR("timeStop")) (0.5 * VAR("VDDH")) 1 "falling")
plot( tRiseSettleStart ?expr '( "tRiseSettleStart" ) )
tRiseStart = cross(clip(v("/Vline" ?result "tran") clipStart VAR("timeStop")) (VAR("VDDL") + (0.1 * vDiff)) 1 "rising")
plot( tRiseStart ?expr '( "tRiseStart" ) )
vDiff = (VAR("VDDH") - VAR("VDDL"))
plot( vDiff ?expr '( "vDiff" ) )
TFall = (tFallStart - tFallEnd)
plot( TFall ?expr '( "TFall" ) )
TRise = (tRiseStart - tRiseEnd)
plot( TRise ?expr '( "TRise" ) )
TPRise = (tTPRiseEnd - tRiseSettleStart)
plot( TPRise ?expr '( "TPRise" ) )
TPFall = (tTPFallEnd - tFallSettleStart)
plot( TPFall ?expr '( "TPFall" ) )
tTPRiseEnd = cross(clip(v("/Vline" ?result "tran") clipStart VAR("timeStop")) (VAR("VDDL") + (0.5 * vDiff)) 1 "rising")
plot( tTPRiseEnd ?expr '( "tTPRiseEnd" ) )
tTPFallEnd = cross(clip(v("/Vline" ?result "tran") clipStart VAR("timeStop")) (VAR("VDDH") - (0.5 * vDiff)) 1 "falling")
plot( tTPFallEnd ?expr '( "tTPFallEnd" ) )
resultsDir( "/net/kafka/nfs/rstdenis/Cadence/simulation/Dual_Supply_Test/spectre/schematic/distributed/job002" )
modelFile(
    '("/software/cadence/ncsu-FreePDK15/hspice_16nm_hp.include" "")
)
desVar(	  "nfin" 18	)
run( ?jobName "job" ?queue "c2107" )
selectResult( 'tran )
plot(getData("/ILine/src") getData("/IVDDH/src") getData("/IVDDL/dst") getData("/VH") getData("/VL") getData("/Vline") )
LeakageIntoVDDL = average(clip(i("/IVDDL/dst" ?result "tran") tLeakageStart tLeakageEnd))
plot( LeakageIntoVDDL ?expr '( "LeakageIntoVDDL" ) )
LeakageLine = average(clip(i("/ILine/src" ?result "tran") tLeakageStart tLeakageEnd))
plot( LeakageLine ?expr '( "LeakageLine" ) )
LeakageVDDH = average(clip(i("/IVDDH/src" ?result "tran") tLeakageStart tLeakageEnd))
plot( LeakageVDDH ?expr '( "LeakageVDDH" ) )
QFall_pVDDL = ymax(iinteg(clip(i("/IVDDL/dst" ?result "tran") tFallSettleStart tFallSettleEnd)))
plot( QFall_pVDDL ?expr '( "QFall_pVDDL" ) )
QRise_pVDDH = ymax(iinteg(clip(i("/IVDDH/src" ?result "tran") tRiseSettleStart tRiseSettleEnd)))
plot( QRise_pVDDH ?expr '( "QRise_pVDDH" ) )
TSettleFall = (tFallSettleEnd - tFallSettleStart)
plot( TSettleFall ?expr '( "TSettleFall" ) )
TSettleRise = (tRiseSettleEnd - tRiseSettleStart)
plot( TSettleRise ?expr '( "TSettleRise" ) )
clipStart = (1.25 * VAR("period"))
plot( clipStart ?expr '( "clipStart" ) )
tFallEnd = cross(clip(v("/Vline" ?result "tran") clipStart VAR("timeStop")) (VAR("VDDH") - (0.9 * vDiff)) 1 "falling")
plot( tFallEnd ?expr '( "tFallEnd" ) )
tFallSettleEnd = cross(clip(v("/Vline" ?result "tran") clipStart VAR("timeStop")) (1.005 * VAR("VDDL")) 1 "falling")
plot( tFallSettleEnd ?expr '( "tFallSettleEnd" ) )
tFallSettleStart = cross(clip(v("/VH" ?result "tran") clipStart VAR("timeStop")) (0.5 * VAR("VDDH")) 1 "rising")
plot( tFallSettleStart ?expr '( "tFallSettleStart" ) )
tFallStart = cross(clip(v("/Vline" ?result "tran") clipStart VAR("timeStop")) (VAR("VDDH") - (0.1 * vDiff)) 1 "falling")
plot( tFallStart ?expr '( "tFallStart" ) )
tLeakageEnd = (clipStart + (0.51 * VAR("period")))
plot( tLeakageEnd ?expr '( "tLeakageEnd" ) )
tLeakageStart = (clipStart + (0.49 * VAR("period")))
plot( tLeakageStart ?expr '( "tLeakageStart" ) )
tRiseEnd = cross(clip(v("/Vline" ?result "tran") clipStart VAR("timeStop")) (VAR("VDDL") + (0.9 * vDiff)) 1 "rising")
plot( tRiseEnd ?expr '( "tRiseEnd" ) )
tRiseSettleEnd = cross(clip(v("/Vline" ?result "tran") clipStart VAR("timeStop")) (0.99 * VAR("VDDH")) 1 "rising")
plot( tRiseSettleEnd ?expr '( "tRiseSettleEnd" ) )
tRiseSettleStart = cross(clip(v("/VH" ?result "tran") clipStart VAR("timeStop")) (0.5 * VAR("VDDH")) 1 "falling")
plot( tRiseSettleStart ?expr '( "tRiseSettleStart" ) )
tRiseStart = cross(clip(v("/Vline" ?result "tran") clipStart VAR("timeStop")) (VAR("VDDL") + (0.1 * vDiff)) 1 "rising")
plot( tRiseStart ?expr '( "tRiseStart" ) )
vDiff = (VAR("VDDH") - VAR("VDDL"))
plot( vDiff ?expr '( "vDiff" ) )
TFall = (tFallStart - tFallEnd)
plot( TFall ?expr '( "TFall" ) )
TRise = (tRiseStart - tRiseEnd)
plot( TRise ?expr '( "TRise" ) )
TPRise = (tTPRiseEnd - tRiseSettleStart)
plot( TPRise ?expr '( "TPRise" ) )
TPFall = (tTPFallEnd - tFallSettleStart)
plot( TPFall ?expr '( "TPFall" ) )
tTPRiseEnd = cross(clip(v("/Vline" ?result "tran") clipStart VAR("timeStop")) (VAR("VDDL") + (0.5 * vDiff)) 1 "rising")
plot( tTPRiseEnd ?expr '( "tTPRiseEnd" ) )
tTPFallEnd = cross(clip(v("/Vline" ?result "tran") clipStart VAR("timeStop")) (VAR("VDDH") - (0.5 * vDiff)) 1 "falling")
plot( tTPFallEnd ?expr '( "tTPFallEnd" ) )
resultsDir( "/net/kafka/nfs/rstdenis/Cadence/simulation/Dual_Supply_Test/spectre/schematic/distributed/job003" )
modelFile(
    '("/software/cadence/ncsu-FreePDK15/hspice_16nm_hp.include" "")
)
delete( 'converge 'ic "/VL" )
delete( 'converge 'ic "/VH" )
delete( 'converge 'ic "/Vline" )
delete( 'converge 'ic "/sH" )
delete( 'converge 'ic "/net035" )
run( ?jobName "job" ?queue "c2107" )
selectResult( 'tran )
plot(getData("/ILine/src") getData("/IVDDH/src") getData("/IVDDL/dst") getData("/VH") getData("/VL") getData("/Vline") )
LeakageIntoVDDL = average(clip(i("/IVDDL/dst" ?result "tran") tLeakageStart tLeakageEnd))
plot( LeakageIntoVDDL ?expr '( "LeakageIntoVDDL" ) )
LeakageLine = average(clip(i("/ILine/src" ?result "tran") tLeakageStart tLeakageEnd))
plot( LeakageLine ?expr '( "LeakageLine" ) )
LeakageVDDH = average(clip(i("/IVDDH/src" ?result "tran") tLeakageStart tLeakageEnd))
plot( LeakageVDDH ?expr '( "LeakageVDDH" ) )
QFall_pVDDL = ymax(iinteg(clip(i("/IVDDL/dst" ?result "tran") tFallSettleStart tFallSettleEnd)))
plot( QFall_pVDDL ?expr '( "QFall_pVDDL" ) )
QRise_pVDDH = ymax(iinteg(clip(i("/IVDDH/src" ?result "tran") tRiseSettleStart tRiseSettleEnd)))
plot( QRise_pVDDH ?expr '( "QRise_pVDDH" ) )
TSettleFall = (tFallSettleEnd - tFallSettleStart)
plot( TSettleFall ?expr '( "TSettleFall" ) )
TSettleRise = (tRiseSettleEnd - tRiseSettleStart)
plot( TSettleRise ?expr '( "TSettleRise" ) )
clipStart = (1.25 * VAR("period"))
plot( clipStart ?expr '( "clipStart" ) )
tFallEnd = cross(clip(v("/Vline" ?result "tran") clipStart VAR("timeStop")) (VAR("VDDH") - (0.9 * vDiff)) 1 "falling")
plot( tFallEnd ?expr '( "tFallEnd" ) )
tFallSettleEnd = cross(clip(v("/Vline" ?result "tran") clipStart VAR("timeStop")) (1.005 * VAR("VDDL")) 1 "falling")
plot( tFallSettleEnd ?expr '( "tFallSettleEnd" ) )
tFallSettleStart = cross(clip(v("/VH" ?result "tran") clipStart VAR("timeStop")) (0.5 * VAR("VDDH")) 1 "rising")
plot( tFallSettleStart ?expr '( "tFallSettleStart" ) )
tFallStart = cross(clip(v("/Vline" ?result "tran") clipStart VAR("timeStop")) (VAR("VDDH") - (0.1 * vDiff)) 1 "falling")
plot( tFallStart ?expr '( "tFallStart" ) )
tLeakageEnd = (clipStart + (0.51 * VAR("period")))
plot( tLeakageEnd ?expr '( "tLeakageEnd" ) )
tLeakageStart = (clipStart + (0.49 * VAR("period")))
plot( tLeakageStart ?expr '( "tLeakageStart" ) )
tRiseEnd = cross(clip(v("/Vline" ?result "tran") clipStart VAR("timeStop")) (VAR("VDDL") + (0.9 * vDiff)) 1 "rising")
plot( tRiseEnd ?expr '( "tRiseEnd" ) )
tRiseSettleEnd = cross(clip(v("/Vline" ?result "tran") clipStart VAR("timeStop")) (0.99 * VAR("VDDH")) 1 "rising")
plot( tRiseSettleEnd ?expr '( "tRiseSettleEnd" ) )
tRiseSettleStart = cross(clip(v("/VH" ?result "tran") clipStart VAR("timeStop")) (0.5 * VAR("VDDH")) 1 "falling")
plot( tRiseSettleStart ?expr '( "tRiseSettleStart" ) )
tRiseStart = cross(clip(v("/Vline" ?result "tran") clipStart VAR("timeStop")) (VAR("VDDL") + (0.1 * vDiff)) 1 "rising")
plot( tRiseStart ?expr '( "tRiseStart" ) )
vDiff = (VAR("VDDH") - VAR("VDDL"))
plot( vDiff ?expr '( "vDiff" ) )
TFall = (tFallStart - tFallEnd)
plot( TFall ?expr '( "TFall" ) )
TRise = (tRiseStart - tRiseEnd)
plot( TRise ?expr '( "TRise" ) )
TPRise = (tTPRiseEnd - tRiseSettleStart)
plot( TPRise ?expr '( "TPRise" ) )
TPFall = (tTPFallEnd - tFallSettleStart)
plot( TPFall ?expr '( "TPFall" ) )
tTPRiseEnd = cross(clip(v("/Vline" ?result "tran") clipStart VAR("timeStop")) (VAR("VDDL") + (0.5 * vDiff)) 1 "rising")
plot( tTPRiseEnd ?expr '( "tTPRiseEnd" ) )
tTPFallEnd = cross(clip(v("/Vline" ?result "tran") clipStart VAR("timeStop")) (VAR("VDDH") - (0.5 * vDiff)) 1 "falling")
plot( tTPFallEnd ?expr '( "tTPFallEnd" ) )
hostMode( 'local )
resultsDir( "/net/kafka/nfs/rstdenis/Cadence/simulation/Dual_Supply_Test/spectre/schematic" )
modelFile(
    '("/software/cadence/ncsu-FreePDK15/hspice_16nm_hp.include" "")
)
run()
selectResult( 'tran )
plot(getData("/ILine/src") getData("/IVDDH/src") getData("/IVDDL/dst") getData("/VH") getData("/VL") getData("/Vline") )
LeakageIntoVDDL = average(clip(i("/IVDDL/dst" ?result "tran") tLeakageStart tLeakageEnd))
plot( LeakageIntoVDDL ?expr '( "LeakageIntoVDDL" ) )
LeakageLine = average(clip(i("/ILine/src" ?result "tran") tLeakageStart tLeakageEnd))
plot( LeakageLine ?expr '( "LeakageLine" ) )
LeakageVDDH = average(clip(i("/IVDDH/src" ?result "tran") tLeakageStart tLeakageEnd))
plot( LeakageVDDH ?expr '( "LeakageVDDH" ) )
QFall_pVDDL = ymax(iinteg(clip(i("/IVDDL/dst" ?result "tran") tFallSettleStart tFallSettleEnd)))
plot( QFall_pVDDL ?expr '( "QFall_pVDDL" ) )
QRise_pVDDH = ymax(iinteg(clip(i("/IVDDH/src" ?result "tran") tRiseSettleStart tRiseSettleEnd)))
plot( QRise_pVDDH ?expr '( "QRise_pVDDH" ) )
TSettleFall = (tFallSettleEnd - tFallSettleStart)
plot( TSettleFall ?expr '( "TSettleFall" ) )
TSettleRise = (tRiseSettleEnd - tRiseSettleStart)
plot( TSettleRise ?expr '( "TSettleRise" ) )
clipStart = (1.25 * VAR("period"))
plot( clipStart ?expr '( "clipStart" ) )
tFallEnd = cross(clip(v("/Vline" ?result "tran") clipStart VAR("timeStop")) (VAR("VDDH") - (0.9 * vDiff)) 1 "falling")
plot( tFallEnd ?expr '( "tFallEnd" ) )
tFallSettleEnd = cross(clip(v("/Vline" ?result "tran") clipStart VAR("timeStop")) (1.005 * VAR("VDDL")) 1 "falling")
plot( tFallSettleEnd ?expr '( "tFallSettleEnd" ) )
tFallSettleStart = cross(clip(v("/VH" ?result "tran") clipStart VAR("timeStop")) (0.5 * VAR("VDDH")) 1 "rising")
plot( tFallSettleStart ?expr '( "tFallSettleStart" ) )
tFallStart = cross(clip(v("/Vline" ?result "tran") clipStart VAR("timeStop")) (VAR("VDDH") - (0.1 * vDiff)) 1 "falling")
plot( tFallStart ?expr '( "tFallStart" ) )
tLeakageEnd = (clipStart + (0.51 * VAR("period")))
plot( tLeakageEnd ?expr '( "tLeakageEnd" ) )
tLeakageStart = (clipStart + (0.49 * VAR("period")))
plot( tLeakageStart ?expr '( "tLeakageStart" ) )
tRiseEnd = cross(clip(v("/Vline" ?result "tran") clipStart VAR("timeStop")) (VAR("VDDL") + (0.9 * vDiff)) 1 "rising")
plot( tRiseEnd ?expr '( "tRiseEnd" ) )
tRiseSettleEnd = cross(clip(v("/Vline" ?result "tran") clipStart VAR("timeStop")) (0.99 * VAR("VDDH")) 1 "rising")
plot( tRiseSettleEnd ?expr '( "tRiseSettleEnd" ) )
tRiseSettleStart = cross(clip(v("/VH" ?result "tran") clipStart VAR("timeStop")) (0.5 * VAR("VDDH")) 1 "falling")
plot( tRiseSettleStart ?expr '( "tRiseSettleStart" ) )
tRiseStart = cross(clip(v("/Vline" ?result "tran") clipStart VAR("timeStop")) (VAR("VDDL") + (0.1 * vDiff)) 1 "rising")
plot( tRiseStart ?expr '( "tRiseStart" ) )
vDiff = (VAR("VDDH") - VAR("VDDL"))
plot( vDiff ?expr '( "vDiff" ) )
TFall = (tFallStart - tFallEnd)
plot( TFall ?expr '( "TFall" ) )
TRise = (tRiseStart - tRiseEnd)
plot( TRise ?expr '( "TRise" ) )
TPRise = (tTPRiseEnd - tRiseSettleStart)
plot( TPRise ?expr '( "TPRise" ) )
TPFall = (tTPFallEnd - tFallSettleStart)
plot( TPFall ?expr '( "TPFall" ) )
tTPRiseEnd = cross(clip(v("/Vline" ?result "tran") clipStart VAR("timeStop")) (VAR("VDDL") + (0.5 * vDiff)) 1 "rising")
plot( tTPRiseEnd ?expr '( "tTPRiseEnd" ) )
tTPFallEnd = cross(clip(v("/Vline" ?result "tran") clipStart VAR("timeStop")) (VAR("VDDH") - (0.5 * vDiff)) 1 "falling")
plot( tTPFallEnd ?expr '( "tTPFallEnd" ) )
modelFile(
    '("/software/cadence/ncsu-FreePDK15/hspice_16nm_hp.include" "")
)
run()
selectResult( 'tran )
plot(getData("/ILine/src") getData("/IVDDH/src") getData("/IVDDL/dst") getData("/VH") getData("/VL") getData("/Vline") )
TSettleRise = (tRiseSettleEnd - tRiseSettleStart)
plot( TSettleRise ?expr '( "TSettleRise" ) )
tFallStart = cross(clip(v("/Vline" ?result "tran") clipStart VAR("timeStop")) (VAR("VDDH") - (0.1 * vDiff)) 1 "falling")
plot( tFallStart ?expr '( "tFallStart" ) )
tRiseEnd = cross(clip(v("/Vline" ?result "tran") clipStart VAR("timeStop")) (VAR("VDDL") + (0.9 * vDiff)) 1 "rising")
plot( tRiseEnd ?expr '( "tRiseEnd" ) )
tRiseSettleEnd = cross(clip(v("/Vline" ?result "tran") clipStart VAR("timeStop")) (0.99 * VAR("VDDH")) 1 "rising")
plot( tRiseSettleEnd ?expr '( "tRiseSettleEnd" ) )
TFall = (tFallStart - tFallEnd)
plot( TFall ?expr '( "TFall" ) )
TRise = (tRiseStart - tRiseEnd)
plot( TRise ?expr '( "TRise" ) )
TPRise = (tTPRiseEnd - tRiseSettleStart)
plot( TPRise ?expr '( "TPRise" ) )
TPFall = (tTPFallEnd - tFallSettleStart)
plot( TPFall ?expr '( "TPFall" ) )
tTPRiseEnd = cross(clip(v("/Vline" ?result "tran") clipStart VAR("timeStop")) (VAR("VDDL") + (0.5 * vDiff)) 1 "rising")
plot( tTPRiseEnd ?expr '( "tTPRiseEnd" ) )
tTPFallEnd = cross(clip(v("/Vline" ?result "tran") clipStart VAR("timeStop")) (VAR("VDDH") - (0.5 * vDiff)) 1 "falling")
plot( tTPFallEnd ?expr '( "tTPFallEnd" ) )
vDiff = (VAR("VDDH") - VAR("VDDL"))
plot( vDiff ?expr '( "vDiff" ) )
LeakageLine = average(clip(i("/ILine/src" ?result "tran") tLeakageStart tLeakageEnd))
plot( LeakageLine ?expr '( "LeakageLine" ) )
tRiseStart = cross(clip(v("/Vline" ?result "tran") clipStart VAR("timeStop")) (VAR("VDDL") + (0.1 * vDiff)) 1 "rising")
plot( tRiseStart ?expr '( "tRiseStart" ) )
tRiseSettleStart = cross(clip(v("/VH" ?result "tran") clipStart VAR("timeStop")) (0.5 * VAR("VDDH")) 1 "falling")
plot( tRiseSettleStart ?expr '( "tRiseSettleStart" ) )
tLeakageEnd = (clipStart + (0.51 * VAR("period")))
plot( tLeakageEnd ?expr '( "tLeakageEnd" ) )
tLeakageStart = (clipStart + (0.49 * VAR("period")))
plot( tLeakageStart ?expr '( "tLeakageStart" ) )
tFallEnd = cross(clip(v("/Vline" ?result "tran") clipStart VAR("timeStop")) (VAR("VDDH") - (0.9 * vDiff)) 1 "falling")
plot( tFallEnd ?expr '( "tFallEnd" ) )
tFallSettleEnd = cross(clip(v("/Vline" ?result "tran") clipStart VAR("timeStop")) (1.005 * VAR("VDDL")) 1 "falling")
plot( tFallSettleEnd ?expr '( "tFallSettleEnd" ) )
tFallSettleStart = cross(clip(v("/VH" ?result "tran") clipStart VAR("timeStop")) (0.5 * VAR("VDDH")) 1 "rising")
plot( tFallSettleStart ?expr '( "tFallSettleStart" ) )
clipStart = (1.25 * VAR("period"))
plot( clipStart ?expr '( "clipStart" ) )
LeakageVDDH = average(clip(i("/IVDDH/src" ?result "tran") tLeakageStart tLeakageEnd))
plot( LeakageVDDH ?expr '( "LeakageVDDH" ) )
TSettleFall = (tFallSettleEnd - tFallSettleStart)
plot( TSettleFall ?expr '( "TSettleFall" ) )
QRise_pVDDH = ymax(iinteg(clip(i("/IVDDH/src" ?result "tran") tRiseSettleStart tRiseSettleEnd)))
plot( QRise_pVDDH ?expr '( "QRise_pVDDH" ) )
QFall_pVDDL = ymax(iinteg(clip(i("/IVDDL/dst" ?result "tran") tFallSettleStart tFallSettleEnd)))
plot( QFall_pVDDL ?expr '( "QFall_pVDDL" ) )
LeakageIntoVDDL = average(clip(i("/IVDDL/dst" ?result "tran") tLeakageStart tLeakageEnd))
plot( LeakageIntoVDDL ?expr '( "LeakageIntoVDDL" ) )
modelFile(
    '("/software/cadence/ncsu-FreePDK15/hspice_16nm_hp.include" "")
)
run()
selectResult( 'tran )
plot(getData("/ILine/src") getData("/IVDDH/src") getData("/IVDDL/dst") getData("/VH") getData("/VL") getData("/Vline") )
TSettleRise = (tRiseSettleEnd - tRiseSettleStart)
plot( TSettleRise ?expr '( "TSettleRise" ) )
tFallStart = cross(clip(v("/Vline" ?result "tran") clipStart VAR("timeStop")) (VAR("VDDH") - (0.1 * vDiff)) 1 "falling")
plot( tFallStart ?expr '( "tFallStart" ) )
tRiseEnd = cross(clip(v("/Vline" ?result "tran") clipStart VAR("timeStop")) (VAR("VDDL") + (0.9 * vDiff)) 1 "rising")
plot( tRiseEnd ?expr '( "tRiseEnd" ) )
tRiseSettleEnd = cross(clip(v("/Vline" ?result "tran") clipStart VAR("timeStop")) (0.99 * VAR("VDDH")) 1 "rising")
plot( tRiseSettleEnd ?expr '( "tRiseSettleEnd" ) )
TFall = (tFallStart - tFallEnd)
plot( TFall ?expr '( "TFall" ) )
TRise = (tRiseStart - tRiseEnd)
plot( TRise ?expr '( "TRise" ) )
TPRise = (tTPRiseEnd - tRiseSettleStart)
plot( TPRise ?expr '( "TPRise" ) )
TPFall = (tTPFallEnd - tFallSettleStart)
plot( TPFall ?expr '( "TPFall" ) )
tTPRiseEnd = cross(clip(v("/Vline" ?result "tran") clipStart VAR("timeStop")) (VAR("VDDL") + (0.5 * vDiff)) 1 "rising")
plot( tTPRiseEnd ?expr '( "tTPRiseEnd" ) )
tTPFallEnd = cross(clip(v("/Vline" ?result "tran") clipStart VAR("timeStop")) (VAR("VDDH") - (0.5 * vDiff)) 1 "falling")
plot( tTPFallEnd ?expr '( "tTPFallEnd" ) )
vDiff = (VAR("VDDH") - VAR("VDDL"))
plot( vDiff ?expr '( "vDiff" ) )
LeakageLine = average(clip(i("/ILine/src" ?result "tran") tLeakageStart tLeakageEnd))
plot( LeakageLine ?expr '( "LeakageLine" ) )
tRiseStart = cross(clip(v("/Vline" ?result "tran") clipStart VAR("timeStop")) (VAR("VDDL") + (0.1 * vDiff)) 1 "rising")
plot( tRiseStart ?expr '( "tRiseStart" ) )
tRiseSettleStart = cross(clip(v("/VH" ?result "tran") clipStart VAR("timeStop")) (0.5 * VAR("VDDH")) 1 "falling")
plot( tRiseSettleStart ?expr '( "tRiseSettleStart" ) )
tLeakageEnd = (clipStart + (0.51 * VAR("period")))
plot( tLeakageEnd ?expr '( "tLeakageEnd" ) )
tLeakageStart = (clipStart + (0.49 * VAR("period")))
plot( tLeakageStart ?expr '( "tLeakageStart" ) )
tFallEnd = cross(clip(v("/Vline" ?result "tran") clipStart VAR("timeStop")) (VAR("VDDH") - (0.9 * vDiff)) 1 "falling")
plot( tFallEnd ?expr '( "tFallEnd" ) )
tFallSettleEnd = cross(clip(v("/Vline" ?result "tran") clipStart VAR("timeStop")) (1.005 * VAR("VDDL")) 1 "falling")
plot( tFallSettleEnd ?expr '( "tFallSettleEnd" ) )
tFallSettleStart = cross(clip(v("/VH" ?result "tran") clipStart VAR("timeStop")) (0.5 * VAR("VDDH")) 1 "rising")
plot( tFallSettleStart ?expr '( "tFallSettleStart" ) )
clipStart = (1.25 * VAR("period"))
plot( clipStart ?expr '( "clipStart" ) )
LeakageVDDH = average(clip(i("/IVDDH/src" ?result "tran") tLeakageStart tLeakageEnd))
plot( LeakageVDDH ?expr '( "LeakageVDDH" ) )
TSettleFall = (tFallSettleEnd - tFallSettleStart)
plot( TSettleFall ?expr '( "TSettleFall" ) )
QRise_pVDDH = ymax(iinteg(clip(i("/IVDDH/src" ?result "tran") tRiseSettleStart tRiseSettleEnd)))
plot( QRise_pVDDH ?expr '( "QRise_pVDDH" ) )
QFall_pVDDL = ymax(iinteg(clip(i("/IVDDL/dst" ?result "tran") tFallSettleStart tFallSettleEnd)))
plot( QFall_pVDDL ?expr '( "QFall_pVDDL" ) )
LeakageIntoVDDL = average(clip(i("/IVDDL/dst" ?result "tran") tLeakageStart tLeakageEnd))
plot( LeakageIntoVDDL ?expr '( "LeakageIntoVDDL" ) )
modelFile(
    '("/software/cadence/ncsu-FreePDK15/hspice_16nm_hp.include" "")
)
run()
selectResult( 'tran )
plot(getData("/ILine/src") getData("/IVDDH/src") getData("/IVDDL/dst") getData("/VH") getData("/VL") getData("/Vline") )
TSettleRise = (tRiseSettleEnd - tRiseSettleStart)
plot( TSettleRise ?expr '( "TSettleRise" ) )
tFallStart = cross(clip(v("/Vline" ?result "tran") clipStart VAR("timeStop")) (VAR("VDDH") - (0.1 * vDiff)) 1 "falling")
plot( tFallStart ?expr '( "tFallStart" ) )
tRiseEnd = cross(clip(v("/Vline" ?result "tran") clipStart VAR("timeStop")) (VAR("VDDL") + (0.9 * vDiff)) 1 "rising")
plot( tRiseEnd ?expr '( "tRiseEnd" ) )
tRiseSettleEnd = cross(clip(v("/Vline" ?result "tran") clipStart VAR("timeStop")) (0.99 * VAR("VDDH")) 1 "rising")
plot( tRiseSettleEnd ?expr '( "tRiseSettleEnd" ) )
TFall = (tFallStart - tFallEnd)
plot( TFall ?expr '( "TFall" ) )
TRise = (tRiseStart - tRiseEnd)
plot( TRise ?expr '( "TRise" ) )
TPRise = (tTPRiseEnd - tRiseSettleStart)
plot( TPRise ?expr '( "TPRise" ) )
TPFall = (tTPFallEnd - tFallSettleStart)
plot( TPFall ?expr '( "TPFall" ) )
tTPRiseEnd = cross(clip(v("/Vline" ?result "tran") clipStart VAR("timeStop")) (VAR("VDDL") + (0.5 * vDiff)) 1 "rising")
plot( tTPRiseEnd ?expr '( "tTPRiseEnd" ) )
tTPFallEnd = cross(clip(v("/Vline" ?result "tran") clipStart VAR("timeStop")) (VAR("VDDH") - (0.5 * vDiff)) 1 "falling")
plot( tTPFallEnd ?expr '( "tTPFallEnd" ) )
vDiff = (VAR("VDDH") - VAR("VDDL"))
plot( vDiff ?expr '( "vDiff" ) )
LeakageLine = average(clip(i("/ILine/src" ?result "tran") tLeakageStart tLeakageEnd))
plot( LeakageLine ?expr '( "LeakageLine" ) )
tRiseStart = cross(clip(v("/Vline" ?result "tran") clipStart VAR("timeStop")) (VAR("VDDL") + (0.1 * vDiff)) 1 "rising")
plot( tRiseStart ?expr '( "tRiseStart" ) )
tRiseSettleStart = cross(clip(v("/VH" ?result "tran") clipStart VAR("timeStop")) (0.5 * VAR("VDDH")) 1 "falling")
plot( tRiseSettleStart ?expr '( "tRiseSettleStart" ) )
tLeakageEnd = (clipStart + (0.51 * VAR("period")))
plot( tLeakageEnd ?expr '( "tLeakageEnd" ) )
tLeakageStart = (clipStart + (0.49 * VAR("period")))
plot( tLeakageStart ?expr '( "tLeakageStart" ) )
tFallEnd = cross(clip(v("/Vline" ?result "tran") clipStart VAR("timeStop")) (VAR("VDDH") - (0.9 * vDiff)) 1 "falling")
plot( tFallEnd ?expr '( "tFallEnd" ) )
tFallSettleEnd = cross(clip(v("/Vline" ?result "tran") clipStart VAR("timeStop")) (1.005 * VAR("VDDL")) 1 "falling")
plot( tFallSettleEnd ?expr '( "tFallSettleEnd" ) )
tFallSettleStart = cross(clip(v("/VH" ?result "tran") clipStart VAR("timeStop")) (0.5 * VAR("VDDH")) 1 "rising")
plot( tFallSettleStart ?expr '( "tFallSettleStart" ) )
clipStart = (1.25 * VAR("period"))
plot( clipStart ?expr '( "clipStart" ) )
LeakageVDDH = average(clip(i("/IVDDH/src" ?result "tran") tLeakageStart tLeakageEnd))
plot( LeakageVDDH ?expr '( "LeakageVDDH" ) )
TSettleFall = (tFallSettleEnd - tFallSettleStart)
plot( TSettleFall ?expr '( "TSettleFall" ) )
QRise_pVDDH = ymax(iinteg(clip(i("/IVDDH/src" ?result "tran") tRiseSettleStart tRiseSettleEnd)))
plot( QRise_pVDDH ?expr '( "QRise_pVDDH" ) )
QFall_pVDDL = ymax(iinteg(clip(i("/IVDDL/dst" ?result "tran") tFallSettleStart tFallSettleEnd)))
plot( QFall_pVDDL ?expr '( "QFall_pVDDL" ) )
LeakageIntoVDDL = average(clip(i("/IVDDL/dst" ?result "tran") tLeakageStart tLeakageEnd))
plot( LeakageIntoVDDL ?expr '( "LeakageIntoVDDL" ) )
modelFile(
    '("/software/cadence/ncsu-FreePDK15/hspice_16nm_hp.include" "")
)
desVar(	  "C" 536f	)
desVar(	  "nfin" 62	)
run()
selectResult( 'tran )
plot(getData("/ILine/src") getData("/IVDDH/src") getData("/IVDDL/dst") getData("/VH") getData("/VL") getData("/Vline") )
LeakageIntoVDDL = average(clip(i("/IVDDL/dst" ?result "tran") tLeakageStart tLeakageEnd))
plot( LeakageIntoVDDL ?expr '( "LeakageIntoVDDL" ) )
LeakageLine = average(clip(i("/ILine/src" ?result "tran") tLeakageStart tLeakageEnd))
plot( LeakageLine ?expr '( "LeakageLine" ) )
LeakageVDDH = average(clip(i("/IVDDH/src" ?result "tran") tLeakageStart tLeakageEnd))
plot( LeakageVDDH ?expr '( "LeakageVDDH" ) )
QFall_pVDDL = ymax(iinteg(clip(i("/IVDDL/dst" ?result "tran") tFallSettleStart tFallSettleEnd)))
plot( QFall_pVDDL ?expr '( "QFall_pVDDL" ) )
QRise_pVDDH = ymax(iinteg(clip(i("/IVDDH/src" ?result "tran") tRiseSettleStart tRiseSettleEnd)))
plot( QRise_pVDDH ?expr '( "QRise_pVDDH" ) )
TFall = (tFallStart - tFallEnd)
plot( TFall ?expr '( "TFall" ) )
TPFall = (tTPFallEnd - tFallSettleStart)
plot( TPFall ?expr '( "TPFall" ) )
TPRise = (tTPRiseEnd - tRiseSettleStart)
plot( TPRise ?expr '( "TPRise" ) )
TRise = (tRiseStart - tRiseEnd)
plot( TRise ?expr '( "TRise" ) )
TSettleFall = (tFallSettleEnd - tFallSettleStart)
plot( TSettleFall ?expr '( "TSettleFall" ) )
TSettleRise = (tRiseSettleEnd - tRiseSettleStart)
plot( TSettleRise ?expr '( "TSettleRise" ) )
clipStart = (1.25 * VAR("period"))
plot( clipStart ?expr '( "clipStart" ) )
tFallEnd = cross(clip(v("/Vline" ?result "tran") clipStart VAR("timeStop")) (VAR("VDDH") - (0.9 * vDiff)) 1 "falling")
plot( tFallEnd ?expr '( "tFallEnd" ) )
tFallSettleEnd = cross(clip(v("/Vline" ?result "tran") clipStart VAR("timeStop")) (1.005 * VAR("VDDL")) 1 "falling")
plot( tFallSettleEnd ?expr '( "tFallSettleEnd" ) )
tFallSettleStart = cross(clip(v("/VH" ?result "tran") clipStart VAR("timeStop")) (0.5 * VAR("VDDH")) 1 "rising")
plot( tFallSettleStart ?expr '( "tFallSettleStart" ) )
tFallStart = cross(clip(v("/Vline" ?result "tran") clipStart VAR("timeStop")) (VAR("VDDH") - (0.1 * vDiff)) 1 "falling")
plot( tFallStart ?expr '( "tFallStart" ) )
tLeakageEnd = (clipStart + (0.51 * VAR("period")))
plot( tLeakageEnd ?expr '( "tLeakageEnd" ) )
tLeakageStart = (clipStart + (0.49 * VAR("period")))
plot( tLeakageStart ?expr '( "tLeakageStart" ) )
tRiseEnd = cross(clip(v("/Vline" ?result "tran") clipStart VAR("timeStop")) (VAR("VDDL") + (0.9 * vDiff)) 1 "rising")
plot( tRiseEnd ?expr '( "tRiseEnd" ) )
tRiseSettleEnd = cross(clip(v("/Vline" ?result "tran") clipStart VAR("timeStop")) (0.99 * VAR("VDDH")) 1 "rising")
plot( tRiseSettleEnd ?expr '( "tRiseSettleEnd" ) )
tRiseSettleStart = cross(clip(v("/VH" ?result "tran") clipStart VAR("timeStop")) (0.5 * VAR("VDDH")) 1 "falling")
plot( tRiseSettleStart ?expr '( "tRiseSettleStart" ) )
tRiseStart = cross(clip(v("/Vline" ?result "tran") clipStart VAR("timeStop")) (VAR("VDDL") + (0.1 * vDiff)) 1 "rising")
plot( tRiseStart ?expr '( "tRiseStart" ) )
tTPFallEnd = cross(clip(v("/Vline" ?result "tran") clipStart VAR("timeStop")) (VAR("VDDH") - (0.5 * vDiff)) 1 "falling")
plot( tTPFallEnd ?expr '( "tTPFallEnd" ) )
tTPRiseEnd = cross(clip(v("/Vline" ?result "tran") clipStart VAR("timeStop")) (VAR("VDDL") + (0.5 * vDiff)) 1 "rising")
plot( tTPRiseEnd ?expr '( "tTPRiseEnd" ) )
vDiff = (VAR("VDDH") - VAR("VDDL"))
plot( vDiff ?expr '( "vDiff" ) )
modelFile(
    '("/software/cadence/ncsu-FreePDK15/hspice_16nm_hp.include" "")
)
run()
selectResult( 'tran )
plot(getData("/ILine/src") getData("/IVDDH/src") getData("/IVDDL/dst") getData("/VH") getData("/VL") getData("/Vline") )
LeakageIntoVDDL = average(clip(i("/IVDDL/dst" ?result "tran") tLeakageStart tLeakageEnd))
plot( LeakageIntoVDDL ?expr '( "LeakageIntoVDDL" ) )
LeakageLine = average(clip(i("/ILine/src" ?result "tran") tLeakageStart tLeakageEnd))
plot( LeakageLine ?expr '( "LeakageLine" ) )
LeakageVDDH = average(clip(i("/IVDDH/src" ?result "tran") tLeakageStart tLeakageEnd))
plot( LeakageVDDH ?expr '( "LeakageVDDH" ) )
QFall_pVDDL = ymax(iinteg(clip(i("/IVDDL/dst" ?result "tran") tFallSettleStart tFallSettleEnd)))
plot( QFall_pVDDL ?expr '( "QFall_pVDDL" ) )
QRise_pVDDH = ymax(iinteg(clip(i("/IVDDH/src" ?result "tran") tRiseSettleStart tRiseSettleEnd)))
plot( QRise_pVDDH ?expr '( "QRise_pVDDH" ) )
TFall = (tFallStart - tFallEnd)
plot( TFall ?expr '( "TFall" ) )
TPFall = (tTPFallEnd - tFallSettleStart)
plot( TPFall ?expr '( "TPFall" ) )
TPRise = (tTPRiseEnd - tRiseSettleStart)
plot( TPRise ?expr '( "TPRise" ) )
TRise = (tRiseStart - tRiseEnd)
plot( TRise ?expr '( "TRise" ) )
TSettleFall = (tFallSettleEnd - tFallSettleStart)
plot( TSettleFall ?expr '( "TSettleFall" ) )
TSettleRise = (tRiseSettleEnd - tRiseSettleStart)
plot( TSettleRise ?expr '( "TSettleRise" ) )
clipStart = (1.25 * VAR("period"))
plot( clipStart ?expr '( "clipStart" ) )
tFallEnd = cross(cVline (VAR("VDDH") - (0.9 * vDiff)) 1 "falling")
plot( tFallEnd ?expr '( "tFallEnd" ) )
tFallSettleEnd = cross(clip(v("/Vline" ?result "tran") clipStart VAR("timeStop")) (1.005 * VAR("VDDL")) 1 "falling")
plot( tFallSettleEnd ?expr '( "tFallSettleEnd" ) )
tFallSettleStart = cross(clip(v("/VH" ?result "tran") clipStart VAR("timeStop")) (0.5 * VAR("VDDH")) 1 "rising")
plot( tFallSettleStart ?expr '( "tFallSettleStart" ) )
tFallStart = cross(cVline (VAR("VDDH") - (0.1 * vDiff)) 1 "falling")
plot( tFallStart ?expr '( "tFallStart" ) )
tLeakageEnd = (clipStart + (0.51 * VAR("period")))
plot( tLeakageEnd ?expr '( "tLeakageEnd" ) )
tLeakageStart = (clipStart + (0.49 * VAR("period")))
plot( tLeakageStart ?expr '( "tLeakageStart" ) )
tRiseEnd = cross(cVline (VAR("VDDL") + (0.9 * vDiff)) 1 "rising")
plot( tRiseEnd ?expr '( "tRiseEnd" ) )
tRiseSettleEnd = cross(cVline (0.99 * VAR("VDDH")) 1 "rising")
plot( tRiseSettleEnd ?expr '( "tRiseSettleEnd" ) )
tRiseSettleStart = cross(clip(v("/VH" ?result "tran") clipStart VAR("timeStop")) (0.5 * VAR("VDDH")) 1 "falling")
plot( tRiseSettleStart ?expr '( "tRiseSettleStart" ) )
tRiseStart = cross(cVline (VAR("VDDL") + (0.1 * vDiff)) 1 "rising")
plot( tRiseStart ?expr '( "tRiseStart" ) )
tTPFallEnd = cross(cVline (VAR("VDDH") - (0.5 * vDiff)) 1 "falling")
plot( tTPFallEnd ?expr '( "tTPFallEnd" ) )
tTPRiseEnd = cross(clip(v("/Vline" ?result "tran") clipStart VAR("timeStop")) (VAR("VDDL") + (0.5 * vDiff)) 1 "rising")
plot( tTPRiseEnd ?expr '( "tTPRiseEnd" ) )
vDiff = (VAR("VDDH") - VAR("VDDL"))
plot( vDiff ?expr '( "vDiff" ) )
cVline = clip(v("/Vline" ?result "tran") clipStart VAR("timeStop"))
plot( cVline ?expr '( "cVline" ) )
modelFile(
    '("/software/cadence/ncsu-FreePDK15/hspice_16nm_hp.include" "")
)
desVar(	  "C" 596.31f	)
run()
selectResult( 'tran )
plot(getData("/ILine/src") getData("/IVDDH/src") getData("/IVDDL/dst") getData("/VH") getData("/VL") getData("/Vline") )
vDiff = (VAR("VDDH") - VAR("VDDL"))
plot( vDiff ?expr '( "vDiff" ) )
LeakageVDDH = average(clip(i("/IVDDH/src" ?result "tran") tLeakageStart tLeakageEnd))
plot( LeakageVDDH ?expr '( "LeakageVDDH" ) )
LeakageLine = average(clip(i("/ILine/src" ?result "tran") tLeakageStart tLeakageEnd))
plot( LeakageLine ?expr '( "LeakageLine" ) )
LeakageIntoVDDL = average(clip(i("/IVDDL/dst" ?result "tran") tLeakageStart tLeakageEnd))
plot( LeakageIntoVDDL ?expr '( "LeakageIntoVDDL" ) )
tFallSettleEnd = cross(clip(v("/Vline" ?result "tran") clipStart VAR("timeStop")) (1.005 * VAR("VDDL")) 1 "falling")
plot( tFallSettleEnd ?expr '( "tFallSettleEnd" ) )
tFallEnd = cross(cVline (VAR("VDDH") - (0.9 * vDiff)) 1 "falling")
plot( tFallEnd ?expr '( "tFallEnd" ) )
tFallStart = cross(cVline (VAR("VDDH") - (0.1 * vDiff)) 1 "falling")
plot( tFallStart ?expr '( "tFallStart" ) )
tTPFallEnd = cross(cVline (VAR("VDDH") - (0.5 * vDiff)) 1 "falling")
plot( tTPFallEnd ?expr '( "tTPFallEnd" ) )
tFallSettleStart = cross(clip(v("/VH" ?result "tran") clipStart VAR("timeStop")) (0.5 * VAR("VDDH")) 1 "rising")
plot( tFallSettleStart ?expr '( "tFallSettleStart" ) )
tLeakageEnd = (clipStart + (0.51 * VAR("period")))
plot( tLeakageEnd ?expr '( "tLeakageEnd" ) )
tLeakageStart = (clipStart + (0.49 * VAR("period")))
plot( tLeakageStart ?expr '( "tLeakageStart" ) )
tRiseSettleEnd = cross(cVline (0.99 * VAR("VDDH")) 1 "rising")
plot( tRiseSettleEnd ?expr '( "tRiseSettleEnd" ) )
tRiseEnd = cross(cVline (VAR("VDDL") + (0.9 * vDiff)) 1 "rising")
plot( tRiseEnd ?expr '( "tRiseEnd" ) )
tTPRiseEnd = cross(clip(v("/Vline" ?result "tran") clipStart VAR("timeStop")) (VAR("VDDL") + (0.5 * vDiff)) 1 "rising")
plot( tTPRiseEnd ?expr '( "tTPRiseEnd" ) )
tRiseStart = cross(cVline (VAR("VDDL") + (0.1 * vDiff)) 1 "rising")
plot( tRiseStart ?expr '( "tRiseStart" ) )
tRiseSettleStart = cross(clip(v("/VH" ?result "tran") clipStart VAR("timeStop")) (0.5 * VAR("VDDH")) 1 "falling")
plot( tRiseSettleStart ?expr '( "tRiseSettleStart" ) )
clipStart = (1.25 * VAR("period"))
plot( clipStart ?expr '( "clipStart" ) )
TSettleFall = (tFallSettleEnd - tFallSettleStart)
plot( TSettleFall ?expr '( "TSettleFall" ) )
TSettleRise = (tRiseSettleEnd - tRiseSettleStart)
plot( TSettleRise ?expr '( "TSettleRise" ) )
TPRise = (tTPRiseEnd - tRiseSettleStart)
plot( TPRise ?expr '( "TPRise" ) )
TPFall = (tTPFallEnd - tFallSettleStart)
plot( TPFall ?expr '( "TPFall" ) )
QRise_pVDDH = ymax(iinteg(clip(i("/IVDDH/src" ?result "tran") tRiseSettleStart tRiseSettleEnd)))
plot( QRise_pVDDH ?expr '( "QRise_pVDDH" ) )
QFall_pVDDL = ymax(iinteg(clip(i("/IVDDL/dst" ?result "tran") tFallSettleStart tFallSettleEnd)))
plot( QFall_pVDDL ?expr '( "QFall_pVDDL" ) )
TRise = (tRiseEnd - tRiseStart)
plot( TRise ?expr '( "TRise" ) )
TFall = (tFallEnd - tFallStart)
plot( TFall ?expr '( "TFall" ) )
cVline = clip(v("/Vline" ?result "tran") clipStart VAR("timeStop"))
plot( cVline ?expr '( "cVline" ) )
hostMode( 'distributed )
resultsDir( "/net/kafka/nfs/rstdenis/Cadence/simulation/Dual_Supply_Test/spectre/schematic/distributed/job002" )
modelFile(
    '("/software/cadence/ncsu-FreePDK15/hspice_16nm_hp.include" "")
)
run( ?jobName "job" ?queue "c2107" )
selectResult( 'tran )
plot(getData("/ILine/src") getData("/IVDDH/src") getData("/IVDDL/dst") getData("/VH") getData("/VL") getData("/Vline") )
LeakageIntoVDDL = average(clip(i("/IVDDL/dst" ?result "tran") tLeakageStart tLeakageEnd))
plot( LeakageIntoVDDL ?expr '( "LeakageIntoVDDL" ) )
LeakageLine = average(clip(i("/ILine/src" ?result "tran") tLeakageStart tLeakageEnd))
plot( LeakageLine ?expr '( "LeakageLine" ) )
LeakageVDDH = average(clip(i("/IVDDH/src" ?result "tran") tLeakageStart tLeakageEnd))
plot( LeakageVDDH ?expr '( "LeakageVDDH" ) )
QFall_pVDDL = ymax(iinteg(clip(i("/IVDDL/dst" ?result "tran") tFallSettleStart tFallSettleEnd)))
plot( QFall_pVDDL ?expr '( "QFall_pVDDL" ) )
QRise_pVDDH = ymax(iinteg(clip(i("/IVDDH/src" ?result "tran") tRiseSettleStart tRiseSettleEnd)))
plot( QRise_pVDDH ?expr '( "QRise_pVDDH" ) )
TFall = (tFallEnd - tFallStart)
plot( TFall ?expr '( "TFall" ) )
TPFall = (tTPFallEnd - tFallSettleStart)
plot( TPFall ?expr '( "TPFall" ) )
TPRise = (tTPRiseEnd - tRiseSettleStart)
plot( TPRise ?expr '( "TPRise" ) )
TRise = (tRiseEnd - tRiseStart)
plot( TRise ?expr '( "TRise" ) )
TSettleFall = (tFallSettleEnd - tFallSettleStart)
plot( TSettleFall ?expr '( "TSettleFall" ) )
TSettleRise = (tRiseSettleEnd - tRiseSettleStart)
plot( TSettleRise ?expr '( "TSettleRise" ) )
cVline = clip(v("/Vline" ?result "tran") clipStart VAR("timeStop"))
plot( cVline ?expr '( "cVline" ) )
clipStart = (1.25 * VAR("period"))
plot( clipStart ?expr '( "clipStart" ) )
tFallEnd = cross(cVline (VAR("VDDH") - (0.9 * vDiff)) 1 "falling")
plot( tFallEnd ?expr '( "tFallEnd" ) )
tFallSettleEnd = cross(cVline (1.005 * VAR("VDDL")) 1 "falling")
plot( tFallSettleEnd ?expr '( "tFallSettleEnd" ) )
tFallSettleStart = cross(clip(v("/VH" ?result "tran") clipStart VAR("timeStop")) (0.5 * VAR("VDDH")) 1 "rising")
plot( tFallSettleStart ?expr '( "tFallSettleStart" ) )
tFallStart = cross(cVline (VAR("VDDH") - (0.1 * vDiff)) 1 "falling")
plot( tFallStart ?expr '( "tFallStart" ) )
tLeakageEnd = (clipStart + (0.51 * VAR("period")))
plot( tLeakageEnd ?expr '( "tLeakageEnd" ) )
tLeakageStart = (clipStart + (0.49 * VAR("period")))
plot( tLeakageStart ?expr '( "tLeakageStart" ) )
tRiseEnd = cross(cVline (VAR("VDDL") + (0.9 * vDiff)) 1 "rising")
plot( tRiseEnd ?expr '( "tRiseEnd" ) )
tRiseSettleEnd = cross(cVline (0.99 * VAR("VDDH")) 1 "rising")
plot( tRiseSettleEnd ?expr '( "tRiseSettleEnd" ) )
tRiseSettleStart = cross(clip(v("/VH" ?result "tran") clipStart VAR("timeStop")) (0.5 * VAR("VDDH")) 1 "falling")
plot( tRiseSettleStart ?expr '( "tRiseSettleStart" ) )
tRiseStart = cross(cVline (VAR("VDDL") + (0.1 * vDiff)) 1 "rising")
plot( tRiseStart ?expr '( "tRiseStart" ) )
tTPFallEnd = cross(cVline (VAR("VDDH") - (0.5 * vDiff)) 1 "falling")
plot( tTPFallEnd ?expr '( "tTPFallEnd" ) )
tTPRiseEnd = cross(cVline (VAR("VDDL") + (0.5 * vDiff)) 1 "rising")
plot( tTPRiseEnd ?expr '( "tTPRiseEnd" ) )
vDiff = (VAR("VDDH") - VAR("VDDL"))
plot( vDiff ?expr '( "vDiff" ) )
hostMode( 'local )
resultsDir( "/net/kafka/nfs/rstdenis/Cadence/simulation/Dual_Supply_Test/spectre/schematic" )
modelFile(
    '("/software/cadence/ncsu-FreePDK15/hspice_16nm_hp.include" "")
)
run()
selectResult( 'tran )
plot(getData("/ILine/src") getData("/IVDDH/src") getData("/IVDDL/dst") getData("/VH") getData("/VL") getData("/Vline") )
LeakageIntoVDDL = average(clip(i("/IVDDL/dst" ?result "tran") tLeakageStart tLeakageEnd))
plot( LeakageIntoVDDL ?expr '( "LeakageIntoVDDL" ) )
LeakageLine = average(clip(i("/ILine/src" ?result "tran") tLeakageStart tLeakageEnd))
plot( LeakageLine ?expr '( "LeakageLine" ) )
LeakageVDDH = average(clip(i("/IVDDH/src" ?result "tran") tLeakageStart tLeakageEnd))
plot( LeakageVDDH ?expr '( "LeakageVDDH" ) )
QFall_pVDDL = ymax(iinteg(clip(i("/IVDDL/dst" ?result "tran") tFallSettleStart tFallSettleEnd)))
plot( QFall_pVDDL ?expr '( "QFall_pVDDL" ) )
QRise_pVDDH = ymax(iinteg(clip(i("/IVDDH/src" ?result "tran") tRiseSettleStart tRiseSettleEnd)))
plot( QRise_pVDDH ?expr '( "QRise_pVDDH" ) )
TFall = (tFallEnd - tFallStart)
plot( TFall ?expr '( "TFall" ) )
TPFall = (tTPFallEnd - tFallSettleStart)
plot( TPFall ?expr '( "TPFall" ) )
TPRise = (tTPRiseEnd - tRiseSettleStart)
plot( TPRise ?expr '( "TPRise" ) )
TRise = (tRiseEnd - tRiseStart)
plot( TRise ?expr '( "TRise" ) )
TSettleFall = (tFallSettleEnd - tFallSettleStart)
plot( TSettleFall ?expr '( "TSettleFall" ) )
TSettleRise = (tRiseSettleEnd - tRiseSettleStart)
plot( TSettleRise ?expr '( "TSettleRise" ) )
cVline = clip(v("/Vline" ?result "tran") clipStart VAR("timeStop"))
plot( cVline ?expr '( "cVline" ) )
clipStart = (1.25 * VAR("period"))
plot( clipStart ?expr '( "clipStart" ) )
tFallEnd = cross(cVline (VAR("VDDH") - (0.9 * vDiff)) 1 "falling")
plot( tFallEnd ?expr '( "tFallEnd" ) )
tFallSettleEnd = cross(cVline (1.005 * VAR("VDDL")) 1 "falling")
plot( tFallSettleEnd ?expr '( "tFallSettleEnd" ) )
tFallSettleStart = cross(clip(v("/VH" ?result "tran") clipStart VAR("timeStop")) (0.5 * VAR("VDDH")) 1 "rising")
plot( tFallSettleStart ?expr '( "tFallSettleStart" ) )
tFallStart = cross(cVline (VAR("VDDH") - (0.1 * vDiff)) 1 "falling")
plot( tFallStart ?expr '( "tFallStart" ) )
tLeakageEnd = (clipStart + (0.51 * VAR("period")))
plot( tLeakageEnd ?expr '( "tLeakageEnd" ) )
tLeakageStart = (clipStart + (0.49 * VAR("period")))
plot( tLeakageStart ?expr '( "tLeakageStart" ) )
tRiseEnd = cross(cVline (VAR("VDDL") + (0.9 * vDiff)) 1 "rising")
plot( tRiseEnd ?expr '( "tRiseEnd" ) )
tRiseSettleEnd = cross(cVline (0.99 * VAR("VDDH")) 1 "rising")
plot( tRiseSettleEnd ?expr '( "tRiseSettleEnd" ) )
tRiseSettleStart = cross(clip(v("/VH" ?result "tran") clipStart VAR("timeStop")) (0.5 * VAR("VDDH")) 1 "falling")
plot( tRiseSettleStart ?expr '( "tRiseSettleStart" ) )
tRiseStart = cross(cVline (VAR("VDDL") + (0.1 * vDiff)) 1 "rising")
plot( tRiseStart ?expr '( "tRiseStart" ) )
tTPFallEnd = cross(cVline (VAR("VDDH") - (0.5 * vDiff)) 1 "falling")
plot( tTPFallEnd ?expr '( "tTPFallEnd" ) )
tTPRiseEnd = cross(cVline (VAR("VDDL") + (0.5 * vDiff)) 1 "rising")
plot( tTPRiseEnd ?expr '( "tTPRiseEnd" ) )
vDiff = (VAR("VDDH") - VAR("VDDL"))
plot( vDiff ?expr '( "vDiff" ) )
