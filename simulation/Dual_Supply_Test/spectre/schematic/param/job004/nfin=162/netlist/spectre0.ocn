simulator( 'spectre )
design(	 "/net/kafka/nfs/rstdenis/Cadence/simulation/Dual_Supply_Test/spectre/schematic/netlist/netlist")
resultsDir( "/net/kafka/nfs/rstdenis/Cadence/simulation/Dual_Supply_Test/spectre/schematic" )
modelFile(
    '("/root/Desktop/Cadence/ncsu-FreePDK15/PTM-MG/smodels.scs" "")
)
analysis('tran ?stop "VAR(\"timeStop\")"  ?errpreset "conservative"  )
desVar(	  "nfin" 12	)
desVar(	  "timeF" "5n+7n+7n+10p"	)
desVar(	  "timeE" "5n+7n+7n"	)
desVar(	  "timeD" "5n+7n+10p"	)
desVar(	  "timeC" "5n+7n"	)
desVar(	  "timeB" "5n+10p"	)
desVar(	  "timeA" 5n	)
desVar(	  "VDDL" .450	)
desVar(	  "VDDH" .600	)
desVar(	  "C" 500f	)
desVar(	  "timeStop" 33n	)
envOption(
	'cmd64bit  t
	'analysisOrder  list("tran")
)
option(	'multithread  "on"
)
save( 'v "/Vline" "/VL" "/VH" )
save( 'i "/IVDDH/src" "/IVDDL/dst" "/ILine/src" )
converge( 'ic "/VL" "0" )
converge( 'ic "/sH" "VDDH" )
converge( 'ic "/VH" "VDDH" )
converge( 'ic "/Vline" "VDDL" )
converge( 'ic "/I19/I0/I0/I7/I3/Q0" "0" )
converge( 'ic "/I19/I0/I0/I7/I3/Q1" "VDDL" )
temp( 27 )
run()
selectResult( 'tran )
plot(getData("/Vline") getData("/VL") getData("/VH") getData("/IVDDH/src") getData("/IVDDL/dst") getData("/ILine/src") )
TSettleRise = (tRiseSettleEnd - tRiseSettleStart)
plot( TSettleRise ?expr '( "TSettleRise" ) )
TSettleFall = (tFallSettleEnd - tFallSettleStart)
plot( TSettleFall ?expr '( "TSettleFall" ) )
LeakageLine = average(clip(i("/ILine/src" ?result "tran") tLeakageStart tLeakageEnd))
plot( LeakageLine ?expr '( "LeakageLine" ) )
LeakageIntoVDDL = average(clip(i("/IVDDL/dst" ?result "tran") tLeakageStart tLeakageEnd))
plot( LeakageIntoVDDL ?expr '( "LeakageIntoVDDL" ) )
LeakageVDDH = average(clip(i("/IVDDH/src" ?result "tran") tLeakageStart tLeakageEnd))
plot( LeakageVDDH ?expr '( "LeakageVDDH" ) )
tRiseSettleStart = cross(v("/VH" ?result "tran") (0.5 * VAR("VDDH")) 2 "falling")
plot( tRiseSettleStart ?expr '( "tRiseSettleStart" ) )
tRiseSettleEnd = cross(v("/Vline" ?result "tran") (0.99 * VAR("VDDH")) 2 "rising")
plot( tRiseSettleEnd ?expr '( "tRiseSettleEnd" ) )
tFallSettleEnd = cross(v("/Vline" ?result "tran") (1.005 * VAR("VDDL")) 1 "falling")
plot( tFallSettleEnd ?expr '( "tFallSettleEnd" ) )
tFallSettleStart = cross(v("/VH" ?result "tran") (0.5 * VAR("VDDH")) 1 "rising")
plot( tFallSettleStart ?expr '( "tFallSettleStart" ) )
QRise_pVDDH = ymax(iinteg(clip(i("/IVDDH/src" ?result "tran") tRiseSettleStart tRiseSettleEnd)))
plot( QRise_pVDDH ?expr '( "QRise_pVDDH" ) )
QFall_pVDDL = ymax(iinteg(clip(i("/IVDDL/dst" ?result "tran") tFallSettleStart tFallSettleEnd)))
plot( QFall_pVDDL ?expr '( "QFall_pVDDL" ) )
tLeakageStart = (VAR("timeB") + (0.49 * (VAR("timeC") - VAR("timeB"))))
plot( tLeakageStart ?expr '( "tLeakageStart" ) )
tLeakageEnd = (VAR("timeC") - (0.49 * (VAR("timeC") - VAR("timeB"))))
plot( tLeakageEnd ?expr '( "tLeakageEnd" ) )
tRiseStart = cross(v("/Vline" ?result "tran") (VAR("VDDL") + (0.1 * vDiff)) 2 "rising")
plot( tRiseStart ?expr '( "tRiseStart" ) )
tFallStart = cross(v("/Vline" ?result "tran") (VAR("VDDH") - (0.1 * vDiff)) 1 "falling")
plot( tFallStart ?expr '( "tFallStart" ) )
tRiseEnd = cross(v("/Vline" ?result "tran") (VAR("VDDL") + (0.9 * vDiff)) 2 "rising")
plot( tRiseEnd ?expr '( "tRiseEnd" ) )
vDiff = (VAR("VDDH") - VAR("VDDL"))
plot( vDiff ?expr '( "vDiff" ) )
tFallEnd = cross(v("/Vline" ?result "tran") (VAR("VDDH") - (0.9 * vDiff)) 1 "falling")
plot( tFallEnd ?expr '( "tFallEnd" ) )
modelFile(
    '("/root/Desktop/Cadence/ncsu-FreePDK15/PTM-MG/smodels.scs" "")
)
desVar(	  "C" 300f	)
run()
selectResult( 'tran )
plot(getData("/Vline") getData("/VL") getData("/VH") getData("/IVDDH/src") getData("/IVDDL/dst") getData("/ILine/src") )
TSettleRise = (tRiseSettleEnd - tRiseSettleStart)
plot( TSettleRise ?expr '( "TSettleRise" ) )
TSettleFall = (tFallSettleEnd - tFallSettleStart)
plot( TSettleFall ?expr '( "TSettleFall" ) )
LeakageLine = average(clip(i("/ILine/src" ?result "tran") tLeakageStart tLeakageEnd))
plot( LeakageLine ?expr '( "LeakageLine" ) )
LeakageIntoVDDL = average(clip(i("/IVDDL/dst" ?result "tran") tLeakageStart tLeakageEnd))
plot( LeakageIntoVDDL ?expr '( "LeakageIntoVDDL" ) )
LeakageVDDH = average(clip(i("/IVDDH/src" ?result "tran") tLeakageStart tLeakageEnd))
plot( LeakageVDDH ?expr '( "LeakageVDDH" ) )
tRiseSettleStart = cross(v("/VH" ?result "tran") (0.5 * VAR("VDDH")) 2 "falling")
plot( tRiseSettleStart ?expr '( "tRiseSettleStart" ) )
tRiseSettleEnd = cross(v("/Vline" ?result "tran") (0.99 * VAR("VDDH")) 2 "rising")
plot( tRiseSettleEnd ?expr '( "tRiseSettleEnd" ) )
tFallSettleEnd = cross(v("/Vline" ?result "tran") (1.005 * VAR("VDDL")) 1 "falling")
plot( tFallSettleEnd ?expr '( "tFallSettleEnd" ) )
tFallSettleStart = cross(v("/VH" ?result "tran") (0.5 * VAR("VDDH")) 1 "rising")
plot( tFallSettleStart ?expr '( "tFallSettleStart" ) )
QRise_pVDDH = ymax(iinteg(clip(i("/IVDDH/src" ?result "tran") tRiseSettleStart tRiseSettleEnd)))
plot( QRise_pVDDH ?expr '( "QRise_pVDDH" ) )
QFall_pVDDL = ymax(iinteg(clip(i("/IVDDL/dst" ?result "tran") tFallSettleStart tFallSettleEnd)))
plot( QFall_pVDDL ?expr '( "QFall_pVDDL" ) )
tLeakageStart = (VAR("timeB") + (0.49 * (VAR("timeC") - VAR("timeB"))))
plot( tLeakageStart ?expr '( "tLeakageStart" ) )
tLeakageEnd = (VAR("timeC") - (0.49 * (VAR("timeC") - VAR("timeB"))))
plot( tLeakageEnd ?expr '( "tLeakageEnd" ) )
tRiseStart = cross(v("/Vline" ?result "tran") (VAR("VDDL") + (0.1 * vDiff)) 2 "rising")
plot( tRiseStart ?expr '( "tRiseStart" ) )
tFallStart = cross(v("/Vline" ?result "tran") (VAR("VDDH") - (0.1 * vDiff)) 1 "falling")
plot( tFallStart ?expr '( "tFallStart" ) )
tRiseEnd = cross(v("/Vline" ?result "tran") (VAR("VDDL") + (0.9 * vDiff)) 2 "rising")
plot( tRiseEnd ?expr '( "tRiseEnd" ) )
vDiff = (VAR("VDDH") - VAR("VDDL"))
plot( vDiff ?expr '( "vDiff" ) )
tFallEnd = cross(v("/Vline" ?result "tran") (VAR("VDDH") - (0.9 * vDiff)) 1 "falling")
plot( tFallEnd ?expr '( "tFallEnd" ) )
modelFile(
    '("/root/Desktop/Cadence/ncsu-FreePDK15/PTM-MG/smodels.scs" "")
)
desVar(	  "timeStop" 28n	)
run()
selectResult( 'tran )
plot(getData("/Vline") getData("/VL") getData("/VH") getData("/IVDDH/src") getData("/IVDDL/dst") getData("/ILine/src") )
TSettleRise = (tRiseSettleEnd - tRiseSettleStart)
plot( TSettleRise ?expr '( "TSettleRise" ) )
TSettleFall = (tFallSettleEnd - tFallSettleStart)
plot( TSettleFall ?expr '( "TSettleFall" ) )
LeakageLine = average(clip(i("/ILine/src" ?result "tran") tLeakageStart tLeakageEnd))
plot( LeakageLine ?expr '( "LeakageLine" ) )
LeakageIntoVDDL = average(clip(i("/IVDDL/dst" ?result "tran") tLeakageStart tLeakageEnd))
plot( LeakageIntoVDDL ?expr '( "LeakageIntoVDDL" ) )
LeakageVDDH = average(clip(i("/IVDDH/src" ?result "tran") tLeakageStart tLeakageEnd))
plot( LeakageVDDH ?expr '( "LeakageVDDH" ) )
tRiseSettleStart = cross(v("/VH" ?result "tran") (0.5 * VAR("VDDH")) 2 "falling")
plot( tRiseSettleStart ?expr '( "tRiseSettleStart" ) )
tRiseSettleEnd = cross(v("/Vline" ?result "tran") (0.99 * VAR("VDDH")) 2 "rising")
plot( tRiseSettleEnd ?expr '( "tRiseSettleEnd" ) )
tFallSettleEnd = cross(v("/Vline" ?result "tran") (1.005 * VAR("VDDL")) 1 "falling")
plot( tFallSettleEnd ?expr '( "tFallSettleEnd" ) )
tFallSettleStart = cross(v("/VH" ?result "tran") (0.5 * VAR("VDDH")) 1 "rising")
plot( tFallSettleStart ?expr '( "tFallSettleStart" ) )
QRise_pVDDH = ymax(iinteg(clip(i("/IVDDH/src" ?result "tran") tRiseSettleStart tRiseSettleEnd)))
plot( QRise_pVDDH ?expr '( "QRise_pVDDH" ) )
QFall_pVDDL = ymax(iinteg(clip(i("/IVDDL/dst" ?result "tran") tFallSettleStart tFallSettleEnd)))
plot( QFall_pVDDL ?expr '( "QFall_pVDDL" ) )
tLeakageStart = (VAR("timeB") + (0.49 * (VAR("timeC") - VAR("timeB"))))
plot( tLeakageStart ?expr '( "tLeakageStart" ) )
tLeakageEnd = (VAR("timeC") - (0.49 * (VAR("timeC") - VAR("timeB"))))
plot( tLeakageEnd ?expr '( "tLeakageEnd" ) )
tRiseStart = cross(v("/Vline" ?result "tran") (VAR("VDDL") + (0.1 * vDiff)) 2 "rising")
plot( tRiseStart ?expr '( "tRiseStart" ) )
tFallStart = cross(v("/Vline" ?result "tran") (VAR("VDDH") - (0.1 * vDiff)) 1 "falling")
plot( tFallStart ?expr '( "tFallStart" ) )
tRiseEnd = cross(v("/Vline" ?result "tran") (VAR("VDDL") + (0.9 * vDiff)) 2 "rising")
plot( tRiseEnd ?expr '( "tRiseEnd" ) )
vDiff = (VAR("VDDH") - VAR("VDDL"))
plot( vDiff ?expr '( "vDiff" ) )
tFallEnd = cross(v("/Vline" ?result "tran") (VAR("VDDH") - (0.9 * vDiff)) 1 "falling")
plot( tFallEnd ?expr '( "tFallEnd" ) )
modelFile(
    '("/root/Desktop/Cadence/ncsu-FreePDK15/PTM-MG/smodels.scs" "")
)
desVar(	  "C" 26.3f	)
run()
selectResult( 'tran )
plot(getData("/Vline") getData("/VL") getData("/VH") getData("/IVDDH/src") getData("/IVDDL/dst") getData("/ILine/src") )
TSettleRise = (tRiseSettleEnd - tRiseSettleStart)
plot( TSettleRise ?expr '( "TSettleRise" ) )
TSettleFall = (tFallSettleEnd - tFallSettleStart)
plot( TSettleFall ?expr '( "TSettleFall" ) )
LeakageLine = average(clip(i("/ILine/src" ?result "tran") tLeakageStart tLeakageEnd))
plot( LeakageLine ?expr '( "LeakageLine" ) )
LeakageIntoVDDL = average(clip(i("/IVDDL/dst" ?result "tran") tLeakageStart tLeakageEnd))
plot( LeakageIntoVDDL ?expr '( "LeakageIntoVDDL" ) )
LeakageVDDH = average(clip(i("/IVDDH/src" ?result "tran") tLeakageStart tLeakageEnd))
plot( LeakageVDDH ?expr '( "LeakageVDDH" ) )
tRiseSettleStart = cross(v("/VH" ?result "tran") (0.5 * VAR("VDDH")) 2 "falling")
plot( tRiseSettleStart ?expr '( "tRiseSettleStart" ) )
tRiseSettleEnd = cross(v("/Vline" ?result "tran") (0.99 * VAR("VDDH")) 2 "rising")
plot( tRiseSettleEnd ?expr '( "tRiseSettleEnd" ) )
tFallSettleEnd = cross(v("/Vline" ?result "tran") (1.005 * VAR("VDDL")) 1 "falling")
plot( tFallSettleEnd ?expr '( "tFallSettleEnd" ) )
tFallSettleStart = cross(v("/VH" ?result "tran") (0.5 * VAR("VDDH")) 1 "rising")
plot( tFallSettleStart ?expr '( "tFallSettleStart" ) )
QRise_pVDDH = ymax(iinteg(clip(i("/IVDDH/src" ?result "tran") tRiseSettleStart tRiseSettleEnd)))
plot( QRise_pVDDH ?expr '( "QRise_pVDDH" ) )
QFall_pVDDL = ymax(iinteg(clip(i("/IVDDL/dst" ?result "tran") tFallSettleStart tFallSettleEnd)))
plot( QFall_pVDDL ?expr '( "QFall_pVDDL" ) )
tLeakageStart = (VAR("timeB") + (0.49 * (VAR("timeC") - VAR("timeB"))))
plot( tLeakageStart ?expr '( "tLeakageStart" ) )
tLeakageEnd = (VAR("timeC") - (0.49 * (VAR("timeC") - VAR("timeB"))))
plot( tLeakageEnd ?expr '( "tLeakageEnd" ) )
tRiseStart = cross(v("/Vline" ?result "tran") (VAR("VDDL") + (0.1 * vDiff)) 2 "rising")
plot( tRiseStart ?expr '( "tRiseStart" ) )
tFallStart = cross(v("/Vline" ?result "tran") (VAR("VDDH") - (0.1 * vDiff)) 1 "falling")
plot( tFallStart ?expr '( "tFallStart" ) )
tRiseEnd = cross(v("/Vline" ?result "tran") (VAR("VDDL") + (0.9 * vDiff)) 2 "rising")
plot( tRiseEnd ?expr '( "tRiseEnd" ) )
vDiff = (VAR("VDDH") - VAR("VDDL"))
plot( vDiff ?expr '( "vDiff" ) )
tFallEnd = cross(v("/Vline" ?result "tran") (VAR("VDDH") - (0.9 * vDiff)) 1 "falling")
plot( tFallEnd ?expr '( "tFallEnd" ) )
modelFile(
    '("/root/Desktop/Cadence/ncsu-FreePDK15/PTM-MG/smodels.scs" "")
)
desVar(	  "C" 300f	)
run()
selectResult( 'tran )
plot(getData("/Vline") getData("/VL") getData("/VH") getData("/IVDDH/src") getData("/IVDDL/dst") getData("/ILine/src") )
TSettleRise = (tRiseSettleEnd - tRiseSettleStart)
plot( TSettleRise ?expr '( "TSettleRise" ) )
TSettleFall = (tFallSettleEnd - tFallSettleStart)
plot( TSettleFall ?expr '( "TSettleFall" ) )
LeakageLine = average(clip(i("/ILine/src" ?result "tran") tLeakageStart tLeakageEnd))
plot( LeakageLine ?expr '( "LeakageLine" ) )
LeakageIntoVDDL = average(clip(i("/IVDDL/dst" ?result "tran") tLeakageStart tLeakageEnd))
plot( LeakageIntoVDDL ?expr '( "LeakageIntoVDDL" ) )
LeakageVDDH = average(clip(i("/IVDDH/src" ?result "tran") tLeakageStart tLeakageEnd))
plot( LeakageVDDH ?expr '( "LeakageVDDH" ) )
tRiseSettleStart = cross(v("/VH" ?result "tran") (0.5 * VAR("VDDH")) 2 "falling")
plot( tRiseSettleStart ?expr '( "tRiseSettleStart" ) )
tRiseSettleEnd = cross(v("/Vline" ?result "tran") (0.99 * VAR("VDDH")) 2 "rising")
plot( tRiseSettleEnd ?expr '( "tRiseSettleEnd" ) )
tFallSettleEnd = cross(v("/Vline" ?result "tran") (1.005 * VAR("VDDL")) 1 "falling")
plot( tFallSettleEnd ?expr '( "tFallSettleEnd" ) )
tFallSettleStart = cross(v("/VH" ?result "tran") (0.5 * VAR("VDDH")) 1 "rising")
plot( tFallSettleStart ?expr '( "tFallSettleStart" ) )
QRise_pVDDH = ymax(iinteg(clip(i("/IVDDH/src" ?result "tran") tRiseSettleStart tRiseSettleEnd)))
plot( QRise_pVDDH ?expr '( "QRise_pVDDH" ) )
QFall_pVDDL = ymax(iinteg(clip(i("/IVDDL/dst" ?result "tran") tFallSettleStart tFallSettleEnd)))
plot( QFall_pVDDL ?expr '( "QFall_pVDDL" ) )
tLeakageStart = (VAR("timeB") + (0.49 * (VAR("timeC") - VAR("timeB"))))
plot( tLeakageStart ?expr '( "tLeakageStart" ) )
tLeakageEnd = (VAR("timeC") - (0.49 * (VAR("timeC") - VAR("timeB"))))
plot( tLeakageEnd ?expr '( "tLeakageEnd" ) )
tRiseStart = cross(v("/Vline" ?result "tran") (VAR("VDDL") + (0.1 * vDiff)) 2 "rising")
plot( tRiseStart ?expr '( "tRiseStart" ) )
tFallStart = cross(v("/Vline" ?result "tran") (VAR("VDDH") - (0.1 * vDiff)) 1 "falling")
plot( tFallStart ?expr '( "tFallStart" ) )
tRiseEnd = cross(v("/Vline" ?result "tran") (VAR("VDDL") + (0.9 * vDiff)) 2 "rising")
plot( tRiseEnd ?expr '( "tRiseEnd" ) )
vDiff = (VAR("VDDH") - VAR("VDDL"))
plot( vDiff ?expr '( "vDiff" ) )
tFallEnd = cross(v("/Vline" ?result "tran") (VAR("VDDH") - (0.9 * vDiff)) 1 "falling")
plot( tFallEnd ?expr '( "tFallEnd" ) )
modelFile(
    '("/root/Desktop/Cadence/ncsu-FreePDK15/PTM-MG/smodels.scs" "")
)
desVar(	  "timeB" "timeA+timerf"	)
desVar(	  "timerf" 10p	)
run()
selectResult( 'tran )
plot(getData("/Vline") getData("/VL") getData("/VH") getData("/IVDDH/src") getData("/IVDDL/dst") getData("/ILine/src") )
TSettleRise = (tRiseSettleEnd - tRiseSettleStart)
plot( TSettleRise ?expr '( "TSettleRise" ) )
TSettleFall = (tFallSettleEnd - tFallSettleStart)
plot( TSettleFall ?expr '( "TSettleFall" ) )
LeakageLine = average(clip(i("/ILine/src" ?result "tran") tLeakageStart tLeakageEnd))
plot( LeakageLine ?expr '( "LeakageLine" ) )
LeakageIntoVDDL = average(clip(i("/IVDDL/dst" ?result "tran") tLeakageStart tLeakageEnd))
plot( LeakageIntoVDDL ?expr '( "LeakageIntoVDDL" ) )
LeakageVDDH = average(clip(i("/IVDDH/src" ?result "tran") tLeakageStart tLeakageEnd))
plot( LeakageVDDH ?expr '( "LeakageVDDH" ) )
tRiseSettleStart = cross(v("/VH" ?result "tran") (0.5 * VAR("VDDH")) 2 "falling")
plot( tRiseSettleStart ?expr '( "tRiseSettleStart" ) )
tRiseSettleEnd = cross(v("/Vline" ?result "tran") (0.99 * VAR("VDDH")) 2 "rising")
plot( tRiseSettleEnd ?expr '( "tRiseSettleEnd" ) )
tFallSettleEnd = cross(v("/Vline" ?result "tran") (1.005 * VAR("VDDL")) 1 "falling")
plot( tFallSettleEnd ?expr '( "tFallSettleEnd" ) )
tFallSettleStart = cross(v("/VH" ?result "tran") (0.5 * VAR("VDDH")) 1 "rising")
plot( tFallSettleStart ?expr '( "tFallSettleStart" ) )
QRise_pVDDH = ymax(iinteg(clip(i("/IVDDH/src" ?result "tran") tRiseSettleStart tRiseSettleEnd)))
plot( QRise_pVDDH ?expr '( "QRise_pVDDH" ) )
QFall_pVDDL = ymax(iinteg(clip(i("/IVDDL/dst" ?result "tran") tFallSettleStart tFallSettleEnd)))
plot( QFall_pVDDL ?expr '( "QFall_pVDDL" ) )
tLeakageStart = (VAR("timeB") + (0.49 * (VAR("timeC") - VAR("timeB"))))
plot( tLeakageStart ?expr '( "tLeakageStart" ) )
tLeakageEnd = (VAR("timeC") - (0.49 * (VAR("timeC") - VAR("timeB"))))
plot( tLeakageEnd ?expr '( "tLeakageEnd" ) )
tRiseStart = cross(v("/Vline" ?result "tran") (VAR("VDDL") + (0.1 * vDiff)) 2 "rising")
plot( tRiseStart ?expr '( "tRiseStart" ) )
tFallStart = cross(v("/Vline" ?result "tran") (VAR("VDDH") - (0.1 * vDiff)) 1 "falling")
plot( tFallStart ?expr '( "tFallStart" ) )
tRiseEnd = cross(v("/Vline" ?result "tran") (VAR("VDDL") + (0.9 * vDiff)) 2 "rising")
plot( tRiseEnd ?expr '( "tRiseEnd" ) )
vDiff = (VAR("VDDH") - VAR("VDDL"))
plot( vDiff ?expr '( "vDiff" ) )
tFallEnd = cross(v("/Vline" ?result "tran") (VAR("VDDH") - (0.9 * vDiff)) 1 "falling")
plot( tFallEnd ?expr '( "tFallEnd" ) )
modelFile(
    '("/root/Desktop/Cadence/ncsu-FreePDK15/PTM-MG/smodels.scs" "")
)
desVar(	  "timeF" "timeE+timerf"	)
desVar(	  "timeD" "timeC+timerf"	)
desVar(	  "timeE" "timeC+timeWait"	)
desVar(	  "timeC" "timeA+timeWait"	)
desVar(	  "timeWait" 7n	)
run()
selectResult( 'tran )
plot(getData("/Vline") getData("/VL") getData("/VH") getData("/IVDDH/src") getData("/IVDDL/dst") getData("/ILine/src") )
TSettleRise = (tRiseSettleEnd - tRiseSettleStart)
plot( TSettleRise ?expr '( "TSettleRise" ) )
TSettleFall = (tFallSettleEnd - tFallSettleStart)
plot( TSettleFall ?expr '( "TSettleFall" ) )
LeakageLine = average(clip(i("/ILine/src" ?result "tran") tLeakageStart tLeakageEnd))
plot( LeakageLine ?expr '( "LeakageLine" ) )
LeakageIntoVDDL = average(clip(i("/IVDDL/dst" ?result "tran") tLeakageStart tLeakageEnd))
plot( LeakageIntoVDDL ?expr '( "LeakageIntoVDDL" ) )
LeakageVDDH = average(clip(i("/IVDDH/src" ?result "tran") tLeakageStart tLeakageEnd))
plot( LeakageVDDH ?expr '( "LeakageVDDH" ) )
tRiseSettleStart = cross(v("/VH" ?result "tran") (0.5 * VAR("VDDH")) 2 "falling")
plot( tRiseSettleStart ?expr '( "tRiseSettleStart" ) )
tRiseSettleEnd = cross(v("/Vline" ?result "tran") (0.99 * VAR("VDDH")) 2 "rising")
plot( tRiseSettleEnd ?expr '( "tRiseSettleEnd" ) )
tFallSettleEnd = cross(v("/Vline" ?result "tran") (1.005 * VAR("VDDL")) 1 "falling")
plot( tFallSettleEnd ?expr '( "tFallSettleEnd" ) )
tFallSettleStart = cross(v("/VH" ?result "tran") (0.5 * VAR("VDDH")) 1 "rising")
plot( tFallSettleStart ?expr '( "tFallSettleStart" ) )
QRise_pVDDH = ymax(iinteg(clip(i("/IVDDH/src" ?result "tran") tRiseSettleStart tRiseSettleEnd)))
plot( QRise_pVDDH ?expr '( "QRise_pVDDH" ) )
QFall_pVDDL = ymax(iinteg(clip(i("/IVDDL/dst" ?result "tran") tFallSettleStart tFallSettleEnd)))
plot( QFall_pVDDL ?expr '( "QFall_pVDDL" ) )
tLeakageStart = (VAR("timeB") + (0.49 * (VAR("timeC") - VAR("timeB"))))
plot( tLeakageStart ?expr '( "tLeakageStart" ) )
tLeakageEnd = (VAR("timeC") - (0.49 * (VAR("timeC") - VAR("timeB"))))
plot( tLeakageEnd ?expr '( "tLeakageEnd" ) )
tRiseStart = cross(v("/Vline" ?result "tran") (VAR("VDDL") + (0.1 * vDiff)) 2 "rising")
plot( tRiseStart ?expr '( "tRiseStart" ) )
tFallStart = cross(v("/Vline" ?result "tran") (VAR("VDDH") - (0.1 * vDiff)) 1 "falling")
plot( tFallStart ?expr '( "tFallStart" ) )
tRiseEnd = cross(v("/Vline" ?result "tran") (VAR("VDDL") + (0.9 * vDiff)) 2 "rising")
plot( tRiseEnd ?expr '( "tRiseEnd" ) )
vDiff = (VAR("VDDH") - VAR("VDDL"))
plot( vDiff ?expr '( "vDiff" ) )
tFallEnd = cross(v("/Vline" ?result "tran") (VAR("VDDH") - (0.9 * vDiff)) 1 "falling")
plot( tFallEnd ?expr '( "tFallEnd" ) )
modelFile(
    '("/root/Desktop/Cadence/ncsu-FreePDK15/PTM-MG/smodels.scs" "")
)
desVar(	  "timeStop" "timeE+timeWait"	)
desVar(	  "C" .59631p	)
run()
selectResult( 'tran )
plot(getData("/Vline") getData("/VL") getData("/VH") getData("/IVDDH/src") getData("/IVDDL/dst") getData("/ILine/src") )
TSettleRise = (tRiseSettleEnd - tRiseSettleStart)
plot( TSettleRise ?expr '( "TSettleRise" ) )
TSettleFall = (tFallSettleEnd - tFallSettleStart)
plot( TSettleFall ?expr '( "TSettleFall" ) )
LeakageLine = average(clip(i("/ILine/src" ?result "tran") tLeakageStart tLeakageEnd))
plot( LeakageLine ?expr '( "LeakageLine" ) )
LeakageIntoVDDL = average(clip(i("/IVDDL/dst" ?result "tran") tLeakageStart tLeakageEnd))
plot( LeakageIntoVDDL ?expr '( "LeakageIntoVDDL" ) )
LeakageVDDH = average(clip(i("/IVDDH/src" ?result "tran") tLeakageStart tLeakageEnd))
plot( LeakageVDDH ?expr '( "LeakageVDDH" ) )
tRiseSettleStart = cross(v("/VH" ?result "tran") (0.5 * VAR("VDDH")) 2 "falling")
plot( tRiseSettleStart ?expr '( "tRiseSettleStart" ) )
tRiseSettleEnd = cross(v("/Vline" ?result "tran") (0.99 * VAR("VDDH")) 2 "rising")
plot( tRiseSettleEnd ?expr '( "tRiseSettleEnd" ) )
tFallSettleEnd = cross(v("/Vline" ?result "tran") (1.005 * VAR("VDDL")) 1 "falling")
plot( tFallSettleEnd ?expr '( "tFallSettleEnd" ) )
tFallSettleStart = cross(v("/VH" ?result "tran") (0.5 * VAR("VDDH")) 1 "rising")
plot( tFallSettleStart ?expr '( "tFallSettleStart" ) )
QRise_pVDDH = ymax(iinteg(clip(i("/IVDDH/src" ?result "tran") tRiseSettleStart tRiseSettleEnd)))
plot( QRise_pVDDH ?expr '( "QRise_pVDDH" ) )
QFall_pVDDL = ymax(iinteg(clip(i("/IVDDL/dst" ?result "tran") tFallSettleStart tFallSettleEnd)))
plot( QFall_pVDDL ?expr '( "QFall_pVDDL" ) )
tLeakageStart = (VAR("timeB") + (0.49 * (VAR("timeC") - VAR("timeB"))))
plot( tLeakageStart ?expr '( "tLeakageStart" ) )
tLeakageEnd = (VAR("timeC") - (0.49 * (VAR("timeC") - VAR("timeB"))))
plot( tLeakageEnd ?expr '( "tLeakageEnd" ) )
tRiseStart = cross(v("/Vline" ?result "tran") (VAR("VDDL") + (0.1 * vDiff)) 2 "rising")
plot( tRiseStart ?expr '( "tRiseStart" ) )
tFallStart = cross(v("/Vline" ?result "tran") (VAR("VDDH") - (0.1 * vDiff)) 1 "falling")
plot( tFallStart ?expr '( "tFallStart" ) )
tRiseEnd = cross(v("/Vline" ?result "tran") (VAR("VDDL") + (0.9 * vDiff)) 2 "rising")
plot( tRiseEnd ?expr '( "tRiseEnd" ) )
vDiff = (VAR("VDDH") - VAR("VDDL"))
plot( vDiff ?expr '( "vDiff" ) )
tFallEnd = cross(v("/Vline" ?result "tran") (VAR("VDDH") - (0.9 * vDiff)) 1 "falling")
plot( tFallEnd ?expr '( "tFallEnd" ) )
modelFile(
    '("/root/Desktop/Cadence/ncsu-FreePDK15/PTM-MG/smodels.scs" "")
)
desVar(	  "timeB" "VAR(\"timeA\")+VAR(\"timerf\")"	)
desVar(	  "timeC" "VAR(\"timeA\")+VAR(\"timeWait\")"	)
run()
selectResult( 'tran )
plot(getData("/Vline") getData("/VL") getData("/VH") getData("/IVDDH/src") getData("/IVDDL/dst") getData("/ILine/src") )
TSettleRise = (tRiseSettleEnd - tRiseSettleStart)
plot( TSettleRise ?expr '( "TSettleRise" ) )
TSettleFall = (tFallSettleEnd - tFallSettleStart)
plot( TSettleFall ?expr '( "TSettleFall" ) )
LeakageLine = average(clip(i("/ILine/src" ?result "tran") tLeakageStart tLeakageEnd))
plot( LeakageLine ?expr '( "LeakageLine" ) )
LeakageIntoVDDL = average(clip(i("/IVDDL/dst" ?result "tran") tLeakageStart tLeakageEnd))
plot( LeakageIntoVDDL ?expr '( "LeakageIntoVDDL" ) )
LeakageVDDH = average(clip(i("/IVDDH/src" ?result "tran") tLeakageStart tLeakageEnd))
plot( LeakageVDDH ?expr '( "LeakageVDDH" ) )
tRiseSettleStart = cross(v("/VH" ?result "tran") (0.5 * VAR("VDDH")) 2 "falling")
plot( tRiseSettleStart ?expr '( "tRiseSettleStart" ) )
tRiseSettleEnd = cross(v("/Vline" ?result "tran") (0.99 * VAR("VDDH")) 2 "rising")
plot( tRiseSettleEnd ?expr '( "tRiseSettleEnd" ) )
tFallSettleEnd = cross(v("/Vline" ?result "tran") (1.005 * VAR("VDDL")) 1 "falling")
plot( tFallSettleEnd ?expr '( "tFallSettleEnd" ) )
tFallSettleStart = cross(v("/VH" ?result "tran") (0.5 * VAR("VDDH")) 1 "rising")
plot( tFallSettleStart ?expr '( "tFallSettleStart" ) )
QRise_pVDDH = ymax(iinteg(clip(i("/IVDDH/src" ?result "tran") tRiseSettleStart tRiseSettleEnd)))
plot( QRise_pVDDH ?expr '( "QRise_pVDDH" ) )
QFall_pVDDL = ymax(iinteg(clip(i("/IVDDL/dst" ?result "tran") tFallSettleStart tFallSettleEnd)))
plot( QFall_pVDDL ?expr '( "QFall_pVDDL" ) )
tLeakageStart = (VAR("timeB") + (0.49 * (VAR("timeC") - VAR("timeB"))))
plot( tLeakageStart ?expr '( "tLeakageStart" ) )
tLeakageEnd = (VAR("timeC") - (0.49 * (VAR("timeC") - VAR("timeB"))))
plot( tLeakageEnd ?expr '( "tLeakageEnd" ) )
tRiseStart = cross(v("/Vline" ?result "tran") (VAR("VDDL") + (0.1 * vDiff)) 2 "rising")
plot( tRiseStart ?expr '( "tRiseStart" ) )
tFallStart = cross(v("/Vline" ?result "tran") (VAR("VDDH") - (0.1 * vDiff)) 1 "falling")
plot( tFallStart ?expr '( "tFallStart" ) )
tRiseEnd = cross(v("/Vline" ?result "tran") (VAR("VDDL") + (0.9 * vDiff)) 2 "rising")
plot( tRiseEnd ?expr '( "tRiseEnd" ) )
vDiff = (VAR("VDDH") - VAR("VDDL"))
plot( vDiff ?expr '( "vDiff" ) )
tFallEnd = cross(v("/Vline" ?result "tran") (VAR("VDDH") - (0.9 * vDiff)) 1 "falling")
plot( tFallEnd ?expr '( "tFallEnd" ) )
modelFile(
    '("/root/Desktop/Cadence/ncsu-FreePDK15/PTM-MG/smodels.scs" "")
)
run()
selectResult( 'tran )
plot(getData("/Vline") getData("/VL") getData("/VH") getData("/IVDDH/src") getData("/IVDDL/dst") getData("/ILine/src") )
TSettleRise = (tRiseSettleEnd - tRiseSettleStart)
plot( TSettleRise ?expr '( "TSettleRise" ) )
TSettleFall = (tFallSettleEnd - tFallSettleStart)
plot( TSettleFall ?expr '( "TSettleFall" ) )
LeakageLine = average(clip(i("/ILine/src" ?result "tran") tLeakageStart tLeakageEnd))
plot( LeakageLine ?expr '( "LeakageLine" ) )
LeakageIntoVDDL = average(clip(i("/IVDDL/dst" ?result "tran") tLeakageStart tLeakageEnd))
plot( LeakageIntoVDDL ?expr '( "LeakageIntoVDDL" ) )
LeakageVDDH = average(clip(i("/IVDDH/src" ?result "tran") tLeakageStart tLeakageEnd))
plot( LeakageVDDH ?expr '( "LeakageVDDH" ) )
tRiseSettleStart = cross(v("/VH" ?result "tran") (0.5 * VAR("VDDH")) 2 "falling")
plot( tRiseSettleStart ?expr '( "tRiseSettleStart" ) )
tRiseSettleEnd = cross(v("/Vline" ?result "tran") (0.99 * VAR("VDDH")) 2 "rising")
plot( tRiseSettleEnd ?expr '( "tRiseSettleEnd" ) )
tFallSettleEnd = cross(v("/Vline" ?result "tran") (1.005 * VAR("VDDL")) 1 "falling")
plot( tFallSettleEnd ?expr '( "tFallSettleEnd" ) )
tFallSettleStart = cross(v("/VH" ?result "tran") (0.5 * VAR("VDDH")) 1 "rising")
plot( tFallSettleStart ?expr '( "tFallSettleStart" ) )
QRise_pVDDH = ymax(iinteg(clip(i("/IVDDH/src" ?result "tran") tRiseSettleStart tRiseSettleEnd)))
plot( QRise_pVDDH ?expr '( "QRise_pVDDH" ) )
QFall_pVDDL = ymax(iinteg(clip(i("/IVDDL/dst" ?result "tran") tFallSettleStart tFallSettleEnd)))
plot( QFall_pVDDL ?expr '( "QFall_pVDDL" ) )
tLeakageStart = (VAR("timeB") + (0.49 * (VAR("timeC") - VAR("timeB"))))
plot( tLeakageStart ?expr '( "tLeakageStart" ) )
tLeakageEnd = (VAR("timeC") - (0.49 * (VAR("timeC") - VAR("timeB"))))
plot( tLeakageEnd ?expr '( "tLeakageEnd" ) )
tRiseStart = cross(v("/Vline" ?result "tran") (VAR("VDDL") + (0.1 * vDiff)) 2 "rising")
plot( tRiseStart ?expr '( "tRiseStart" ) )
tFallStart = cross(v("/Vline" ?result "tran") (VAR("VDDH") - (0.1 * vDiff)) 1 "falling")
plot( tFallStart ?expr '( "tFallStart" ) )
tRiseEnd = cross(v("/Vline" ?result "tran") (VAR("VDDL") + (0.9 * vDiff)) 2 "rising")
plot( tRiseEnd ?expr '( "tRiseEnd" ) )
vDiff = (VAR("VDDH") - VAR("VDDL"))
plot( vDiff ?expr '( "vDiff" ) )
tFallEnd = cross(v("/Vline" ?result "tran") (VAR("VDDH") - (0.9 * vDiff)) 1 "falling")
plot( tFallEnd ?expr '( "tFallEnd" ) )
modelFile(
    '("/root/Desktop/Cadence/ncsu-FreePDK15/PTM-MG/smodels.scs" "")
)
desVar(	  "timeC" "timeA+timeWait"	)
desVar(	  "timeB" "timeA+timerf"	)
run()
selectResult( 'tran )
plot(getData("/Vline") getData("/VL") getData("/VH") getData("/IVDDH/src") getData("/IVDDL/dst") getData("/ILine/src") )
TSettleRise = (tRiseSettleEnd - tRiseSettleStart)
plot( TSettleRise ?expr '( "TSettleRise" ) )
TSettleFall = (tFallSettleEnd - tFallSettleStart)
plot( TSettleFall ?expr '( "TSettleFall" ) )
LeakageLine = average(clip(i("/ILine/src" ?result "tran") tLeakageStart tLeakageEnd))
plot( LeakageLine ?expr '( "LeakageLine" ) )
LeakageIntoVDDL = average(clip(i("/IVDDL/dst" ?result "tran") tLeakageStart tLeakageEnd))
plot( LeakageIntoVDDL ?expr '( "LeakageIntoVDDL" ) )
LeakageVDDH = average(clip(i("/IVDDH/src" ?result "tran") tLeakageStart tLeakageEnd))
plot( LeakageVDDH ?expr '( "LeakageVDDH" ) )
tRiseSettleStart = cross(v("/VH" ?result "tran") (0.5 * VAR("VDDH")) 2 "falling")
plot( tRiseSettleStart ?expr '( "tRiseSettleStart" ) )
tRiseSettleEnd = cross(v("/Vline" ?result "tran") (0.99 * VAR("VDDH")) 2 "rising")
plot( tRiseSettleEnd ?expr '( "tRiseSettleEnd" ) )
tFallSettleEnd = cross(v("/Vline" ?result "tran") (1.005 * VAR("VDDL")) 1 "falling")
plot( tFallSettleEnd ?expr '( "tFallSettleEnd" ) )
tFallSettleStart = cross(v("/VH" ?result "tran") (0.5 * VAR("VDDH")) 1 "rising")
plot( tFallSettleStart ?expr '( "tFallSettleStart" ) )
QRise_pVDDH = ymax(iinteg(clip(i("/IVDDH/src" ?result "tran") tRiseSettleStart tRiseSettleEnd)))
plot( QRise_pVDDH ?expr '( "QRise_pVDDH" ) )
QFall_pVDDL = ymax(iinteg(clip(i("/IVDDL/dst" ?result "tran") tFallSettleStart tFallSettleEnd)))
plot( QFall_pVDDL ?expr '( "QFall_pVDDL" ) )
tLeakageStart = (VAR("timeB") + (0.49 * (VAR("timeC") - VAR("timeB"))))
plot( tLeakageStart ?expr '( "tLeakageStart" ) )
tLeakageEnd = (VAR("timeC") - (0.49 * (VAR("timeC") - VAR("timeB"))))
plot( tLeakageEnd ?expr '( "tLeakageEnd" ) )
tRiseStart = cross(v("/Vline" ?result "tran") (VAR("VDDL") + (0.1 * vDiff)) 2 "rising")
plot( tRiseStart ?expr '( "tRiseStart" ) )
tFallStart = cross(v("/Vline" ?result "tran") (VAR("VDDH") - (0.1 * vDiff)) 1 "falling")
plot( tFallStart ?expr '( "tFallStart" ) )
tRiseEnd = cross(v("/Vline" ?result "tran") (VAR("VDDL") + (0.9 * vDiff)) 2 "rising")
plot( tRiseEnd ?expr '( "tRiseEnd" ) )
vDiff = (VAR("VDDH") - VAR("VDDL"))
plot( vDiff ?expr '( "vDiff" ) )
tFallEnd = cross(v("/Vline" ?result "tran") (VAR("VDDH") - (0.9 * vDiff)) 1 "falling")
plot( tFallEnd ?expr '( "tFallEnd" ) )
modelFile(
    '("/root/Desktop/Cadence/ncsu-FreePDK15/PTM-MG/smodels.scs" "")
)
desVar(	  "timeStop" 26n	)
desVar(	  "timeF" 19.01n	)
desVar(	  "timeE" 19n	)
desVar(	  "timeD" 12.01n	)
desVar(	  "timeC" 12n	)
desVar(	  "timeB" 5.01n	)
delete( 'desVar "timeWait" )
delete( 'desVar "timerf" )
run()
selectResult( 'tran )
plot(getData("/Vline") getData("/VL") getData("/VH") getData("/IVDDH/src") getData("/IVDDL/dst") getData("/ILine/src") )
TSettleRise = (tRiseSettleEnd - tRiseSettleStart)
plot( TSettleRise ?expr '( "TSettleRise" ) )
TSettleFall = (tFallSettleEnd - tFallSettleStart)
plot( TSettleFall ?expr '( "TSettleFall" ) )
LeakageLine = average(clip(i("/ILine/src" ?result "tran") tLeakageStart tLeakageEnd))
plot( LeakageLine ?expr '( "LeakageLine" ) )
LeakageIntoVDDL = average(clip(i("/IVDDL/dst" ?result "tran") tLeakageStart tLeakageEnd))
plot( LeakageIntoVDDL ?expr '( "LeakageIntoVDDL" ) )
LeakageVDDH = average(clip(i("/IVDDH/src" ?result "tran") tLeakageStart tLeakageEnd))
plot( LeakageVDDH ?expr '( "LeakageVDDH" ) )
tRiseSettleStart = cross(v("/VH" ?result "tran") (0.5 * VAR("VDDH")) 2 "falling")
plot( tRiseSettleStart ?expr '( "tRiseSettleStart" ) )
tRiseSettleEnd = cross(v("/Vline" ?result "tran") (0.99 * VAR("VDDH")) 2 "rising")
plot( tRiseSettleEnd ?expr '( "tRiseSettleEnd" ) )
tFallSettleEnd = cross(v("/Vline" ?result "tran") (1.005 * VAR("VDDL")) 1 "falling")
plot( tFallSettleEnd ?expr '( "tFallSettleEnd" ) )
tFallSettleStart = cross(v("/VH" ?result "tran") (0.5 * VAR("VDDH")) 1 "rising")
plot( tFallSettleStart ?expr '( "tFallSettleStart" ) )
QRise_pVDDH = ymax(iinteg(clip(i("/IVDDH/src" ?result "tran") tRiseSettleStart tRiseSettleEnd)))
plot( QRise_pVDDH ?expr '( "QRise_pVDDH" ) )
QFall_pVDDL = ymax(iinteg(clip(i("/IVDDL/dst" ?result "tran") tFallSettleStart tFallSettleEnd)))
plot( QFall_pVDDL ?expr '( "QFall_pVDDL" ) )
tLeakageStart = (VAR("timeB") + (0.49 * (VAR("timeC") - VAR("timeB"))))
plot( tLeakageStart ?expr '( "tLeakageStart" ) )
tLeakageEnd = (VAR("timeC") - (0.49 * (VAR("timeC") - VAR("timeB"))))
plot( tLeakageEnd ?expr '( "tLeakageEnd" ) )
tRiseStart = cross(v("/Vline" ?result "tran") (VAR("VDDL") + (0.1 * vDiff)) 2 "rising")
plot( tRiseStart ?expr '( "tRiseStart" ) )
tFallStart = cross(v("/Vline" ?result "tran") (VAR("VDDH") - (0.1 * vDiff)) 1 "falling")
plot( tFallStart ?expr '( "tFallStart" ) )
tRiseEnd = cross(v("/Vline" ?result "tran") (VAR("VDDL") + (0.9 * vDiff)) 2 "rising")
plot( tRiseEnd ?expr '( "tRiseEnd" ) )
vDiff = (VAR("VDDH") - VAR("VDDL"))
plot( vDiff ?expr '( "vDiff" ) )
tFallEnd = cross(v("/Vline" ?result "tran") (VAR("VDDH") - (0.9 * vDiff)) 1 "falling")
plot( tFallEnd ?expr '( "tFallEnd" ) )
hostMode( 'distributed )
resultsDir( "/net/kafka/nfs/rstdenis/Cadence/simulation/Dual_Supply_Test/spectre/schematic/distributed/job003" )
modelFile(
    '("/software/cadence/ncsu-FreePDK15/hspice_16nm_hp.include" "")
)
desVar(	  "nfin" 60	)
run( ?jobName "job" ?queue "c2107" )
selectResult( 'tran )
plot(getData("/Vline") getData("/VL") getData("/VH") getData("/IVDDH/src") getData("/IVDDL/dst") getData("/ILine/src") )
TSettleRise = (tRiseSettleEnd - tRiseSettleStart)
plot( TSettleRise ?expr '( "TSettleRise" ) )
TSettleFall = (tFallSettleEnd - tFallSettleStart)
plot( TSettleFall ?expr '( "TSettleFall" ) )
LeakageLine = average(clip(i("/ILine/src" ?result "tran") tLeakageStart tLeakageEnd))
plot( LeakageLine ?expr '( "LeakageLine" ) )
LeakageIntoVDDL = average(clip(i("/IVDDL/dst" ?result "tran") tLeakageStart tLeakageEnd))
plot( LeakageIntoVDDL ?expr '( "LeakageIntoVDDL" ) )
LeakageVDDH = average(clip(i("/IVDDH/src" ?result "tran") tLeakageStart tLeakageEnd))
plot( LeakageVDDH ?expr '( "LeakageVDDH" ) )
tRiseSettleStart = cross(v("/VH" ?result "tran") (0.5 * VAR("VDDH")) 2 "falling")
plot( tRiseSettleStart ?expr '( "tRiseSettleStart" ) )
tRiseSettleEnd = cross(v("/Vline" ?result "tran") (0.99 * VAR("VDDH")) 2 "rising")
plot( tRiseSettleEnd ?expr '( "tRiseSettleEnd" ) )
tFallSettleEnd = cross(v("/Vline" ?result "tran") (1.005 * VAR("VDDL")) 1 "falling")
plot( tFallSettleEnd ?expr '( "tFallSettleEnd" ) )
tFallSettleStart = cross(v("/VH" ?result "tran") (0.5 * VAR("VDDH")) 1 "rising")
plot( tFallSettleStart ?expr '( "tFallSettleStart" ) )
QRise_pVDDH = ymax(iinteg(clip(i("/IVDDH/src" ?result "tran") tRiseSettleStart tRiseSettleEnd)))
plot( QRise_pVDDH ?expr '( "QRise_pVDDH" ) )
QFall_pVDDL = ymax(iinteg(clip(i("/IVDDL/dst" ?result "tran") tFallSettleStart tFallSettleEnd)))
plot( QFall_pVDDL ?expr '( "QFall_pVDDL" ) )
tLeakageStart = (VAR("timeB") + (0.49 * (VAR("timeC") - VAR("timeB"))))
plot( tLeakageStart ?expr '( "tLeakageStart" ) )
tLeakageEnd = (VAR("timeC") - (0.49 * (VAR("timeC") - VAR("timeB"))))
plot( tLeakageEnd ?expr '( "tLeakageEnd" ) )
tRiseStart = cross(v("/Vline" ?result "tran") (VAR("VDDL") + (0.1 * vDiff)) 2 "rising")
plot( tRiseStart ?expr '( "tRiseStart" ) )
tFallStart = cross(v("/Vline" ?result "tran") (VAR("VDDH") - (0.1 * vDiff)) 1 "falling")
plot( tFallStart ?expr '( "tFallStart" ) )
tRiseEnd = cross(v("/Vline" ?result "tran") (VAR("VDDL") + (0.9 * vDiff)) 2 "rising")
plot( tRiseEnd ?expr '( "tRiseEnd" ) )
vDiff = (VAR("VDDH") - VAR("VDDL"))
plot( vDiff ?expr '( "vDiff" ) )
tFallEnd = cross(v("/Vline" ?result "tran") (VAR("VDDH") - (0.9 * vDiff)) 1 "falling")
plot( tFallEnd ?expr '( "tFallEnd" ) )
