simulator( 'spectre )
design(	 "/net/kafka/nfs/rstdenis/Cadence/simulation/Dual_Supply_Test/spectre/schematic/netlist/netlist")
resultsDir( "/net/kafka/nfs/rstdenis/Cadence/simulation/Dual_Supply_Test/spectre/schematic" )
modelFile(
    '("/root/Desktop/Cadence/ncsu-FreePDK15/hspice_20nm_hp.include" "")
)
analysis('tran ?stop "VAR(\"timeStop\")"  ?errpreset "conservative"  )
desVar(	  "startDelay" 5n	)
desVar(	  "period" 14n	)
desVar(	  "timeStop" 32n	)
desVar(	  "nfin" 60	)
desVar(	  "VDDL" .450	)
desVar(	  "VDDH" .600	)
desVar(	  "C" .59631p	)
desVar(	  "pulseWidth" 7n	)
envOption(
	'cmd64bit  t
	'analysisOrder  list("tran")
)
option(	'multithread  "on"
)
save( 'v "/VH" "/VL" "/Vline" )
save( 'i "/ILine/src" "/IVDDH/src" "/IVDDL/dst" )
converge( 'ic "/VL" "0" )
converge( 'ic "/VH" "VDDH" )
converge( 'ic "/Vline" "VDDL" )
converge( 'ic "/I19/I0/I0/I7/I3/Q0" "0" )
converge( 'ic "/I19/I0/I0/I7/I3/Q1" "VDDL" )
converge( 'ic "/sH" "VDDH" )
converge( 'ic "/net035" "0" )
run()
selectResult( 'tran )
plot(getData("/ILine/src") getData("/IVDDH/src") getData("/IVDDL/dst") getData("/VH") getData("/VL") getData("/Vline") )
LeakageIntoVDDL = average(clip(i("/IVDDL/dst" ?result "tran") tLeakageStart tLeakageEnd))
plot( LeakageIntoVDDL ?expr '( "LeakageIntoVDDL" ) )
LeakageLine = average(clip(i("/ILine/src" ?result "tran") tLeakageStart tLeakageEnd))
plot( LeakageLine ?expr '( "LeakageLine" ) )
LeakageVDDH = average(clip(i("/IVDDH/src" ?result "tran") tLeakageStart tLeakageEnd))
plot( LeakageVDDH ?expr '( "LeakageVDDH" ) )
QFall_pVDDL = ymax(iinteg(clip(i("/IVDDL/dst" ?result "tran") tFallSettleStart tFallSettleEnd)))
plot( QFall_pVDDL ?expr '( "QFall_pVDDL" ) )
QRise_pVDDH = ymax(iinteg(clip(i("/IVDDH/src" ?result "tran") tRiseSettleStart tRiseSettleEnd)))
plot( QRise_pVDDH ?expr '( "QRise_pVDDH" ) )
TSettleFall = (tFallSettleEnd - tFallSettleStart)
plot( TSettleFall ?expr '( "TSettleFall" ) )
TSettleRise = (tRiseSettleEnd - tRiseSettleStart)
plot( TSettleRise ?expr '( "TSettleRise" ) )
clipStart = (1.25 * VAR("period"))
plot( clipStart ?expr '( "clipStart" ) )
tFallEnd = cross(clip(v("/Vline" ?result "tran") clipStart VAR("timeStop")) (VAR("VDDH") - (0.9 * vDiff)) 1 "falling")
plot( tFallEnd ?expr '( "tFallEnd" ) )
tFallSettleEnd = cross(clip(v("/Vline" ?result "tran") clipStart VAR("timeStop")) (1.005 * VAR("VDDL")) 1 "falling")
plot( tFallSettleEnd ?expr '( "tFallSettleEnd" ) )
tFallSettleStart = cross(clip(v("/VH" ?result "tran") clipStart VAR("timeStop")) (0.5 * VAR("VDDH")) 1 "rising")
plot( tFallSettleStart ?expr '( "tFallSettleStart" ) )
tFallStart = cross(clip(v("/Vline" ?result "tran") clipStart VAR("timeStop")) (VAR("VDDH") - (0.1 * vDiff)) 1 "falling")
plot( tFallStart ?expr '( "tFallStart" ) )
tLeakageEnd = (clipStart + (0.51 * VAR("period")))
plot( tLeakageEnd ?expr '( "tLeakageEnd" ) )
tLeakageStart = (clipStart + (0.49 * VAR("period")))
plot( tLeakageStart ?expr '( "tLeakageStart" ) )
tRiseEnd = cross(clip(v("/Vline" ?result "tran") clipStart VAR("timeStop")) (VAR("VDDL") + (0.9 * vDiff)) 1 "rising")
plot( tRiseEnd ?expr '( "tRiseEnd" ) )
tRiseSettleEnd = cross(clip(v("/Vline" ?result "tran") clipStart VAR("timeStop")) (0.99 * VAR("VDDH")) 1 "rising")
plot( tRiseSettleEnd ?expr '( "tRiseSettleEnd" ) )
tRiseSettleStart = cross(clip(v("/VH" ?result "tran") clipStart VAR("timeStop")) (0.5 * VAR("VDDH")) 1 "falling")
plot( tRiseSettleStart ?expr '( "tRiseSettleStart" ) )
tRiseStart = cross(clip(v("/Vline" ?result "tran") clipStart VAR("timeStop")) (VAR("VDDL") + (0.1 * vDiff)) 1 "rising")
plot( tRiseStart ?expr '( "tRiseStart" ) )
vDiff = (VAR("VDDH") - VAR("VDDL"))
plot( vDiff ?expr '( "vDiff" ) )
