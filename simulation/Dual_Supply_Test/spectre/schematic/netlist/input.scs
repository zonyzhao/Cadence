// Design: 16nm_Tests/Dual_Supply_Test
simulator lang=spectre
global 0 vdd! vcc!
parameters C=2.5p timeE=15n timeF=15.25n timeC=8n timeD=8.25n VDDH=.600 VDDL=.400 timeB=1.25n timeA=1n
include "/root/Desktop/Cadence/ncsu-FreePDK15/hspice_16nm_hp.include"

// 16nm/6T_SetRead_PWR/schematic
subckt _sub20 \~R0 \~R1 Go SM0\<0\> SM0\<1\> SM1\<0\> SM1\<1\> GND
    M5 (\~R0 SM0\<0\> net18 GND) nfet w=40n l=16n nfin=1 nf=1 m=1
    M3 (\~R0 SM0\<1\> net18 GND) nfet w=40n l=16n nfin=1 nf=1 m=1
    M2 (net18 Go GND GND) nfet w=40n l=16n nfin=1 nf=1 m=1
    M1 (\~R1 SM1\<1\> net18 GND) nfet w=40n l=16n nfin=1 nf=1 m=1
    M0 (\~R1 SM1\<0\> net18 GND) nfet w=40n l=16n nfin=1 nf=1 m=1
ends _sub20

// 16nm/6T_32x_CTRL_PWR/schematic
subckt _sub21 B0 B1 S W0 W1 VDD GND
    M10 (B1 B0 net22 VDD) pfet w=100n l=20n nfin=1 nf=1 m=1
    M9 (net22 W1 VDD VDD) pfet w=100n l=20n nfin=1 nf=1 m=1
    M8 (B0 B1 net23 VDD) pfet w=100n l=20n nfin=1 nf=1 m=1
    M7 (net23 W0 VDD VDD) pfet w=100n l=20n nfin=1 nf=1 m=1
    M2 (B1 S VDD VDD) pfet w=100n l=20n nfin=1 nf=1 m=1
    M0 (B0 S VDD VDD) pfet w=100n l=20n nfin=1 nf=1 m=1
    M6 (B1 W1 net24 GND) nfet w=60n l=20n nfin=1 nf=1 m=1
    M5 (net24 S GND GND) nfet w=60n l=20n nfin=1 nf=1 m=1
    M4 (net25 S GND GND) nfet w=60n l=20n nfin=1 nf=1 m=1
    M3 (B0 W0 net25 GND) nfet w=60n l=20n nfin=1 nf=1 m=1
ends _sub21

// 16nm/6T_PWR/schematic
subckt _sub22 A B0 B1 VDD GND
    M5 (Q0 Q1 GND GND) nfet w=60n l=20n nfin=1 nf=1 m=1
    M4 (Q1 Q0 GND GND) nfet w=60n l=20n nfin=1 nf=1 m=1
    M1 (Q1 A B1 GND) nfet w=120n l=20n nfin=2 nf=1 m=1
    M0 (Q0 A B0 GND) nfet w=120n l=20n nfin=2 nf=1 m=1
    M3 (Q0 Q1 VDD VDD) pfet w=100n l=20n nfin=1 nf=1 m=1
    M2 (Q1 Q0 VDD VDD) pfet w=100n l=20n nfin=1 nf=1 m=1
ends _sub22

// 16nm/6T_4x_PWR/schematic
subckt _sub23 A\<3\> A\<2\> A\<1\> A\<0\> B0 B1 GND VDD
    I3 (A\<0\> B0 B1 VDD GND) _sub22
    I2 (A\<1\> B0 B1 VDD GND) _sub22
    I1 (A\<2\> B0 B1 VDD GND) _sub22
    I0 (A\<3\> B0 B1 VDD GND) _sub22
ends _sub23

// 16nm/6T_32x_PWR/schematic
subckt _sub24 A\<31\> A\<30\> A\<29\> A\<28\> A\<27\> A\<26\> A\<25\> A\<24\> A\<23\> A\<22\> A\<21\> A\<20\> A\<19\> A\<18\> A\<17\> A\<16\> A\<15\> A\<14\> A\<13\> A\<12\> A\<11\> A\<10\> A\<9\> A\<8\> A\<7\> A\<6\> A\<5\> A\<4\> A\<3\> A\<2\> A\<1\> A\<0\> B0 B1 GND VDD\<0\> VDD\<1\>
    I7 (A\<3\> A\<2\> A\<1\> A\<0\> B0 B1 GND VDD\<0\>) _sub23
    I6 (A\<7\> A\<6\> A\<5\> A\<4\> B0 B1 GND VDD\<0\>) _sub23
    I5 (A\<11\> A\<10\> A\<9\> A\<8\> B0 B1 GND VDD\<0\>) _sub23
    I4 (A\<15\> A\<14\> A\<13\> A\<12\> B0 B1 GND VDD\<0\>) _sub23
    I3 (A\<19\> A\<18\> A\<17\> A\<16\> B0 B1 GND VDD\<1\>) _sub23
    I2 (A\<23\> A\<22\> A\<21\> A\<20\> B0 B1 GND VDD\<1\>) _sub23
    I1 (A\<27\> A\<26\> A\<25\> A\<24\> B0 B1 GND VDD\<1\>) _sub23
    I0 (A\<31\> A\<30\> A\<29\> A\<28\> B0 B1 GND VDD\<1\>) _sub23
ends _sub24

// 16nm/nand4_1x_PWR/schematic
subckt nand4_1x_PWR A B C D GND VDD Y
    M5 (Y D VDD VDD) pfet w=100n l=20n nfin=1 nf=1 m=1
    M4 (Y C VDD VDD) pfet w=100n l=20n nfin=1 nf=1 m=1
    M1 (Y B VDD VDD) pfet w=100n l=20n nfin=1 nf=1 m=1
    M0 (Y A VDD VDD) pfet w=100n l=20n nfin=1 nf=1 m=1
    M7 (net23 D GND GND) nfet w=240n l=20n nfin=1 nf=1 m=1
    M6 (net25 C net23 GND) nfet w=240n l=20n nfin=1 nf=1 m=1
    M3 (net24 B net25 GND) nfet w=240n l=20n nfin=1 nf=1 m=1
    M2 (Y A net24 GND) nfet w=240n l=20n nfin=1 nf=1 m=1
ends nand4_1x_PWR

// 16nm/6T_32x4_PWR/schematic
subckt _sub25 A\<31\> A\<30\> A\<29\> A\<28\> A\<27\> A\<26\> A\<25\> A\<24\> A\<23\> A\<22\> A\<21\> A\<20\> A\<19\> A\<18\> A\<17\> A\<16\> A\<15\> A\<14\> A\<13\> A\<12\> A\<11\> A\<10\> A\<9\> A\<8\> A\<7\> A\<6\> A\<5\> A\<4\> A\<3\> A\<2\> A\<1\> A\<0\> B0 B1 GND S\<3\> S\<2\> S\<1\> S\<0\> SM0 SM1 VDD\<7\> VDD\<6\> VDD\<5\> VDD\<4\> VDD\<3\> VDD\<2\> VDD\<1\> VDD\<0\> VDDM W0 W1
    I4 (B0P1 B1P1 S\<0\> W0 W1 VDDM GND) _sub21
    I5 (B0P2 B1P2 S\<1\> W0 W1 VDDM GND) _sub21
    I6 (B0P3 B1P3 S\<2\> W0 W1 VDDM GND) _sub21
    I7 (B0P4 B1P4 S\<3\> W0 W1 VDDM GND) _sub21
    I3 (A\<31\> A\<30\> A\<29\> A\<28\> A\<27\> A\<26\> A\<25\> A\<24\> A\<23\> A\<22\> A\<21\> A\<20\> A\<19\> A\<18\> A\<17\> A\<16\> A\<15\> A\<14\> A\<13\> A\<12\> A\<11\> A\<10\> A\<9\> A\<8\> A\<7\> A\<6\> A\<5\> A\<4\> A\<3\> A\<2\> A\<1\> A\<0\> B0P4 B1P4 GND VDD\<6\> VDD\<7\>) _sub24
    I1 (A\<31\> A\<30\> A\<29\> A\<28\> A\<27\> A\<26\> A\<25\> A\<24\> A\<23\> A\<22\> A\<21\> A\<20\> A\<19\> A\<18\> A\<17\> A\<16\> A\<15\> A\<14\> A\<13\> A\<12\> A\<11\> A\<10\> A\<9\> A\<8\> A\<7\> A\<6\> A\<5\> A\<4\> A\<3\> A\<2\> A\<1\> A\<0\> B0P2 B1P2 GND VDD\<2\> VDD\<3\>) _sub24
    I2 (A\<31\> A\<30\> A\<29\> A\<28\> A\<27\> A\<26\> A\<25\> A\<24\> A\<23\> A\<22\> A\<21\> A\<20\> A\<19\> A\<18\> A\<17\> A\<16\> A\<15\> A\<14\> A\<13\> A\<12\> A\<11\> A\<10\> A\<9\> A\<8\> A\<7\> A\<6\> A\<5\> A\<4\> A\<3\> A\<2\> A\<1\> A\<0\> B0P3 B1P3 GND VDD\<4\> VDD\<5\>) _sub24
    I0 (A\<31\> A\<30\> A\<29\> A\<28\> A\<27\> A\<26\> A\<25\> A\<24\> A\<23\> A\<22\> A\<21\> A\<20\> A\<19\> A\<18\> A\<17\> A\<16\> A\<15\> A\<14\> A\<13\> A\<12\> A\<11\> A\<10\> A\<9\> A\<8\> A\<7\> A\<6\> A\<5\> A\<4\> A\<3\> A\<2\> A\<1\> A\<0\> B0P1 B1P1 GND VDD\<0\> VDD\<1\>) _sub24
    I11 (B1P1 B1P2 B1P3 B1P4 GND VDDM SM1) nand4_1x_PWR
    I10 (B0P1 B0P2 B0P3 B0P4 GND VDDM SM0) nand4_1x_PWR
    M1 (B0P1 B0 net066 GND) nfet w=60n l=20n nfin=1 nf=1 m=1
    M10 (B1P2 B1 net071 GND) nfet w=60n l=20n nfin=1 nf=1 m=1
    M7 (B0P2 B0 net068 GND) nfet w=60n l=20n nfin=1 nf=1 m=1
    M13 (B0P3 B0 net072 GND) nfet w=60n l=20n nfin=1 nf=1 m=1
    M16 (B1P3 B1 net073 GND) nfet w=60n l=20n nfin=1 nf=1 m=1
    M22 (B1P4 B1 net077 GND) nfet w=60n l=20n nfin=1 nf=1 m=1
    M19 (B0P4 B0 net078 GND) nfet w=60n l=20n nfin=1 nf=1 m=1
    M4 (B1P1 B1 net067 GND) nfet w=60n l=20n nfin=1 nf=1 m=1
    M0 (net066 net031 GND GND) nfet w=60n l=20n nfin=1 nf=1 m=1
    M3 (net067 net031 GND GND) nfet w=60n l=20n nfin=1 nf=1 m=1
    M9 (net071 net030 GND GND) nfet w=60n l=20n nfin=1 nf=1 m=1
    M6 (net068 net030 GND GND) nfet w=60n l=20n nfin=1 nf=1 m=1
    M12 (net072 net028 GND GND) nfet w=60n l=20n nfin=1 nf=1 m=1
    M15 (net073 net028 GND GND) nfet w=60n l=20n nfin=1 nf=1 m=1
    M21 (net077 net026 GND GND) nfet w=60n l=20n nfin=1 nf=1 m=1
    M18 (net078 net026 GND GND) nfet w=60n l=20n nfin=1 nf=1 m=1
    C7 (B1P4 GND) capacitor c=1.2822f m=1
    C3 (B1P2 GND) capacitor c=1.2822f m=1
    C5 (B1P3 GND) capacitor c=1.2822f m=1
    C6 (B0P4 GND) capacitor c=1.2822f m=1
    C4 (B0P3 GND) capacitor c=1.2822f m=1
    C2 (B0P2 GND) capacitor c=1.2822f m=1
    C1 (B1P1 GND) capacitor c=1.2822f m=1
    C0 (B0P1 GND) capacitor c=1.2822f m=1
    M5 (B1P1 net031 VDDM VDDM) pfet w=100n l=20n nfin=1 nf=1 m=1
    M2 (B0P1 net031 VDDM VDDM) pfet w=100n l=20n nfin=1 nf=1 m=1
    M11 (B1P2 net030 VDDM VDDM) pfet w=100n l=20n nfin=1 nf=1 m=1
    M8 (B0P2 net030 VDDM VDDM) pfet w=100n l=20n nfin=1 nf=1 m=1
    M17 (B1P3 net028 VDDM VDDM) pfet w=100n l=20n nfin=1 nf=1 m=1
    M14 (B0P3 net028 VDDM VDDM) pfet w=100n l=20n nfin=1 nf=1 m=1
    M20 (B0P4 net026 VDDM VDDM) pfet w=100n l=20n nfin=1 nf=1 m=1
    M23 (B1P4 net026 VDDM VDDM) pfet w=100n l=20n nfin=1 nf=1 m=1
ends _sub25

// 16nm/6T_CHUNK_PWR/schematic
subckt _sub26 \~R0\<3\> \~R0\<2\> \~R0\<1\> \~R0\<0\> \~R1\<3\> \~R1\<2\> \~R1\<1\> \~R1\<0\> A\<63\> A\<62\> A\<61\> A\<60\> A\<59\> A\<58\> A\<57\> A\<56\> A\<55\> A\<54\> A\<53\> A\<52\> A\<51\> A\<50\> A\<49\> A\<48\> A\<47\> A\<46\> A\<45\> A\<44\> A\<43\> A\<42\> A\<41\> A\<40\> A\<39\> A\<38\> A\<37\> A\<36\> A\<35\> A\<34\> A\<33\> A\<32\> A\<31\> A\<30\> A\<29\> A\<28\> A\<27\> A\<26\> A\<25\> A\<24\> A\<23\> A\<22\> A\<21\> A\<20\> A\<19\> A\<18\> A\<17\> A\<16\> A\<15\> A\<14\> A\<13\> A\<12\> A\<11\> A\<10\> A\<9\> A\<8\> A\<7\> A\<6\> A\<5\> A\<4\> A\<3\> A\<2\> A\<1\> A\<0\> B0\<3\> B0\<2\> B0\<1\> B0\<0\> B1\<3\> B1\<2\> B1\<1\> B1\<0\> S\<7\> S\<6\> S\<5\> S\<4\> S\<3\> S\<2\> S\<1\> S\<0\> W0\<3\> W0\<2\> W0\<1\> W0\<0\> W1\<3\> W1\<2\> W1\<1\> W1\<0\> Go GND VDDM VDD\<15\> VDD\<14\> VDD\<13\> VDD\<12\> VDD\<11\> VDD\<10\> VDD\<9\> VDD\<8\> VDD\<7\> VDD\<6\> VDD\<5\> VDD\<4\> VDD\<3\> VDD\<2\> VDD\<1\> VDD\<0\>
    I7 (\~R0\<3\> \~R1\<3\> Go SM0_0_bit3 SM0_1_bit3 SM1_0_bit3 SM1_1_bit3 GND) _sub20
    I6 (\~R0\<2\> \~R1\<2\> Go SM0_0_bit2 SM0_1_bit2 SM1_0_bit2 SM1_1_bit2 GND) _sub20
    I5 (\~R0\<1\> \~R1\<1\> Go SM0_0_bit1 SM0_1_bit1 SM1_0_bit1 SM1_1_bit1 GND) _sub20
    I4 (\~R0\<0\> \~R1\<0\> Go SM0_0_bit0 SM0_1_bit0 SM1_0_bit0 SM1_1_bit0 GND) _sub20
    I11 (A\<63\> A\<62\> A\<61\> A\<60\> A\<59\> A\<58\> A\<57\> A\<56\> A\<55\> A\<54\> A\<53\> A\<52\> A\<51\> A\<50\> A\<49\> A\<48\> A\<47\> A\<46\> A\<45\> A\<44\> A\<43\> A\<42\> A\<41\> A\<40\> A\<39\> A\<38\> A\<37\> A\<36\> A\<35\> A\<34\> A\<33\> A\<32\> B0\<3\> B1\<3\> GND S\<7\> S\<6\> S\<5\> S\<4\> SM0_1_bit3 SM1_1_bit3 VDD\<15\> VDD\<14\> VDD\<13\> VDD\<12\> VDD\<11\> VDD\<10\> VDD\<9\> VDD\<8\> VDDM W0\<3\> W1\<3\>) _sub25
    I10 (A\<63\> A\<62\> A\<61\> A\<60\> A\<59\> A\<58\> A\<57\> A\<56\> A\<55\> A\<54\> A\<53\> A\<52\> A\<51\> A\<50\> A\<49\> A\<48\> A\<47\> A\<46\> A\<45\> A\<44\> A\<43\> A\<42\> A\<41\> A\<40\> A\<39\> A\<38\> A\<37\> A\<36\> A\<35\> A\<34\> A\<33\> A\<32\> B0\<2\> B1\<2\> GND S\<7\> S\<6\> S\<5\> S\<4\> SM0_1_bit2 SM1_1_bit2 VDD\<15\> VDD\<14\> VDD\<13\> VDD\<12\> VDD\<11\> VDD\<10\> VDD\<9\> VDD\<8\> VDDM W0\<2\> W1\<2\>) _sub25
    I9 (A\<63\> A\<62\> A\<61\> A\<60\> A\<59\> A\<58\> A\<57\> A\<56\> A\<55\> A\<54\> A\<53\> A\<52\> A\<51\> A\<50\> A\<49\> A\<48\> A\<47\> A\<46\> A\<45\> A\<44\> A\<43\> A\<42\> A\<41\> A\<40\> A\<39\> A\<38\> A\<37\> A\<36\> A\<35\> A\<34\> A\<33\> A\<32\> B0\<1\> B1\<1\> GND S\<7\> S\<6\> S\<5\> S\<4\> SM0_1_bit1 SM1_1_bit1 VDD\<15\> VDD\<14\> VDD\<13\> VDD\<12\> VDD\<11\> VDD\<10\> VDD\<9\> VDD\<8\> VDDM W0\<1\> W1\<1\>) _sub25
    I8 (A\<63\> A\<62\> A\<61\> A\<60\> A\<59\> A\<58\> A\<57\> A\<56\> A\<55\> A\<54\> A\<53\> A\<52\> A\<51\> A\<50\> A\<49\> A\<48\> A\<47\> A\<46\> A\<45\> A\<44\> A\<43\> A\<42\> A\<41\> A\<40\> A\<39\> A\<38\> A\<37\> A\<36\> A\<35\> A\<34\> A\<33\> A\<32\> B0\<0\> B1\<0\> GND S\<7\> S\<6\> S\<5\> S\<4\> SM0_1_bit0 SM1_1_bit0 VDD\<15\> VDD\<14\> VDD\<13\> VDD\<12\> VDD\<11\> VDD\<10\> VDD\<9\> VDD\<8\> VDDM W0\<0\> W1\<0\>) _sub25
    I3 (A\<31\> A\<30\> A\<29\> A\<28\> A\<27\> A\<26\> A\<25\> A\<24\> A\<23\> A\<22\> A\<21\> A\<20\> A\<19\> A\<18\> A\<17\> A\<16\> A\<15\> A\<14\> A\<13\> A\<12\> A\<11\> A\<10\> A\<9\> A\<8\> A\<7\> A\<6\> A\<5\> A\<4\> A\<3\> A\<2\> A\<1\> A\<0\> B0\<3\> B1\<3\> GND S\<3\> S\<2\> S\<1\> S\<0\> SM0_0_bit3 SM1_0_bit3 VDD\<7\> VDD\<6\> VDD\<5\> VDD\<4\> VDD\<3\> VDD\<2\> VDD\<1\> VDD\<0\> VDDM W0\<3\> W1\<3\>) _sub25
    I2 (A\<31\> A\<30\> A\<29\> A\<28\> A\<27\> A\<26\> A\<25\> A\<24\> A\<23\> A\<22\> A\<21\> A\<20\> A\<19\> A\<18\> A\<17\> A\<16\> A\<15\> A\<14\> A\<13\> A\<12\> A\<11\> A\<10\> A\<9\> A\<8\> A\<7\> A\<6\> A\<5\> A\<4\> A\<3\> A\<2\> A\<1\> A\<0\> B0\<2\> B1\<2\> GND S\<3\> S\<2\> S\<1\> S\<0\> SM0_0_bit2 SM1_0_bit2 VDD\<7\> VDD\<6\> VDD\<5\> VDD\<4\> VDD\<3\> VDD\<2\> VDD\<1\> VDD\<0\> VDDM W0\<2\> W1\<2\>) _sub25
    I1 (A\<31\> A\<30\> A\<29\> A\<28\> A\<27\> A\<26\> A\<25\> A\<24\> A\<23\> A\<22\> A\<21\> A\<20\> A\<19\> A\<18\> A\<17\> A\<16\> A\<15\> A\<14\> A\<13\> A\<12\> A\<11\> A\<10\> A\<9\> A\<8\> A\<7\> A\<6\> A\<5\> A\<4\> A\<3\> A\<2\> A\<1\> A\<0\> B0\<1\> B1\<1\> GND S\<3\> S\<2\> S\<1\> S\<0\> SM0_0_bit1 SM1_0_bit1 VDD\<7\> VDD\<6\> VDD\<5\> VDD\<4\> VDD\<3\> VDD\<2\> VDD\<1\> VDD\<0\> VDDM W0\<1\> W1\<1\>) _sub25
    I0 (A\<31\> A\<30\> A\<29\> A\<28\> A\<27\> A\<26\> A\<25\> A\<24\> A\<23\> A\<22\> A\<21\> A\<20\> A\<19\> A\<18\> A\<17\> A\<16\> A\<15\> A\<14\> A\<13\> A\<12\> A\<11\> A\<10\> A\<9\> A\<8\> A\<7\> A\<6\> A\<5\> A\<4\> A\<3\> A\<2\> A\<1\> A\<0\> B0\<0\> B1\<0\> GND S\<3\> S\<2\> S\<1\> S\<0\> SM0_0_bit0 SM1_0_bit0 VDD\<7\> VDD\<6\> VDD\<5\> VDD\<4\> VDD\<3\> VDD\<2\> VDD\<1\> VDD\<0\> VDDM W0\<0\> W1\<0\>) _sub25
ends _sub26

// 16nm/inv_1x_PWR/schematic
subckt inv_1x_PWR A GND VDD Y
    M0 (Y A GND GND) nfet w=60n l=20n nfin=1 nf=1 m=1
    M1 (Y A VDD VDD) pfet w=100n l=20n nfin=1 nf=1 m=1
ends inv_1x_PWR

// 16nm/inv_4x_PWR/schematic
subckt inv_4x_PWR A GND VDD Y
    M0 (Y A GND GND) nfet w=240n l=20n nfin=4 nf=1 m=1
    M1 (Y A VDD VDD) pfet w=400n l=20n nfin=4 nf=1 m=1
ends inv_4x_PWR

// 16nm_Tests/Dual_Supply_Test/schematic
I0 (\~R0_1\<3\> \~R0_1\<2\> \~R0_1\<1\> \~R0_1\<0\> \~R1_1\<3\> \~R1_1\<2\> \~R1_1\<1\> \~R1_1\<0\> 0 0 0 0 0 0 0 0 0 0 0 0 0 0 0 0 0 0 0 0 0 0 0 0 0 0 0 0 0 0 0 0 0 0 0 0 0 0 0 0 0 0 0 0 0 0 0 0 0 0 0 0 0 0 0 0 0 0 0 0 0 0 0 0 0 0 0 0 0 0 0 0 0 0 0 0 0 0 0 0 0 0 0 0 0 0 0 0 0 0 vcc! VDD\<15\> VDD\<14\> VDD\<13\> VDD\<12\> VDD\<11\> VDD\<10\> VDD\<9\> VDD\<8\> VDD\<7\> VDD\<6\> VDD\<5\> VDD\<4\> VDD\<3\> VDD\<2\> VDD\<1\> VDD\<0\>) _sub26
V0 (vcc! 0) vsource type=dc dc=VDDL
V1 (vdd! 0) vsource type=dc dc=VDDH
V5 (sH 0) vsource type=pwl wave=[ 0 VDDH timeA VDDH timeB 0 timeC 0 timeD VDDH timeE VDDH timeF 0 ]
V2 (sL 0) vsource type=pwl wave=[ 0 0 timeA 0 timeB VDDL timeC VDDL timeD 0 timeE 0 timeF VDDL ]
M4 (Vline VH vdd! vdd!) pfet w=800n l=20n nfin=32 nf=1 m=1
M3 (Vline VL vcc! vcc!) pfet w=800n l=20n nfin=32 nf=1 m=1
M0\<3\> (\~R1_1\<3\> net016\<0\> vcc! vcc!) pfet w=100n l=20n nfin=1 nf=1 m=1
M0\<2\> (\~R1_1\<2\> net016\<1\> vcc! vcc!) pfet w=100n l=20n nfin=1 nf=1 m=1
M0\<1\> (\~R1_1\<1\> net016\<2\> vcc! vcc!) pfet w=100n l=20n nfin=1 nf=1 m=1
M0\<0\> (\~R1_1\<0\> net016\<3\> vcc! vcc!) pfet w=100n l=20n nfin=1 nf=1 m=1
M1\<3\> (\~R0_1\<3\> net016\<0\> vcc! vcc!) pfet w=100n l=20n nfin=1 nf=1 m=1
M1\<2\> (\~R0_1\<2\> net016\<1\> vcc! vcc!) pfet w=100n l=20n nfin=1 nf=1 m=1
M1\<1\> (\~R0_1\<1\> net016\<2\> vcc! vcc!) pfet w=100n l=20n nfin=1 nf=1 m=1
M1\<0\> (\~R0_1\<0\> net016\<3\> vcc! vcc!) pfet w=100n l=20n nfin=1 nf=1 m=1
I6 (net038 0 vcc! VL) inv_1x_PWR
I5 (sL 0 vcc! net038) inv_1x_PWR
I24 (sH 0 vdd! net035) inv_1x_PWR
I19\<7\> (Vline VDD\<7\>) iprobe
I19\<6\> (Vline VDD\<6\>) iprobe
I19\<5\> (Vline VDD\<5\>) iprobe
I19\<4\> (Vline VDD\<4\>) iprobe
I19\<3\> (Vline VDD\<3\>) iprobe
I19\<2\> (Vline VDD\<2\>) iprobe
I19\<1\> (Vline VDD\<1\>) iprobe
I19\<0\> (Vline VDD\<0\>) iprobe
I14\<7\> (vcc! VDD\<15\>) iprobe
I14\<6\> (vcc! VDD\<14\>) iprobe
I14\<5\> (vcc! VDD\<13\>) iprobe
I14\<4\> (vcc! VDD\<12\>) iprobe
I14\<3\> (vcc! VDD\<11\>) iprobe
I14\<2\> (vcc! VDD\<10\>) iprobe
I14\<1\> (vcc! VDD\<9\>) iprobe
I14\<0\> (vcc! VDD\<8\>) iprobe
C0 (Vline 0) capacitor c=C m=1
I25 (net035 0 vdd! VH) inv_4x_PWR
ic Vline=VDDL VH=VDDH sH=VDDH VL=0 sL=0
simulatorOptions options temp=27
tran tran stop=25n errpreset=conservative
save Vline VL VH V0:p V1:p sH sL
