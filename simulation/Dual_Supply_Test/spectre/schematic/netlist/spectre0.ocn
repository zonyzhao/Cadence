simulator( 'spectre )
design(	 "/net/kafka/nfs/rstdenis/Cadence/simulation/Dual_Supply_Test/spectre/schematic/netlist/netlist")
resultsDir( "/net/kafka/nfs/rstdenis/Cadence/simulation/Dual_Supply_Test/spectre/schematic" )
modelFile(
    '("/root/Desktop/Cadence/ncsu-FreePDK15/hspice_16nm_hp.include" "")
)
analysis('tran ?stop "25n"  ?errpreset "conservative"  )
desVar(	  "timeA" 1n	)
desVar(	  "timeB" 1.25n	)
desVar(	  "VDDL" .400	)
desVar(	  "VDDH" .600	)
desVar(	  "timeD" 8.25n	)
desVar(	  "timeC" 8n	)
desVar(	  "timeF" 15.25n	)
desVar(	  "timeE" 15n	)
desVar(	  "C" 0.4p	)
envOption(
	'analysisOrder  list("tran")
)
option(	'multithread  "on"
)
save( 'v "/Vline" "/VL" "/VH" "/sH" "/sL" )
save( 'i "/V0/MINUS" "/V1/MINUS" "/M3/S" "/M3/G" "/M3/B" "/M3/D" )
converge( 'ic "/sL" "0" )
converge( 'ic "/VL" "0" )
converge( 'ic "/sH" "VDDH" )
converge( 'ic "/VH" "VDDH" )
converge( 'ic "/Vline" "VDDL" )
temp( 27 )
run()
selectResult( 'tran )
plot(getData("/Vline") getData("/VL") getData("/VH") getData("/V0/MINUS") getData("/V1/MINUS") getData("/sH") getData("/sL") getData("/M3/S") getData("/M3/G") getData("/M3/B") getData("/M3/D") )
modelFile(
    '("/root/Desktop/Cadence/ncsu-FreePDK15/hspice_16nm_hp.include" "")
)
save( 'i "/I19/src" "/I14<0>/src" )
save( 'i /M3/S /M3/G /M3/B /M3/D )
run()
selectResult( 'tran )
plot(getData("/Vline") getData("/VL") getData("/VH") getData("/V0/MINUS") getData("/V1/MINUS") getData("/sH") getData("/sL") getData("/I19/src") getData("/I14<0>/src") )
modelFile(
    '("/root/Desktop/Cadence/ncsu-FreePDK15/hspice_16nm_hp.include" "")
)
save( 'i "/I27/src" )
run()
selectResult( 'tran )
plot(getData("/Vline") getData("/VL") getData("/VH") getData("/V0/MINUS") getData("/V1/MINUS") getData("/sH") getData("/sL") getData("/I19/src") getData("/I27/src") )
modelFile(
    '("/root/Desktop/Cadence/ncsu-FreePDK15/hspice_16nm_hp.include" "")
)
save( 'i "/I12/src" "/I16/src" )
delete( 'save 'v /sH /sL )
save( 'i /V0/MINUS /V1/MINUS /I19/src /I14<0>/src /I27/src )
run()
selectResult( 'tran )
plot(getData("/Vline") getData("/VL") getData("/VH") getData("/I12/src") getData("/I16/src") )
Trise = riseTime(v("/Vline" ?result "tran") 0.4 nil 0.6 nil 5 95 t "time")
plot( Trise ?expr '( "Trise" ) )
modelFile(
    '("/root/Desktop/Cadence/ncsu-FreePDK15/hspice_16nm_hp.include" "")
)
run()
selectResult( 'tran )
plot(getData("/Vline") getData("/VL") getData("/VH") getData("/I12/src") getData("/I16/src") )
Trise = riseTime(v("/Vline" ?result "tran") 0.4 nil 0.6 nil 5 95 t "time")
plot( Trise ?expr '( "Trise" ) )
Tfall = riseTime(v("/Vline" ?result "tran") 0.6 nil 0.4 nil 95 5 t "time")
plot( Tfall ?expr '( "Tfall" ) )
modelFile(
    '("/root/Desktop/Cadence/ncsu-FreePDK15/hspice_16nm_hp.include" "")
)
run()
selectResult( 'tran )
plot(getData("/Vline") getData("/VL") getData("/VH") getData("/I12/src") getData("/I16/src") )
Trise = riseTime(v("/Vline" ?result "tran") 0.4 nil 0.6 nil 5 95 t "time")
plot( Trise ?expr '( "Trise" ) )
Tfall = riseTime(v("/Vline" ?result "tran") 0.6 nil 0.4 nil 5 95 t "time")
plot( Tfall ?expr '( "Tfall" ) )
modelFile(
    '("/root/Desktop/Cadence/ncsu-FreePDK15/hspice_16nm_hp.include" "")
)
save( 'i "/IVDDL/dst" "/IVDDH/dst" "/IVDDL/src" "/IVDDH/src" )
save( 'i /I12/src /I16/src )
run()
selectResult( 'tran )
plot(getData("/Vline") getData("/VL") getData("/VH") getData("/IVDDL/dst") getData("/IVDDH/dst") getData("/IVDDL/src") getData("/IVDDH/src") )
Trise = riseTime(v("/Vline" ?result "tran") 0.4 nil 0.6 nil 5 95 t "time")
plot( Trise ?expr '( "Trise" ) )
Tfall = riseTime(v("/Vline" ?result "tran") 0.6 nil 0.4 nil 5 95 t "time")
plot( Tfall ?expr '( "Tfall" ) )
modelFile(
    '("/root/Desktop/Cadence/ncsu-FreePDK15/hspice_16nm_hp.include" "")
)
run()
selectResult( 'tran )
plot(getData("/Vline") getData("/VL") getData("/VH") getData("/IVDDL/dst") getData("/IVDDH/dst") getData("/IVDDL/src") getData("/IVDDH/src") )
Trise = riseTime(v("/Vline" ?result "tran") 0.4 nil 0.6 nil 2 98 t "time")
plot( Trise ?expr '( "Trise" ) )
Tfall = riseTime(v("/Vline" ?result "tran") 0.6 nil 0.4 nil 2 98 t "time")
plot( Tfall ?expr '( "Tfall" ) )
modelFile(
    '("/root/Desktop/Cadence/ncsu-FreePDK15/hspice_16nm_hp.include" "")
)
run()
selectResult( 'tran )
plot(getData("/Vline") getData("/VL") getData("/VH") getData("/IVDDL/dst") getData("/IVDDH/dst") getData("/IVDDL/src") getData("/IVDDH/src") )
Trise = riseTime(v("/Vline" ?result "tran") 0.4 nil 0.6 nil 2 98 nil "time")
plot( Trise ?expr '( "Trise" ) )
Tfall = riseTime(v("/Vline" ?result "tran") 0.6 nil 0.4 nil 2 98 nil "time")
plot( Tfall ?expr '( "Tfall" ) )
modelFile(
    '("/root/Desktop/Cadence/ncsu-FreePDK15/hspice_16nm_hp.include" "")
)
run()
selectResult( 'tran )
plot(getData("/Vline") getData("/VL") getData("/VH") getData("/IVDDL/dst") getData("/IVDDH/dst") getData("/IVDDL/src") getData("/IVDDH/src") )
Trise = riseTime(v("/Vline" ?result "tran") 0.4 nil 0.6 nil 2 98 nil "time")
plot( Trise ?expr '( "Trise" ) )
Tfall = riseTime(v("/Vline" ?result "tran") 0.6 nil 0.4 nil 2 98 nil "time")
plot( Tfall ?expr '( "Tfall" ) )
modelFile(
    '("/root/Desktop/Cadence/ncsu-FreePDK15/hspice_16nm_hp.include" "")
)
run()
selectResult( 'tran )
plot(getData("/Vline") getData("/VL") getData("/VH") getData("/IVDDL/dst") getData("/IVDDH/dst") getData("/IVDDL/src") getData("/IVDDH/src") )
Trise = riseTime(v("/Vline" ?result "tran") 0.4 nil 0.6 nil 2 98 nil "time")
plot( Trise ?expr '( "Trise" ) )
Tfall = riseTime(v("/Vline" ?result "tran") 0.6 nil 0.4 nil 2 98 nil "time")
plot( Tfall ?expr '( "Tfall" ) )
modelFile(
    '("/root/Desktop/Cadence/ncsu-FreePDK15/hspice_16nm_hp.include" "")
)
run()
selectResult( 'tran )
plot(getData("/Vline") getData("/VL") getData("/VH") getData("/IVDDL/dst") getData("/IVDDH/dst") getData("/IVDDL/src") getData("/IVDDH/src") )
Trise = riseTime(v("/Vline" ?result "tran") 0.4 nil 0.6 nil 2 98 nil "time")
plot( Trise ?expr '( "Trise" ) )
Tfall = riseTime(v("/Vline" ?result "tran") 0.6 nil 0.4 nil 2 98 nil "time")
plot( Tfall ?expr '( "Tfall" ) )
modelFile(
    '("/root/Desktop/Cadence/ncsu-FreePDK15/hspice_16nm_hp.include" "")
)
desVar(	  "nfin" 32	)
save( 'i /IVDDL/dst /IVDDH/dst )
run()
selectResult( 'tran )
plot(getData("/Vline") getData("/VL") getData("/VH") getData("/IVDDL/src") getData("/IVDDH/src") )
Trise = riseTime(v("/Vline" ?result "tran") 0.4 nil 0.6 nil 2 98 nil "time")
plot( Trise ?expr '( "Trise" ) )
Tfall = riseTime(v("/Vline" ?result "tran") 0.6 nil 0.4 nil 2 98 nil "time")
plot( Tfall ?expr '( "Tfall" ) )
modelFile(
    '("/root/Desktop/Cadence/ncsu-FreePDK15/hspice_16nm_hp.include" "")
)
desVar(	  "nfin" 64	)
run()
selectResult( 'tran )
plot(getData("/Vline") getData("/VL") getData("/VH") getData("/IVDDL/src") getData("/IVDDH/src") )
Trise = riseTime(v("/Vline" ?result "tran") 0.4 nil 0.6 nil 2 98 nil "time")
plot( Trise ?expr '( "Trise" ) )
Tfall = riseTime(v("/Vline" ?result "tran") 0.6 nil 0.4 nil 2 98 nil "time")
plot( Tfall ?expr '( "Tfall" ) )
modelFile(
    '("/root/Desktop/Cadence/ncsu-FreePDK15/hspice_16nm_hp.include" "")
)
run()
selectResult( 'tran )
plot(getData("/Vline") getData("/VL") getData("/VH") getData("/IVDDH/src") getData("/IVDDL/src") )
Trise = (cross(v("/Vline" ?result "tran") (0.98 * VAR("VDDH")) 2 "rising") - cross(v("/VH" ?result "tran") VAR("VDDL") 2 "falling"))
plot( Trise ?expr '( "Trise" ) )
Tfall = (cross(v("/Vline" ?result "tran") VAR("VDDL") 1 "falling") - cross(v("/VH" ?result "tran") VAR("VDDL") 1 "rising"))
plot( Tfall ?expr '( "Tfall" ) )
modelFile(
    '("/root/Desktop/Cadence/ncsu-FreePDK15/hspice_16nm_hp.include" "")
)
analysis('tran ?stop "15n"  )
desVar(	  "timeD" 5.25n	)
desVar(	  "timeC" 5n	)
desVar(	  "timeF" 10.25n	)
desVar(	  "timeE" 10n	)
run()
selectResult( 'tran )
plot(getData("/Vline") getData("/VL") getData("/VH") getData("/IVDDH/src") getData("/IVDDL/src") )
Trise = (cross(v("/Vline" ?result "tran") (0.98 * VAR("VDDH")) 2 "rising") - cross(v("/VH" ?result "tran") VAR("VDDL") 2 "falling"))
plot( Trise ?expr '( "Trise" ) )
Tfall = (cross(v("/Vline" ?result "tran") VAR("VDDL") 1 "falling") - xval(intersect(clip(v("/VH" ?result "tran") 7e-09 9e-09) clip(v("/VL" ?result "tran") 7e-09 9e-09))))
plot( Tfall ?expr '( "Tfall" ) )
modelFile(
    '("/root/Desktop/Cadence/ncsu-FreePDK15/hspice_16nm_hp.include" "")
)
run()
selectResult( 'tran )
plot(getData("/Vline") getData("/VL") getData("/VH") getData("/IVDDH/src") getData("/IVDDL/src") )
Trise = (cross(v("/Vline" ?result "tran") (0.98 * VAR("VDDH")) 2 "rising") - cross(v("/VH" ?result "tran") VAR("VDDL") 2 "falling"))
plot( Trise ?expr '( "Trise" ) )
Tfall = (cross(v("/Vline" ?result "tran") VAR("VDDL") 1 "falling") - xval(intersect(clip(v("/VH" ?result "tran") 7e-09 9e-09) clip(v("/VL" ?result "tran") 7e-09 9e-09))))
plot( Tfall ?expr '( "Tfall" ) )
modelFile(
    '("/root/Desktop/Cadence/ncsu-FreePDK15/hspice_16nm_hp.include" "")
)
run()
selectResult( 'tran )
plot(getData("/Vline") getData("/VL") getData("/VH") getData("/IVDDH/src") getData("/IVDDL/src") )
Trise = (cross(v("/Vline" ?result "tran") (0.98 * VAR("VDDH")) 2 "rising") - cross(v("/VH" ?result "tran") VAR("VDDL") 2 "falling"))
plot( Trise ?expr '( "Trise" ) )
Tfall = (cross(v("/Vline" ?result "tran") VAR("VDDL") 1 "falling") - cross(v("/VH" ?result "tran") VAR("VDDL") 1 "rising"))
plot( Tfall ?expr '( "Tfall" ) )
modelFile(
    '("/root/Desktop/Cadence/ncsu-FreePDK15/hspice_16nm_hp.include" "")
)
run()
selectResult( 'tran )
plot(getData("/Vline") getData("/VL") getData("/VH") getData("/IVDDH/src") getData("/IVDDL/src") )
Trise = (cross(v("/Vline" ?result "tran") (0.98 * VAR("VDDH")) 2 "rising") - cross(v("/VH" ?result "tran") VAR("VDDL") 2 "falling"))
plot( Trise ?expr '( "Trise" ) )
Tfall = (cross(v("/Vline" ?result "tran") VAR("VDDL") 1 "falling") - cross(v("/VH" ?result "tran") (0.98 * VAR("VDDH")) 1 "rising"))
plot( Tfall ?expr '( "Tfall" ) )
modelFile(
    '("/root/Desktop/Cadence/ncsu-FreePDK15/hspice_16nm_hp.include" "")
)
run()
selectResult( 'tran )
plot(getData("/Vline") getData("/VL") getData("/VH") getData("/IVDDH/src") getData("/IVDDL/src") )
Trise = (cross(v("/Vline" ?result "tran") (0.99 * VAR("VDDH")) 2 "rising") - cross(v("/VH" ?result "tran") VAR("VDDL") 2 "falling"))
plot( Trise ?expr '( "Trise" ) )
Tfall = (cross(v("/Vline" ?result "tran") VAR("VDDL") 1 "falling") - cross(v("/VH" ?result "tran") (0.98 * VAR("VDDH")) 1 "rising"))
plot( Tfall ?expr '( "Tfall" ) )
modelFile(
    '("/root/Desktop/Cadence/ncsu-FreePDK15/hspice_16nm_hp.include" "")
)
desVar(	  "nfin" 60	)
save( 'i "/I17/src" )
run()
selectResult( 'tran )
plot(getData("/Vline") getData("/VL") getData("/VH") getData("/IVDDH/src") getData("/IVDDL/src") getData("/I17/src") )
Trise = (cross(v("/Vline" ?result "tran") (0.99 * VAR("VDDH")) 2 "rising") - cross(v("/VH" ?result "tran") VAR("VDDL") 2 "falling"))
plot( Trise ?expr '( "Trise" ) )
Tfall = (cross(v("/Vline" ?result "tran") VAR("VDDL") 1 "falling") - cross(v("/VH" ?result "tran") (0.98 * VAR("VDDH")) 1 "rising"))
plot( Tfall ?expr '( "Tfall" ) )
modelFile(
    '("/root/Desktop/Cadence/ncsu-FreePDK15/hspice_16nm_hp.include" "")
)
run()
selectResult( 'tran )
plot(getData("/Vline") getData("/VL") getData("/VH") getData("/IVDDH/src") getData("/IVDDL/src") getData("/I17/src") )
Trise = (cross(v("/Vline" ?result "tran") (0.99 * VAR("VDDH")) 2 "rising") - cross(v("/VH" ?result "tran") VAR("VDDL") 2 "falling"))
plot( Trise ?expr '( "Trise" ) )
Tfall = (cross(v("/Vline" ?result "tran") VAR("VDDL") 1 "falling") - cross(v("/VH" ?result "tran") (0.98 * VAR("VDDH")) 1 "rising"))
plot( Tfall ?expr '( "Tfall" ) )
modelFile(
    '("/root/Desktop/Cadence/ncsu-FreePDK15/hspice_16nm_hp.include" "")
)
run()
selectResult( 'tran )
plot(getData("/Vline") getData("/VL") getData("/VH") getData("/IVDDH/src") getData("/IVDDL/src") getData("/I17/src") )
Trise = (cross(v("/Vline" ?result "tran") (0.99 * VAR("VDDH")) 2 "rising") - cross(v("/VH" ?result "tran") VAR("VDDL") 2 "falling"))
plot( Trise ?expr '( "Trise" ) )
Tfall = (cross(v("/Vline" ?result "tran") VAR("VDDL") 1 "falling") - cross(v("/VH" ?result "tran") (0.98 * VAR("VDDH")) 1 "rising"))
plot( Tfall ?expr '( "Tfall" ) )
modelFile(
    '("/root/Desktop/Cadence/ncsu-FreePDK15/hspice_16nm_hp.include" "")
)
run()
selectResult( 'tran )
plot(getData("/Vline") getData("/VL") getData("/VH") getData("/IVDDH/src") getData("/IVDDL/src") getData("/I17/src") )
Trise = (cross(v("/Vline" ?result "tran") (0.99 * VAR("VDDH")) 2 "rising") - cross(v("/VH" ?result "tran") VAR("VDDL") 2 "falling"))
plot( Trise ?expr '( "Trise" ) )
Tfall = (cross(v("/Vline" ?result "tran") VAR("VDDL") 1 "falling") - cross(v("/VH" ?result "tran") (0.98 * VAR("VDDH")) 1 "rising"))
plot( Tfall ?expr '( "Tfall" ) )
modelFile(
    '("/root/Desktop/Cadence/ncsu-FreePDK15/hspice_16nm_hp.include" "")
)
run()
selectResult( 'tran )
plot(getData("/Vline") getData("/VL") getData("/VH") getData("/IVDDH/src") getData("/IVDDL/src") getData("/I17/src") )
Trise = (cross(v("/Vline" ?result "tran") (0.99 * VAR("VDDH")) 2 "rising") - cross(v("/VH" ?result "tran") VAR("VDDL") 2 "falling"))
plot( Trise ?expr '( "Trise" ) )
Tfall = (cross(v("/Vline" ?result "tran") VAR("VDDL") 1 "falling") - cross(v("/VH" ?result "tran") (0.99 * VAR("VDDH")) 1 "rising"))
plot( Tfall ?expr '( "Tfall" ) )
modelFile(
    '("/root/Desktop/Cadence/ncsu-FreePDK15/hspice_16nm_hp.include" "")
)
desVar(	  "nfin" 64	)
run()
selectResult( 'tran )
plot(getData("/Vline") getData("/VL") getData("/VH") getData("/IVDDH/src") getData("/IVDDL/src") getData("/I17/src") )
Trise = (cross(v("/Vline" ?result "tran") (0.99 * VAR("VDDH")) 2 "rising") - cross(v("/VH" ?result "tran") VAR("VDDL") 2 "falling"))
plot( Trise ?expr '( "Trise" ) )
Tfall = (cross(v("/Vline" ?result "tran") VAR("VDDL") 1 "falling") - cross(v("/VH" ?result "tran") (0.99 * VAR("VDDH")) 1 "rising"))
plot( Tfall ?expr '( "Tfall" ) )
modelFile(
    '("/root/Desktop/Cadence/ncsu-FreePDK15/hspice_16nm_hp.include" "")
)
desVar(	  "VDDL" .450	)
run()
selectResult( 'tran )
plot(getData("/Vline") getData("/VL") getData("/VH") getData("/IVDDH/src") getData("/IVDDL/src") getData("/I17/src") )
Trise = (cross(v("/Vline" ?result "tran") (0.99 * VAR("VDDH")) 2 "rising") - cross(v("/VH" ?result "tran") VAR("VDDL") 2 "falling"))
plot( Trise ?expr '( "Trise" ) )
Tfall = (cross(v("/Vline" ?result "tran") VAR("VDDL") 1 "falling") - cross(v("/VH" ?result "tran") (0.99 * VAR("VDDH")) 1 "rising"))
plot( Tfall ?expr '( "Tfall" ) )
modelFile(
    '("/root/Desktop/Cadence/ncsu-FreePDK15/hspice_16nm_hp.include" "")
)
run()
selectResult( 'tran )
plot(getData("/Vline") getData("/VL") getData("/VH") getData("/IVDDH/src") getData("/IVDDL/src") getData("/I17/src") )
Trise = (cross(v("/Vline" ?result "tran") (0.99 * VAR("VDDH")) 2 "rising") - cross(v("/VH" ?result "tran") VAR("VDDL") 2 "falling"))
plot( Trise ?expr '( "Trise" ) )
Tfall = (cross(v("/Vline" ?result "tran") VAR("VDDL") 1 "falling") - cross(v("/VH" ?result "tran") (0.99 * VAR("VDDH")) 1 "rising"))
plot( Tfall ?expr '( "Tfall" ) )
modelFile(
    '("/root/Desktop/Cadence/ncsu-FreePDK15/hspice_16nm_hp.include" "")
)
run()
selectResult( 'tran )
plot(getData("/Vline") getData("/VL") getData("/VH") getData("/IVDDH/src") getData("/IVDDL/src") getData("/I17/src") getData("/sH") )
Trise = (cross(v("/Vline" ?result "tran") (0.99 * VAR("VDDH")) 2 "rising") - cross(v("/VH" ?result "tran") VAR("VDDL") 2 "falling"))
plot( Trise ?expr '( "Trise" ) )
Tfall = (cross(v("/Vline" ?result "tran") (1.01 * VAR("VDDL")) 1 "falling") - cross(v("/VH" ?result "tran") (0.99 * VAR("VDDH")) 1 "rising"))
plot( Tfall ?expr '( "Tfall" ) )
modelFile(
    '("/root/Desktop/Cadence/ncsu-FreePDK15/hspice_16nm_hp.include" "")
)
run()
selectResult( 'tran )
plot(getData("/Vline") getData("/VL") getData("/VH") getData("/IVDDH/src") getData("/IVDDL/src") getData("/I17/src") getData("/sH") )
Trise = (cross(v("/Vline" ?result "tran") (0.99 * VAR("VDDH")) 2 "rising") - cross(v("/VH" ?result "tran") VAR("VDDL") 2 "falling"))
plot( Trise ?expr '( "Trise" ) )
Tfall = (cross(v("/Vline" ?result "tran") (1.01 * VAR("VDDL")) 1 "falling") - cross(v("/VH" ?result "tran") (0.99 * VAR("VDDH")) 1 "rising"))
plot( Tfall ?expr '( "Tfall" ) )
modelFile(
    '("/root/Desktop/Cadence/ncsu-FreePDK15/hspice_16nm_hp.include" "")
)
analysis('tran ?stop "8n"  )
desVar(	  "timeD" 2.75n	)
desVar(	  "timeC" 2.5n	)
desVar(	  "timeF" 4.25n	)
desVar(	  "timeE" 4	)
run()
selectResult( 'tran )
plot(getData("/Vline") getData("/VL") getData("/VH") getData("/IVDDH/src") getData("/IVDDL/src") getData("/I17/src") getData("/sH") )
Trise = (cross(v("/Vline" ?result "tran") (0.99 * VAR("VDDH")) 2 "rising") - cross(v("/VH") (0.5 * VAR("VDDH")) 2 "falling"))
plot( Trise ?expr '( "Trise" ) )
Tfall = (cross(v("/Vline" ?result "tran") (1.01 * VAR("VDDL")) 1 "falling") - cross(v("/VH" ?result "tran") (0.5 * VAR("VDDH")) 1 "rising"))
plot( Tfall ?expr '( "Tfall" ) )
modelFile(
    '("/root/Desktop/Cadence/ncsu-FreePDK15/hspice_16nm_hp.include" "")
)
analysis('tran ?stop "15n"  )
desVar(	  "timeF" 7.25n	)
desVar(	  "timeE" 7	)
desVar(	  "timeD" 3.25n	)
desVar(	  "timeC" 3n	)
delete( 'converge 'ic "/sL" )
run()
selectResult( 'tran )
plot(getData("/Vline") getData("/VL") getData("/VH") getData("/IVDDH/src") getData("/IVDDL/src") getData("/I17/src") )
Trise = (cross(v("/Vline" ?result "tran") (0.99 * VAR("VDDH")) 2 "rising") - cross(v("/VH" ?result "tran") VAR("VDDL") 2 "falling"))
plot( Trise ?expr '( "Trise" ) )
Tfall = (cross(v("/Vline" ?result "tran") VAR("VDDL") 1 "falling") - cross(v("/VH" ?result "tran") (0.99 * VAR("VDDH")) 1 "rising"))
plot( Tfall ?expr '( "Tfall" ) )
modelFile(
    '("/root/Desktop/Cadence/ncsu-FreePDK15/hspice_16nm_hp.include" "")
)
analysis('tran ?stop "12n"  )
desVar(	  "timeE" 7n	)
run()
selectResult( 'tran )
plot(getData("/Vline") getData("/VL") getData("/VH") getData("/IVDDH/src") getData("/IVDDL/src") getData("/I17/src") )
Trise = (cross(v("/Vline" ?result "tran") (0.99 * VAR("VDDH")) 2 "rising") - cross(v("/VH" ?result "tran") VAR("VDDL") 2 "falling"))
plot( Trise ?expr '( "Trise" ) )
Tfall = (cross(v("/Vline" ?result "tran") VAR("VDDL") 1 "falling") - cross(v("/VH" ?result "tran") (0.99 * VAR("VDDH")) 1 "rising"))
plot( Tfall ?expr '( "Tfall" ) )
modelFile(
    '("/root/Desktop/Cadence/ncsu-FreePDK15/hspice_16nm_hp.include" "")
)
analysis('tran ?stop "8n"  )
desVar(	  "timeF" 5.75n	)
desVar(	  "timeE" 5.5n	)
run()
selectResult( 'tran )
plot(getData("/Vline") getData("/VL") getData("/VH") getData("/IVDDH/src") getData("/IVDDL/src") getData("/I17/src") )
Trise = (cross(v("/Vline" ?result "tran") (0.99 * VAR("VDDH")) 2 "rising") - cross(v("/VH" ?result "tran") VAR("VDDL") 2 "falling"))
plot( Trise ?expr '( "Trise" ) )
Tfall = (cross(v("/Vline" ?result "tran") VAR("VDDL") 1 "falling") - cross(v("/VH" ?result "tran") (0.99 * VAR("VDDH")) 1 "rising"))
plot( Tfall ?expr '( "Tfall" ) )
modelFile(
    '("/root/Desktop/Cadence/ncsu-FreePDK15/hspice_16nm_hp.include" "")
)
desVar(	  "timeF" 5.52n	)
desVar(	  "timeD" 3.02n	)
desVar(	  "timeB" 1.02n	)
run()
selectResult( 'tran )
plot(getData("/Vline") getData("/VL") getData("/VH") getData("/IVDDH/src") getData("/IVDDL/src") getData("/I17/src") )
Trise = (cross(v("/Vline" ?result "tran") (0.99 * VAR("VDDH")) 2 "rising") - cross(v("/VH" ?result "tran") VAR("VDDL") 2 "falling"))
plot( Trise ?expr '( "Trise" ) )
Tfall = (cross(v("/Vline" ?result "tran") VAR("VDDL") 1 "falling") - cross(v("/VH" ?result "tran") (0.99 * VAR("VDDH")) 1 "rising"))
plot( Tfall ?expr '( "Tfall" ) )
modelFile(
    '("/root/Desktop/Cadence/ncsu-FreePDK15/hspice_16nm_hp.include" "")
)
envOption(
	'cmd64bit  t
)
run()
selectResult( 'tran )
plot(getData("/Vline") getData("/VL") getData("/VH") getData("/IVDDH/src") getData("/IVDDL/src") getData("/I17/src") )
Trise = (cross(v("/Vline" ?result "tran") (0.99 * VAR("VDDH")) 2 "rising") - cross(v("/VH" ?result "tran") (0.5 * VAR("VDDH")) 2 "falling"))
plot( Trise ?expr '( "Trise" ) )
Tfall = (cross(v("/Vline" ?result "tran") (1.01 * VAR("VDDL")) 1 "falling") - cross(v("/VH" ?result "tran") (0.5 * VAR("VDDL")) 1 "rising"))
plot( Tfall ?expr '( "Tfall" ) )
modelFile(
    '("/root/Desktop/Cadence/ncsu-FreePDK15/hspice_16nm_hp.include" "")
)
run()
selectResult( 'tran )
plot(getData("/Vline") getData("/VL") getData("/VH") getData("/IVDDH/src") getData("/IVDDL/src") getData("/I17/src") )
Trise = (cross(v("/Vline" ?result "tran") (0.99 * VAR("VDDH")) 2 "rising") - cross(v("/VH" ?result "tran") (0.5 * VAR("VDDH")) 2 "falling"))
plot( Trise ?expr '( "Trise" ) )
Tfall = (cross(v("/Vline" ?result "tran") (1.01 * VAR("VDDL")) 1 "falling") - cross(v("/VH" ?result "tran") (0.5 * VAR("VDDH")) 1 "rising"))
plot( Tfall ?expr '( "Tfall" ) )
modelFile(
    '("/root/Desktop/Cadence/ncsu-FreePDK15/hspice_16nm_hp.include" "")
)
analysis('tran ?stop "22n"  )
desVar(	  "timeF" 15.02n	)
desVar(	  "timeE" 15n	)
desVar(	  "timeD" 8.02n	)
desVar(	  "timeC" 8n	)
run()
selectResult( 'tran )
plot(getData("/Vline") getData("/VL") getData("/VH") getData("/IVDDH/src") getData("/IVDDL/src") getData("/I17/src") )
Trise = (cross(v("/Vline" ?result "tran") (0.99 * VAR("VDDH")) 2 "rising") - cross(v("/VH" ?result "tran") (0.5 * VAR("VDDH")) 2 "falling"))
plot( Trise ?expr '( "Trise" ) )
Tfall = (cross(v("/Vline" ?result "tran") (1.01 * VAR("VDDL")) 1 "falling") - cross(v("/VH" ?result "tran") (0.5 * VAR("VDDH")) 1 "rising"))
plot( Tfall ?expr '( "Tfall" ) )
modelFile(
    '("/root/Desktop/Cadence/ncsu-FreePDK15/hspice_16nm_hp.include" "")
)
save( 'i "/IVDDL/dst" "/ILine/src" )
save( 'i /IVDDL/src /I17/src )
run()
selectResult( 'tran )
plot(getData("/Vline") getData("/VL") getData("/VH") getData("/IVDDH/src") getData("/IVDDL/dst") getData("/ILine/src") )
Trise = (cross(v("/Vline" ?result "tran") (0.99 * VAR("VDDH")) 2 "rising") - cross(v("/VH" ?result "tran") (0.5 * VAR("VDDH")) 2 "falling"))
plot( Trise ?expr '( "Trise" ) )
Tfall = (cross(v("/Vline" ?result "tran") (1.01 * VAR("VDDL")) 1 "falling") - cross(v("/VL" ?result "tran") (0.5 * VAR("VDDH")) 1 "rising"))
plot( Tfall ?expr '( "Tfall" ) )
leakageLine = average(i("/ILine/src") (VAR("timeB") + (0.25 * (VAR("timeC") - VAR("timeB")))) (VAR("timeC") - (0.25 * (VAR("timeC") - VAR("timeB")))))
plot( leakageLine ?expr '( "leakageLine" ) )
backLeakage = average(i("/IVDDL/dst") (VAR("timeB") + (0.25 * (VAR("timeC") - VAR("timeB")))) (VAR("timeC") - (0.25 * (VAR("timeC") - VAR("timeB")))))
plot( backLeakage ?expr '( "backLeakage" ) )
totalLeak = average(i("/IVDDH/src") (VAR("timeB") + (0.25 * (VAR("timeC") - VAR("timeB")))) (VAR("timeC") - (0.25 * (VAR("timeC") - VAR("timeB")))))
plot( totalLeak ?expr '( "totalLeak" ) )
modelFile(
    '("/root/Desktop/Cadence/ncsu-FreePDK15/hspice_16nm_hp.include" "")
)
run()
selectResult( 'tran )
plot(getData("/Vline") getData("/VL") getData("/VH") getData("/IVDDH/src") getData("/IVDDL/dst") getData("/ILine/src") )
Trise = (cross(v("/Vline" ?result "tran") (0.99 * VAR("VDDH")) 2 "rising") - cross(v("/VH" ?result "tran") (0.5 * VAR("VDDH")) 2 "falling"))
plot( Trise ?expr '( "Trise" ) )
Tfall = (cross(v("/Vline" ?result "tran") (1.01 * VAR("VDDL")) 1 "falling") - cross(v("/VH" ?result "tran") (0.5 * VAR("VDDH")) 1 "rising"))
plot( Tfall ?expr '( "Tfall" ) )
leakageLine = average(clip(i("/ILine/src" ?result "tran") (VAR("timeB") + (0.25 * (VAR("timeC") - VAR("timeB")))) (VAR("timeC") - (0.25 * (VAR("timeC") - VAR("timeB"))))))
plot( leakageLine ?expr '( "leakageLine" ) )
backLeakage = average(clip(i("/IVDDL/dst" ?result "tran") (VAR("timeB") + (0.25 * (VAR("timeC") - VAR("timeB")))) (VAR("timeC") - (0.25 * (VAR("timeC") - VAR("timeB"))))))
plot( backLeakage ?expr '( "backLeakage" ) )
totalLeak = average(clip(i("/IVDDH/src" ?result "tran") (VAR("timeB") + (0.25 * (VAR("timeC") - VAR("timeB")))) (VAR("timeC") - (0.25 * (VAR("timeC") - VAR("timeB"))))))
plot( totalLeak ?expr '( "totalLeak" ) )
modelFile(
    '("/root/Desktop/Cadence/ncsu-FreePDK15/hspice_16nm_hp.include" "")
)
desVar(	  "nfin" 2	)
run()
selectResult( 'tran )
plot(getData("/Vline") getData("/VL") getData("/VH") getData("/IVDDH/src") getData("/IVDDL/dst") getData("/ILine/src") )
Trise = (cross(v("/Vline" ?result "tran") (0.99 * VAR("VDDH")) 2 "rising") - cross(v("/VH" ?result "tran") (0.5 * VAR("VDDH")) 2 "falling"))
plot( Trise ?expr '( "Trise" ) )
Tfall = (cross(v("/Vline" ?result "tran") (1.01 * VAR("VDDL")) 1 "falling") - cross(v("/VH" ?result "tran") (0.5 * VAR("VDDH")) 1 "rising"))
plot( Tfall ?expr '( "Tfall" ) )
leakageLine = average(clip(i("/ILine/src" ?result "tran") (VAR("timeB") + (0.25 * (VAR("timeC") - VAR("timeB")))) (VAR("timeC") - (0.25 * (VAR("timeC") - VAR("timeB"))))))
plot( leakageLine ?expr '( "leakageLine" ) )
backLeakage = average(clip(i("/IVDDL/dst" ?result "tran") (VAR("timeB") + (0.25 * (VAR("timeC") - VAR("timeB")))) (VAR("timeC") - (0.25 * (VAR("timeC") - VAR("timeB"))))))
plot( backLeakage ?expr '( "backLeakage" ) )
totalLeak = average(clip(i("/IVDDH/src" ?result "tran") (VAR("timeB") + (0.25 * (VAR("timeC") - VAR("timeB")))) (VAR("timeC") - (0.25 * (VAR("timeC") - VAR("timeB"))))))
plot( totalLeak ?expr '( "totalLeak" ) )
modelFile(
    '("/root/Desktop/Cadence/ncsu-FreePDK15/hspice_16nm_hp.include" "")
)
desVar(	  "timeF" 15.01n	)
desVar(	  "timeD" 8.01n	)
desVar(	  "timeB" 1.01n	)
desVar(	  "nfin" 4	)
run()
selectResult( 'tran )
plot(getData("/Vline") getData("/VL") getData("/VH") getData("/IVDDH/src") getData("/IVDDL/dst") getData("/ILine/src") )
Trise = (cross(v("/Vline" ?result "tran") (0.99 * VAR("VDDH")) 2 "rising") - cross(v("/VH" ?result "tran") (0.5 * VAR("VDDH")) 2 "falling"))
plot( Trise ?expr '( "Trise" ) )
Tfall = (cross(v("/Vline" ?result "tran") (1.01 * VAR("VDDL")) 1 "falling") - cross(v("/VH" ?result "tran") (0.5 * VAR("VDDH")) 1 "rising"))
plot( Tfall ?expr '( "Tfall" ) )
leakageLine = average(clip(i("/ILine/src" ?result "tran") (VAR("timeB") + (0.25 * (VAR("timeC") - VAR("timeB")))) (VAR("timeC") - (0.25 * (VAR("timeC") - VAR("timeB"))))))
plot( leakageLine ?expr '( "leakageLine" ) )
backLeakage = average(clip(i("/IVDDL/dst" ?result "tran") (VAR("timeB") + (0.25 * (VAR("timeC") - VAR("timeB")))) (VAR("timeC") - (0.25 * (VAR("timeC") - VAR("timeB"))))))
plot( backLeakage ?expr '( "backLeakage" ) )
totalLeak = average(clip(i("/IVDDH/src" ?result "tran") (VAR("timeB") + (0.25 * (VAR("timeC") - VAR("timeB")))) (VAR("timeC") - (0.25 * (VAR("timeC") - VAR("timeB"))))))
plot( totalLeak ?expr '( "totalLeak" ) )
modelFile(
    '("/root/Desktop/Cadence/ncsu-FreePDK15/hspice_16nm_hp.include" "")
)
desVar(	  "nfin" 7	)
run()
selectResult( 'tran )
plot(getData("/Vline") getData("/VL") getData("/VH") getData("/IVDDH/src") getData("/IVDDL/dst") getData("/ILine/src") )
Trise = (cross(v("/Vline" ?result "tran") (0.99 * VAR("VDDH")) 2 "rising") - cross(v("/VH" ?result "tran") (0.5 * VAR("VDDH")) 2 "falling"))
plot( Trise ?expr '( "Trise" ) )
Tfall = (cross(v("/Vline" ?result "tran") (1.01 * VAR("VDDL")) 1 "falling") - cross(v("/VH" ?result "tran") (0.5 * VAR("VDDH")) 1 "rising"))
plot( Tfall ?expr '( "Tfall" ) )
leakageLine = average(clip(i("/ILine/src" ?result "tran") (VAR("timeB") + (0.25 * (VAR("timeC") - VAR("timeB")))) (VAR("timeC") - (0.25 * (VAR("timeC") - VAR("timeB"))))))
plot( leakageLine ?expr '( "leakageLine" ) )
backLeakage = average(clip(i("/IVDDL/dst" ?result "tran") (VAR("timeB") + (0.25 * (VAR("timeC") - VAR("timeB")))) (VAR("timeC") - (0.25 * (VAR("timeC") - VAR("timeB"))))))
plot( backLeakage ?expr '( "backLeakage" ) )
totalLeak = average(clip(i("/IVDDH/src" ?result "tran") (VAR("timeB") + (0.25 * (VAR("timeC") - VAR("timeB")))) (VAR("timeC") - (0.25 * (VAR("timeC") - VAR("timeB"))))))
plot( totalLeak ?expr '( "totalLeak" ) )
modelFile(
    '("/root/Desktop/Cadence/ncsu-FreePDK15/hspice_16nm_hp.include" "")
)
run()
selectResult( 'tran )
plot(getData("/Vline") getData("/VL") getData("/VH") getData("/IVDDH/src") getData("/IVDDL/dst") getData("/ILine/src") )
Trise = (cross(v("/Vline" ?result "tran") (0.99 * VAR("VDDH")) 2 "rising") - cross(v("/VH" ?result "tran") (0.5 * VAR("VDDH")) 2 "falling"))
plot( Trise ?expr '( "Trise" ) )
Tfall = (cross(v("/Vline" ?result "tran") (1.01 * VAR("VDDL")) 1 "falling") - cross(v("/VH" ?result "tran") (0.5 * VAR("VDDH")) 1 "rising"))
plot( Tfall ?expr '( "Tfall" ) )
leakageLine = average(clip(i("/ILine/src" ?result "tran") (VAR("timeB") + (0.33 * (VAR("timeC") - VAR("timeB")))) (VAR("timeC") - (0.33 * (VAR("timeC") - VAR("timeB"))))))
plot( leakageLine ?expr '( "leakageLine" ) )
backLeakage = average(clip(i("/IVDDL/dst" ?result "tran") (VAR("timeB") + (0.33 * (VAR("timeC") - VAR("timeB")))) (VAR("timeC") - (0.33 * (VAR("timeC") - VAR("timeB"))))))
plot( backLeakage ?expr '( "backLeakage" ) )
totalLeak = average(clip(i("/IVDDH/src" ?result "tran") (VAR("timeB") + (0.33 * (VAR("timeC") - VAR("timeB")))) (VAR("timeC") - (0.33 * (VAR("timeC") - VAR("timeB"))))))
plot( totalLeak ?expr '( "totalLeak" ) )
modelFile(
    '("/root/Desktop/Cadence/ncsu-FreePDK15/hspice_16nm_hp.include" "")
)
desVar(	  "nfin" 32	)
desVar(	  "C" 0.8753152p	)
run()
selectResult( 'tran )
plot(getData("/Vline") getData("/VL") getData("/VH") getData("/IVDDH/src") getData("/IVDDL/dst") getData("/ILine/src") )
Trise = (cross(v("/Vline" ?result "tran") (0.99 * VAR("VDDH")) 2 "rising") - cross(v("/VH" ?result "tran") (0.5 * VAR("VDDH")) 2 "falling"))
plot( Trise ?expr '( "Trise" ) )
Tfall = (cross(v("/Vline" ?result "tran") (1.01 * VAR("VDDL")) 1 "falling") - cross(v("/VH" ?result "tran") (0.5 * VAR("VDDH")) 1 "rising"))
plot( Tfall ?expr '( "Tfall" ) )
leakageLine = average(clip(i("/ILine/src" ?result "tran") (VAR("timeB") + (0.33 * (VAR("timeC") - VAR("timeB")))) (VAR("timeC") - (0.33 * (VAR("timeC") - VAR("timeB"))))))
plot( leakageLine ?expr '( "leakageLine" ) )
leakageIntoVDDL = average(clip(i("/IVDDL/dst" ?result "tran") (VAR("timeB") + (0.33 * (VAR("timeC") - VAR("timeB")))) (VAR("timeC") - (0.33 * (VAR("timeC") - VAR("timeB"))))))
plot( leakageIntoVDDL ?expr '( "leakageIntoVDDL" ) )
leakageVDDH = average(clip(i("/IVDDH/src" ?result "tran") (VAR("timeB") + (0.33 * (VAR("timeC") - VAR("timeB")))) (VAR("timeC") - (0.33 * (VAR("timeC") - VAR("timeB"))))))
plot( leakageVDDH ?expr '( "leakageVDDH" ) )
