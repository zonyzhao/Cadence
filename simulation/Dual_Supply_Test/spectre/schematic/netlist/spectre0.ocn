simulator( 'spectre )
design(	 "/net/kafka/nfs/rstdenis/Cadence/simulation/Dual_Supply_Test/spectre/schematic/netlist/netlist")
resultsDir( "/net/kafka/nfs/rstdenis/Cadence/simulation/Dual_Supply_Test/spectre/schematic" )
modelFile(
    '("./ncsu-FreePDK15/hspice_16nm_hp.include" "")
)
analysis('tran ?stop "10n"  ?errpreset "conservative"  )
desVar(	  "VDDL" .400	)
desVar(	  "VDDH" .600	)
desVar(	  "timeA" 10p	)
envOption(
	'analysisOrder  list("tran")
)
option(	'multithread  "on"
)
save( 'i "/V0/MINUS" "/V1/MINUS" )
converge( 'ic "/VL" "0" )
converge( 'ic "/net037" "0" )
converge( 'ic "/net018" "VDDH" )
converge( 'ic "/VH" "VDDH" )
temp( 27 )
run()
selectResult( 'tran )
plot(getData("/Vline") getData("/VL") getData("/VH") getData("/V0/MINUS") getData("/V1/MINUS") )
modelFile(
    '("./ncsu-FreePDK15/hspice_16nm_hp.include" "")
)
run()
selectResult( 'tran )
plot(getData("/Vline") getData("/VL") getData("/VH") getData("/V0/MINUS") getData("/V1/MINUS") )
modelFile(
    '("./ncsu-FreePDK15/hspice_16nm_hp.include" "")
)
run()
selectResult( 'tran )
plot(getData("/Vline") getData("/VL") getData("/VH") getData("/V0/MINUS") getData("/V1/MINUS") )
modelFile(
    '("/root/Desktop/Cadence/ncsu-FreePDK15/hspice_16nm_hp.include" "")
)
run()
selectResult( 'tran )
plot(getData("/Vline") getData("/VL") getData("/VH") getData("/V0/MINUS") getData("/V1/MINUS") )
modelFile(
    '("/root/Desktop/Cadence/ncsu-FreePDK15/hspice_16nm_hp.include" "")
)
run()
selectResult( 'tran )
plot(getData("/Vline") getData("/VL") getData("/VH") getData("/V0/MINUS") getData("/V1/MINUS") )
modelFile(
    '("/root/Desktop/Cadence/ncsu-FreePDK15/hspice_16nm_hp.include" "")
)
analysis('tran ?stop "6n"  )
desVar(	  "timeA" 500p	)
run()
selectResult( 'tran )
plot(getData("/Vline") getData("/VL") getData("/VH") getData("/V0/MINUS") getData("/V1/MINUS") )
modelFile(
    '("/root/Desktop/Cadence/ncsu-FreePDK15/hspice_16nm_hp.include" "")
)
analysis('tran ?stop "8n"  )
desVar(	  "timeA" 2n	)
desVar(	  "timeB" 2.5n	)
run()
selectResult( 'tran )
plot(getData("/Vline") getData("/VL") getData("/VH") getData("/V0/MINUS") getData("/V1/MINUS") )
modelFile(
    '("/root/Desktop/Cadence/ncsu-FreePDK15/hspice_16nm_hp.include" "")
)
analysis('tran ?stop "15n"  )
desVar(	  "timeD" 6.5n	)
desVar(	  "timeC" 6n	)
save( 'v "/Vline" "/VL" "/VH" )
run()
selectResult( 'tran )
plot(getData("/sL") getData("/sH") getData("/Vline") getData("/VL") getData("/VH") getData("/V0/MINUS") getData("/V1/MINUS") )
modelFile(
    '("/root/Desktop/Cadence/ncsu-FreePDK15/hspice_16nm_hp.include" "")
)
analysis('tran ?stop "20n"  )
desVar(	  "timeA" 1n	)
desVar(	  "timeB" 1.25n	)
desVar(	  "timeD" 6.25n	)
desVar(	  "timeF" 10	)
desVar(	  "timeE" 10.25	)
save( 'v "/sH" "/sL" )
run()
selectResult( 'tran )
plot(getData("/Vline") getData("/VL") getData("/VH") getData("/V0/MINUS") getData("/V1/MINUS") getData("/sH") getData("/sL") )
modelFile(
    '("/root/Desktop/Cadence/ncsu-FreePDK15/hspice_16nm_hp.include" "")
)
desVar(	  "timeF" 10.25n	)
desVar(	  "timeE" 10n	)
run()
selectResult( 'tran )
plot(getData("/Vline") getData("/VL") getData("/VH") getData("/V0/MINUS") getData("/V1/MINUS") getData("/sH") getData("/sL") )
modelFile(
    '("/root/Desktop/Cadence/ncsu-FreePDK15/hspice_16nm_hp.include" "")
)
analysis('tran ?stop "30n"  )
desVar(	  "timeD" 7.25n	)
desVar(	  "timeC" 7n	)
desVar(	  "timeF" 13.25n	)
desVar(	  "timeE" 13n	)
converge( 'ic "/Vline" "VDDL" )
run()
selectResult( 'tran )
plot(getData("/Vline") getData("/VL") getData("/VH") getData("/V0/MINUS") getData("/V1/MINUS") getData("/sH") getData("/sL") )
modelFile(
    '("/root/Desktop/Cadence/ncsu-FreePDK15/hspice_16nm_hp.include" "")
)
analysis('tran ?stop "20n"  )
run()
selectResult( 'tran )
plot(getData("/Vline") getData("/VL") getData("/VH") getData("/V0/MINUS") getData("/V1/MINUS") getData("/sH") getData("/sL") )
modelFile(
    '("/root/Desktop/Cadence/ncsu-FreePDK15/hspice_16nm_hp.include" "")
)
run()
selectResult( 'tran )
plot(getData("/Vline") getData("/VL") getData("/VH") getData("/V0/MINUS") getData("/V1/MINUS") getData("/sH") getData("/sL") )
modelFile(
    '("/root/Desktop/Cadence/ncsu-FreePDK15/hspice_16nm_hp.include" "")
)
run()
selectResult( 'tran )
plot(getData("/Vline") getData("/VL") getData("/VH") getData("/V0/MINUS") getData("/V1/MINUS") getData("/sH") getData("/sL") )
modelFile(
    '("/root/Desktop/Cadence/ncsu-FreePDK15/hspice_16nm_hp.include" "")
)
run()
selectResult( 'tran )
plot(getData("/Vline") getData("/VL") getData("/VH") getData("/V0/MINUS") getData("/V1/MINUS") getData("/sH") getData("/sL") )
modelFile(
    '("/root/Desktop/Cadence/ncsu-FreePDK15/hspice_16nm_hp.include" "")
)
run()
selectResult( 'tran )
plot(getData("/Vline") getData("/VL") getData("/VH") getData("/V0/MINUS") getData("/V1/MINUS") getData("/sH") getData("/sL") )
modelFile(
    '("/root/Desktop/Cadence/ncsu-FreePDK15/hspice_16nm_hp.include" "")
)
run()
selectResult( 'tran )
plot(getData("/Vline") getData("/VL") getData("/VH") getData("/V0/MINUS") getData("/V1/MINUS") getData("/sH") getData("/sL") )
modelFile(
    '("/root/Desktop/Cadence/ncsu-FreePDK15/hspice_16nm_hp.include" "")
)
converge( 'ic "/sL" "0" )
converge( 'ic "/sH" "VDDH" )
delete( 'converge 'ic "/net037" )
delete( 'converge 'ic "/net018" )
run()
selectResult( 'tran )
plot(getData("/Vline") getData("/VL") getData("/VH") getData("/V0/MINUS") getData("/V1/MINUS") getData("/sH") getData("/sL") )
modelFile(
    '("/root/Desktop/Cadence/ncsu-FreePDK15/hspice_16nm_lstp.include" "")
)
run()
selectResult( 'tran )
plot(getData("/Vline") getData("/VL") getData("/VH") getData("/V0/MINUS") getData("/V1/MINUS") getData("/sH") getData("/sL") )
modelFile(
    '("/root/Desktop/Cadence/ncsu-FreePDK15/hspice_16nm_lstp.include" "")
)
analysis('tran ?stop "30n"  )
desVar(	  "timeD" 10.25n	)
desVar(	  "timeC" 10n	)
desVar(	  "timeF" 20.25n	)
desVar(	  "timeE" 20n	)
run()
selectResult( 'tran )
plot(getData("/Vline") getData("/VL") getData("/VH") getData("/V0/MINUS") getData("/V1/MINUS") getData("/sH") getData("/sL") )
modelFile(
    '("/root/Desktop/Cadence/ncsu-FreePDK15/hspice_16nm_lstp.include" "")
)
run()
selectResult( 'tran )
plot(getData("/Vline") getData("/VL") getData("/VH") getData("/V0/MINUS") getData("/V1/MINUS") getData("/sH") getData("/sL") )
modelFile(
    '("/root/Desktop/Cadence/ncsu-FreePDK15/hspice_16nm_hp.include" "")
)
analysis('tran ?stop "25n"  )
desVar(	  "timeD" 8.25n	)
desVar(	  "timeC" 8n	)
desVar(	  "timeF" 15.25n	)
desVar(	  "timeE" 15n	)
run()
selectResult( 'tran )
plot(getData("/Vline") getData("/VL") getData("/VH") getData("/V0/MINUS") getData("/V1/MINUS") getData("/sH") getData("/sL") )
modelFile(
    '("/root/Desktop/Cadence/ncsu-FreePDK15/hspice_16nm_hp.include" "")
)
desVar(	  "C" 2.5p	)
run()
selectResult( 'tran )
plot(getData("/Vline") getData("/VL") getData("/VH") getData("/V0/MINUS") getData("/V1/MINUS") getData("/sH") getData("/sL") )
modelFile(
    '("/root/Desktop/Cadence/ncsu-FreePDK15/hspice_16nm_hp.include" "")
)
run()
selectResult( 'tran )
plot(getData("/Vline") getData("/VL") getData("/VH") getData("/V0/MINUS") getData("/V1/MINUS") getData("/sH") getData("/sL") )
