simulator( 'spectre )
design(	 "/net/kafka/nfs/rstdenis/Cadence/simulation/Dual_Supply_Test/spectre/schematic/netlist/netlist")
resultsDir( "/net/kafka/nfs/rstdenis/Cadence/simulation/Dual_Supply_Test/spectre/schematic" )
modelFile(
    '("/root/Desktop/Cadence/ncsu-FreePDK15/hspice_16nm_hp.include" "")
)
analysis('tran ?stop "22n"  ?errpreset "conservative"  )
desVar(	  "timeF" 15.01n	)
desVar(	  "timeE" 15n	)
desVar(	  "timeD" 8.01n	)
desVar(	  "timeC" 8n	)
desVar(	  "timeB" 1.01n	)
desVar(	  "timeA" 1n	)
desVar(	  "nfin" 32	)
desVar(	  "VDDL" .450	)
desVar(	  "VDDH" .600	)
desVar(	  "C" 0.8753152p	)
envOption(
	'cmd64bit  t
	'analysisOrder  list("tran")
)
option(	'multithread  "on"
)
save( 'v "/Vline" "/VL" "/VH" )
save( 'i "/IVDDH/src" "/IVDDL/dst" "/ILine/src" )
converge( 'ic "/VL" "0" )
converge( 'ic "/sH" "VDDH" )
converge( 'ic "/VH" "VDDH" )
converge( 'ic "/Vline" "VDDL" )
temp( 27 )
run()
selectResult( 'tran )
plot(getData("/Vline") getData("/VL") getData("/VH") getData("/IVDDH/src") getData("/IVDDL/dst") getData("/ILine/src") )
Trise = (tRiseEnd - tRiseStart)
plot( Trise ?expr '( "Trise" ) )
Tfall = (tFallEnd - tFallStart)
plot( Tfall ?expr '( "Tfall" ) )
leakageLine = average(clip(i("/ILine/src" ?result "tran") (VAR("timeB") + (0.33 * (VAR("timeC") - VAR("timeB")))) (VAR("timeC") - (0.33 * (VAR("timeC") - VAR("timeB"))))))
plot( leakageLine ?expr '( "leakageLine" ) )
leakageIntoVDDL = average(clip(i("/IVDDL/dst" ?result "tran") (VAR("timeB") + (0.33 * (VAR("timeC") - VAR("timeB")))) (VAR("timeC") - (0.33 * (VAR("timeC") - VAR("timeB"))))))
plot( leakageIntoVDDL ?expr '( "leakageIntoVDDL" ) )
leakageVDDH = average(clip(i("/IVDDH/src" ?result "tran") (VAR("timeB") + (0.33 * (VAR("timeC") - VAR("timeB")))) (VAR("timeC") - (0.33 * (VAR("timeC") - VAR("timeB"))))))
plot( leakageVDDH ?expr '( "leakageVDDH" ) )
tRiseStart = cross(v("/VH" ?result "tran") (0.5 * VAR("VDDH")) 2 "falling")
plot( tRiseStart ?expr '( "tRiseStart" ) )
tRiseEnd = cross(v("/Vline" ?result "tran") (0.995 * VAR("VDDH")) 2 "rising")
plot( tRiseEnd ?expr '( "tRiseEnd" ) )
tFallEnd = cross(v("/Vline" ?result "tran") (1.005 * VAR("VDDL")) 1 "falling")
plot( tFallEnd ?expr '( "tFallEnd" ) )
tFallStart = cross(v("/VH" ?result "tran") (0.5 * VAR("VDDH")) 1 "rising")
plot( tFallStart ?expr '( "tFallStart" ) )
