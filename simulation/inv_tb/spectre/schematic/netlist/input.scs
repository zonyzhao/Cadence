// Design: EEC289O_Tests/inv_tb
simulator lang=spectre
global 0 vdd!
parameters vdd=1.8V
include "/root/Desktop/Cadence/ncsu-cdk-1.6.0.beta/models/spectre/PTM/PTM180nm_bulk.scs"

// EEC289O/inv_1xt/schematic
subckt inv_1xt A Y
    P0 (Y A vdd! vdd!) tsmc18dP w=1.035u l=180.0n m=1 region=sat
    N0 (Y A 0 0) tsmc18dN w=360.0n l=180.0n m=1 region=sat
ends inv_1xt

// EEC289O_Tests/inv_tb/schematic
V0 (vdd! 0) vsource type=dc dc=vdd
I72 (nvtc Yvtc) inv_1xt
V1 (nvtc 0) vsource type=pwl mag=1 phase=0 offset=900m wave=[ 0 0 100n vdd ]
simulatorOptions options temp=27
ac ac start=100M stop=100G
save nvtc Yvtc
