simulator( 'spectre )
hostMode( 'distributed )
design(	 "/net/bull/apps/Cadence/simulation/inv_tb/spectre/schematic/netlist/netlist")
resultsDir( "/net/bull/apps/Cadence/simulation/inv_tb/spectre/schematic/distributed/job001" )
modelFile(
    '("/root/Desktop/Cadence/ncsu-cdk-1.6.0.beta/models/spectre/PTM/PTM180nm_bulk.scs" "")
)
analysis('ac ?start "100M"  ?stop "100G"  )
desVar(	  "vdd" "1.8V"	)
envOption(
	'analysisOrder  list("ac")
)
save( 'v "/nvtc" "/Yvtc" )
temp( 27 )
run( ?jobName "job" ?mail "rstdenis@ucdavis.edu" )
selectResult( 'ac )
plot(getData("/nvtc") getData("/Yvtc") )
hostMode( 'local )
resultsDir( "/net/bull/apps/Cadence/simulation/inv_tb/spectre/schematic" )
modelFile(
    '("/root/Desktop/Cadence/ncsu-cdk-1.6.0.beta/models/spectre/PTM/PTM180nm_bulk.scs" "")
)
run()
selectResult( 'ac )
plot(getData("/nvtc") getData("/Yvtc") )
modelFile(
    '("/root/Desktop/Cadence/ncsu-cdk-1.6.0.beta/models/spectre/PTM/PTM180nm_bulk.scs" "")
)
desVar(	  "vdd" .636	)
run()
selectResult( 'ac )
plot(getData("/nvtc") getData("/Yvtc") )
modelFile(
    '("/root/Desktop/Cadence/ncsu-cdk-1.6.0.beta/models/spectre/PTM/PTM180nm_bulk.scs" "")
)
desVar(	  "vdd" 1	)
run()
selectResult( 'ac )
plot(getData("/nvtc") getData("/Yvtc") )
modelFile(
    '("/root/Desktop/Cadence/ncsu-cdk-1.6.0.beta/models/spectre/PTM/PTM180nm_bulk.scs" "")
)
desVar(	  "vdd" 1.6	)
run()
selectResult( 'ac )
plot(getData("/nvtc") getData("/Yvtc") )
