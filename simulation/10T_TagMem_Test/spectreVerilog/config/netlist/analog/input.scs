// Design: 16nm_Tests/10T_TagMem_Test
simulator lang=spectre
global 0 vcc! vdd!
parameters vdd=0.5 vcc=vdd
include "/software/cadence/ncsu-FreePDK15/hspice_16nm_hp.include"

// 16nm/inv_1x/schematic
//system verilogNetlist schematic cmos.sch cmos_sch veriloga ahdl
subckt inv_1x A Y
    M0 (Y A 0 0) nfet w=60n l=20n nfin=1 m=1 degradation=no
    M1 (Y A vdd! vdd!) pfet w=100n l=20n nfin=1 m=1 degradation=no
ends inv_1x

// 16nm/nand_1x/schematic
//system verilogNetlist schematic cmos.sch cmos_sch veriloga ahdl
subckt nand_1x A B Y
    M1 (Y B vdd! vdd!) pfet w=100n l=20n nfin=1 m=1 degradation=no
    M0 (Y A vdd! vdd!) pfet w=100n l=20n nfin=1 m=1 degradation=no
    M3 (net22 B 0 0) nfet w=120n l=20n nfin=1 m=1 degradation=no
    M2 (Y A net22 0) nfet w=120n l=20n nfin=1 m=1 degradation=no
ends nand_1x

// 16nm/TH44/schematic
//system verilogNetlist schematic cmos.sch cmos_sch veriloga ahdl
subckt TH44 A B C D Y
    M19 (net13 A 0 0) nfet w=120n l=20n nfin=1 m=1 degradation=no
    M18 (net13 B 0 0) nfet w=120n l=20n nfin=1 m=1 degradation=no
    M17 (net13 C 0 0) nfet w=120n l=20n nfin=1 m=1 degradation=no
    M16 (net13 D 0 0) nfet w=120n l=20n nfin=1 m=1 degradation=no
    M15 (Y net19 0 0) nfet w=60n l=20n nfin=1 m=1 degradation=no
    M14 (net42 A 0 0) nfet w=240n l=20n nfin=1 m=1 degradation=no
    M13 (net43 B net42 0) nfet w=240n l=20n nfin=1 m=1 degradation=no
    M12 (net44 C net43 0) nfet w=240n l=20n nfin=1 m=1 degradation=no
    M11 (net19 D net44 0) nfet w=240n l=20n nfin=1 m=1 degradation=no
    M10 (net19 Y net13 0) nfet w=120n l=20n nfin=1 m=1 degradation=no
    M9 (Y net19 vdd! vdd!) pfet w=100n l=20n nfin=1 m=1 degradation=yes
    M8 (net19 Y net15 vdd!) pfet w=200n l=20n nfin=1 m=1 degradation=yes
    M7 (net15 D vdd! vdd!) pfet w=200n l=20n nfin=1 m=1 degradation=yes
    M6 (net15 C vdd! vdd!) pfet w=200n l=20n nfin=1 m=1 degradation=yes
    M5 (net15 B vdd! vdd!) pfet w=200n l=20n nfin=1 m=1 degradation=yes
    M4 (net15 A vdd! vdd!) pfet w=200n l=20n nfin=1 m=1 degradation=yes
    M3 (net19 D net45 vdd!) pfet w=320n l=20n nfin=1 m=1 degradation=yes
    M2 (net45 C net46 vdd!) pfet w=320n l=20n nfin=1 m=1 degradation=yes
    M1 (net46 B net47 vdd!) pfet w=320n l=20n nfin=1 m=1 degradation=yes
    M0 (net47 A vdd! vdd!) pfet w=320n l=20n nfin=1 m=1 degradation=yes
ends TH44

// 16nm/TH22/schematic
//system verilogNetlist schematic cmos.sch cmos_sch veriloga ahdl
subckt TH22 A B Y
    M5 (Y net5 0 0) nfet w=60n l=20n nfin=1 m=1 degradation=no
    M4 (net5 Y net9 0) nfet w=120n l=20n nfin=1 m=1 degradation=no
    M3 (net9 B 0 0) nfet w=120n l=20n nfin=1 m=1 degradation=no
    M2 (net9 A 0 0) nfet w=120n l=20n nfin=1 m=1 degradation=no
    M1 (net5 B net17 0) nfet w=120n l=20n nfin=1 m=1 degradation=no
    M0 (net17 A 0 0) nfet w=120n l=20n nfin=1 m=1 degradation=no
    M11 (Y net5 vdd! vdd!) pfet w=100n l=20n nfin=1 m=1 degradation=yes
    M10 (net5 B net032 vdd!) pfet w=200n l=20n nfin=1 m=1 degradation=yes
    M9 (net032 A vdd! vdd!) pfet w=200n l=20n nfin=1 m=1 degradation=yes
    M8 (net037 B vdd! vdd!) pfet w=200n l=20n nfin=1 m=1 degradation=yes
    M7 (net037 A vdd! vdd!) pfet w=200n l=20n nfin=1 m=1 degradation=yes
    M6 (net5 Y net037 vdd!) pfet w=200n l=20n nfin=1 m=1 degradation=yes
ends TH22

// 16nm/10T_DUAL_SRAM_CompDetect/schematic
//system verilogNetlist schematic cmos.sch cmos_sch veriloga ahdl
subckt _sub138 KRe KRv KWe KWv R0_31 R0_30 R0_29 R0_28 R0_27 R0_26 R0_25 R0_24 R0_23 R0_22 R0_21 R0_20 R0_19 R0_18 R0_17 R0_16 R0_15 R0_14 R0_13 R0_12 R0_11 R0_10 R0_9 R0_8 R0_7 R0_6 R0_5 R0_4 R0_3 R0_2 R0_1 R0_0 R1_31 R1_30 R1_29 R1_28 R1_27 R1_26 R1_25 R1_24 R1_23 R1_22 R1_21 R1_20 R1_19 R1_18 R1_17 R1_16 R1_15 R1_14 R1_13 R1_12 R1_11 R1_10 R1_9 R1_8 R1_7 R1_6 R1_5 R1_4 R1_3 R1_2 R1_1 R1_0 Re2_7 Re2_6 Re2_5 Re2_4 Re2_3 Re2_2 Re2_1 Re2_0 W0_31 W0_30 W0_29 W0_28 W0_27 W0_26 W0_25 W0_24 W0_23 W0_22 W0_21 W0_20 W0_19 W0_18 W0_17 W0_16 W0_15 W0_14 W0_13 W0_12 W0_11 W0_10 W0_9 W0_8 W0_7 W0_6 W0_5 W0_4 W0_3 W0_2 W0_1 W0_0 W1_31 W1_30 W1_29 W1_28 W1_27 W1_26 W1_25 W1_24 W1_23 W1_22 W1_21 W1_20 W1_19 W1_18 W1_17 W1_16 W1_15 W1_14 W1_13 W1_12 W1_11 W1_10 W1_9 W1_8 W1_7 W1_6 W1_5 W1_4 W1_3 W1_2 W1_1 W1_0 We_7 We_6 We_5 We_4 We_3 We_2 We_1 We_0 \~R0_31 \~R0_30 \~R0_29 \~R0_28 \~R0_27 \~R0_26 \~R0_25 \~R0_24 \~R0_23 \~R0_22 \~R0_21 \~R0_20 \~R0_19 \~R0_18 \~R0_17 \~R0_16 \~R0_15 \~R0_14 \~R0_13 \~R0_12 \~R0_11 \~R0_10 \~R0_9 \~R0_8 \~R0_7 \~R0_6 \~R0_5 \~R0_4 \~R0_3 \~R0_2 \~R0_1 \~R0_0 \~R1_31 \~R1_30 \~R1_29 \~R1_28 \~R1_27 \~R1_26 \~R1_25 \~R1_24 \~R1_23 \~R1_22 \~R1_21 \~R1_20 \~R1_19 \~R1_18 \~R1_17 \~R1_16 \~R1_15 \~R1_14 \~R1_13 \~R1_12 \~R1_11 \~R1_10 \~R1_9 \~R1_8 \~R1_7 \~R1_6 \~R1_5 \~R1_4 \~R1_3 \~R1_2 \~R1_1 \~R1_0 \~W0_31 \~W0_30 \~W0_29 \~W0_28 \~W0_27 \~W0_26 \~W0_25 \~W0_24 \~W0_23 \~W0_22 \~W0_21 \~W0_20 \~W0_19 \~W0_18 \~W0_17 \~W0_16 \~W0_15 \~W0_14 \~W0_13 \~W0_12 \~W0_11 \~W0_10 \~W0_9 \~W0_8 \~W0_7 \~W0_6 \~W0_5 \~W0_4 \~W0_3 \~W0_2 \~W0_1 \~W0_0 \~W1_31 \~W1_30 \~W1_29 \~W1_28 \~W1_27 \~W1_26 \~W1_25 \~W1_24 \~W1_23 \~W1_22 \~W1_21 \~W1_20 \~W1_19 \~W1_18 \~W1_17 \~W1_16 \~W1_15 \~W1_14 \~W1_13 \~W1_12 \~W1_11 \~W1_10 \~W1_9 \~W1_8 \~W1_7 \~W1_6 \~W1_5 \~W1_4 \~W1_3 \~W1_2 \~W1_1 \~W1_0
    I77_3 (net0117_0 We_7) inv_1x
    I77_2 (net0117_1 We_6) inv_1x
    I77_1 (net0117_2 We_5) inv_1x
    I77_0 (net0117_3 We_4) inv_1x
    I76_3 (net0118_0 We_3) inv_1x
    I76_2 (net0118_1 We_2) inv_1x
    I76_1 (net0118_2 We_1) inv_1x
    I76_0 (net0118_3 We_0) inv_1x
    I75_3 (net0115_0 Re2_7) inv_1x
    I75_2 (net0115_1 Re2_6) inv_1x
    I75_1 (net0115_2 Re2_5) inv_1x
    I75_0 (net0115_3 Re2_4) inv_1x
    I73_3 (\~KRe_7 net0115_0) inv_1x
    I73_2 (\~KRe_6 net0115_1) inv_1x
    I73_1 (\~KRe_5 net0115_2) inv_1x
    I73_0 (\~KRe_4 net0115_3) inv_1x
    I72_3 (\~KRe_3 net0116_0) inv_1x
    I72_2 (\~KRe_2 net0116_1) inv_1x
    I72_1 (\~KRe_1 net0116_2) inv_1x
    I72_0 (\~KRe_0 net0116_3) inv_1x
    I71_3 (\~KWe_7 net0117_0) inv_1x
    I71_2 (\~KWe_6 net0117_1) inv_1x
    I71_1 (\~KWe_5 net0117_2) inv_1x
    I71_0 (\~KWe_4 net0117_3) inv_1x
    I70_3 (\~KWe_3 net0118_0) inv_1x
    I70_2 (\~KWe_2 net0118_1) inv_1x
    I70_1 (\~KWe_1 net0118_2) inv_1x
    I70_0 (\~KWe_0 net0118_3) inv_1x
    I66 (KRve_0 \~KRe_0) inv_1x
    I63 (KRve_1 \~KRe_1) inv_1x
    I59 (KRve_2 \~KRe_2) inv_1x
    I56 (KRve_3 \~KRe_3) inv_1x
    I52 (KRve_4 \~KRe_4) inv_1x
    I49 (KRve_5 \~KRe_5) inv_1x
    I45 (KRve_6 \~KRe_6) inv_1x
    I42 (KRve_7 \~KRe_7) inv_1x
    I37 (KWve_7 \~KWe_7) inv_1x
    I36 (KWve_6 \~KWe_6) inv_1x
    I35 (KWve_5 \~KWe_5) inv_1x
    I34 (KWve_4 \~KWe_4) inv_1x
    I33 (KWve_3 \~KWe_3) inv_1x
    I32 (KWve_2 \~KWe_2) inv_1x
    I31 (KWve_1 \~KWe_1) inv_1x
    I30 (KWve_0 \~KWe_0) inv_1x
    I74_3 (net0116_0 Re2_3) inv_1x
    I74_2 (net0116_1 Re2_2) inv_1x
    I74_1 (net0116_2 Re2_1) inv_1x
    I74_0 (net0116_3 Re2_0) inv_1x
    I3_31 (\~R1_31 R1_31) inv_1x
    I3_30 (\~R1_30 R1_30) inv_1x
    I3_29 (\~R1_29 R1_29) inv_1x
    I3_28 (\~R1_28 R1_28) inv_1x
    I3_27 (\~R1_27 R1_27) inv_1x
    I3_26 (\~R1_26 R1_26) inv_1x
    I3_25 (\~R1_25 R1_25) inv_1x
    I3_24 (\~R1_24 R1_24) inv_1x
    I3_23 (\~R1_23 R1_23) inv_1x
    I3_22 (\~R1_22 R1_22) inv_1x
    I3_21 (\~R1_21 R1_21) inv_1x
    I3_20 (\~R1_20 R1_20) inv_1x
    I3_19 (\~R1_19 R1_19) inv_1x
    I3_18 (\~R1_18 R1_18) inv_1x
    I3_17 (\~R1_17 R1_17) inv_1x
    I3_16 (\~R1_16 R1_16) inv_1x
    I3_15 (\~R1_15 R1_15) inv_1x
    I3_14 (\~R1_14 R1_14) inv_1x
    I3_13 (\~R1_13 R1_13) inv_1x
    I3_12 (\~R1_12 R1_12) inv_1x
    I3_11 (\~R1_11 R1_11) inv_1x
    I3_10 (\~R1_10 R1_10) inv_1x
    I3_9 (\~R1_9 R1_9) inv_1x
    I3_8 (\~R1_8 R1_8) inv_1x
    I3_7 (\~R1_7 R1_7) inv_1x
    I3_6 (\~R1_6 R1_6) inv_1x
    I3_5 (\~R1_5 R1_5) inv_1x
    I3_4 (\~R1_4 R1_4) inv_1x
    I3_3 (\~R1_3 R1_3) inv_1x
    I3_2 (\~R1_2 R1_2) inv_1x
    I3_1 (\~R1_1 R1_1) inv_1x
    I3_0 (\~R1_0 R1_0) inv_1x
    I2_31 (\~R0_31 R0_31) inv_1x
    I2_30 (\~R0_30 R0_30) inv_1x
    I2_29 (\~R0_29 R0_29) inv_1x
    I2_28 (\~R0_28 R0_28) inv_1x
    I2_27 (\~R0_27 R0_27) inv_1x
    I2_26 (\~R0_26 R0_26) inv_1x
    I2_25 (\~R0_25 R0_25) inv_1x
    I2_24 (\~R0_24 R0_24) inv_1x
    I2_23 (\~R0_23 R0_23) inv_1x
    I2_22 (\~R0_22 R0_22) inv_1x
    I2_21 (\~R0_21 R0_21) inv_1x
    I2_20 (\~R0_20 R0_20) inv_1x
    I2_19 (\~R0_19 R0_19) inv_1x
    I2_18 (\~R0_18 R0_18) inv_1x
    I2_17 (\~R0_17 R0_17) inv_1x
    I2_16 (\~R0_16 R0_16) inv_1x
    I2_15 (\~R0_15 R0_15) inv_1x
    I2_14 (\~R0_14 R0_14) inv_1x
    I2_13 (\~R0_13 R0_13) inv_1x
    I2_12 (\~R0_12 R0_12) inv_1x
    I2_11 (\~R0_11 R0_11) inv_1x
    I2_10 (\~R0_10 R0_10) inv_1x
    I2_9 (\~R0_9 R0_9) inv_1x
    I2_8 (\~R0_8 R0_8) inv_1x
    I2_7 (\~R0_7 R0_7) inv_1x
    I2_6 (\~R0_6 R0_6) inv_1x
    I2_5 (\~R0_5 R0_5) inv_1x
    I2_4 (\~R0_4 R0_4) inv_1x
    I2_3 (\~R0_3 R0_3) inv_1x
    I2_2 (\~R0_2 R0_2) inv_1x
    I2_1 (\~R0_1 R0_1) inv_1x
    I2_0 (\~R0_0 R0_0) inv_1x
    I1_31 (W1_31 \~W1_31) inv_1x
    I1_30 (W1_30 \~W1_30) inv_1x
    I1_29 (W1_29 \~W1_29) inv_1x
    I1_28 (W1_28 \~W1_28) inv_1x
    I1_27 (W1_27 \~W1_27) inv_1x
    I1_26 (W1_26 \~W1_26) inv_1x
    I1_25 (W1_25 \~W1_25) inv_1x
    I1_24 (W1_24 \~W1_24) inv_1x
    I1_23 (W1_23 \~W1_23) inv_1x
    I1_22 (W1_22 \~W1_22) inv_1x
    I1_21 (W1_21 \~W1_21) inv_1x
    I1_20 (W1_20 \~W1_20) inv_1x
    I1_19 (W1_19 \~W1_19) inv_1x
    I1_18 (W1_18 \~W1_18) inv_1x
    I1_17 (W1_17 \~W1_17) inv_1x
    I1_16 (W1_16 \~W1_16) inv_1x
    I1_15 (W1_15 \~W1_15) inv_1x
    I1_14 (W1_14 \~W1_14) inv_1x
    I1_13 (W1_13 \~W1_13) inv_1x
    I1_12 (W1_12 \~W1_12) inv_1x
    I1_11 (W1_11 \~W1_11) inv_1x
    I1_10 (W1_10 \~W1_10) inv_1x
    I1_9 (W1_9 \~W1_9) inv_1x
    I1_8 (W1_8 \~W1_8) inv_1x
    I1_7 (W1_7 \~W1_7) inv_1x
    I1_6 (W1_6 \~W1_6) inv_1x
    I1_5 (W1_5 \~W1_5) inv_1x
    I1_4 (W1_4 \~W1_4) inv_1x
    I1_3 (W1_3 \~W1_3) inv_1x
    I1_2 (W1_2 \~W1_2) inv_1x
    I1_1 (W1_1 \~W1_1) inv_1x
    I1_0 (W1_0 \~W1_0) inv_1x
    I0_31 (W0_31 \~W0_31) inv_1x
    I0_30 (W0_30 \~W0_30) inv_1x
    I0_29 (W0_29 \~W0_29) inv_1x
    I0_28 (W0_28 \~W0_28) inv_1x
    I0_27 (W0_27 \~W0_27) inv_1x
    I0_26 (W0_26 \~W0_26) inv_1x
    I0_25 (W0_25 \~W0_25) inv_1x
    I0_24 (W0_24 \~W0_24) inv_1x
    I0_23 (W0_23 \~W0_23) inv_1x
    I0_22 (W0_22 \~W0_22) inv_1x
    I0_21 (W0_21 \~W0_21) inv_1x
    I0_20 (W0_20 \~W0_20) inv_1x
    I0_19 (W0_19 \~W0_19) inv_1x
    I0_18 (W0_18 \~W0_18) inv_1x
    I0_17 (W0_17 \~W0_17) inv_1x
    I0_16 (W0_16 \~W0_16) inv_1x
    I0_15 (W0_15 \~W0_15) inv_1x
    I0_14 (W0_14 \~W0_14) inv_1x
    I0_13 (W0_13 \~W0_13) inv_1x
    I0_12 (W0_12 \~W0_12) inv_1x
    I0_11 (W0_11 \~W0_11) inv_1x
    I0_10 (W0_10 \~W0_10) inv_1x
    I0_9 (W0_9 \~W0_9) inv_1x
    I0_8 (W0_8 \~W0_8) inv_1x
    I0_7 (W0_7 \~W0_7) inv_1x
    I0_6 (W0_6 \~W0_6) inv_1x
    I0_5 (W0_5 \~W0_5) inv_1x
    I0_4 (W0_4 \~W0_4) inv_1x
    I0_3 (W0_3 \~W0_3) inv_1x
    I0_2 (W0_2 \~W0_2) inv_1x
    I0_1 (W0_1 \~W0_1) inv_1x
    I0_0 (W0_0 \~W0_0) inv_1x
    I5_31 (\~R0_31 \~R1_31 Rnand_31) nand_1x
    I5_30 (\~R0_30 \~R1_30 Rnand_30) nand_1x
    I5_29 (\~R0_29 \~R1_29 Rnand_29) nand_1x
    I5_28 (\~R0_28 \~R1_28 Rnand_28) nand_1x
    I5_27 (\~R0_27 \~R1_27 Rnand_27) nand_1x
    I5_26 (\~R0_26 \~R1_26 Rnand_26) nand_1x
    I5_25 (\~R0_25 \~R1_25 Rnand_25) nand_1x
    I5_24 (\~R0_24 \~R1_24 Rnand_24) nand_1x
    I5_23 (\~R0_23 \~R1_23 Rnand_23) nand_1x
    I5_22 (\~R0_22 \~R1_22 Rnand_22) nand_1x
    I5_21 (\~R0_21 \~R1_21 Rnand_21) nand_1x
    I5_20 (\~R0_20 \~R1_20 Rnand_20) nand_1x
    I5_19 (\~R0_19 \~R1_19 Rnand_19) nand_1x
    I5_18 (\~R0_18 \~R1_18 Rnand_18) nand_1x
    I5_17 (\~R0_17 \~R1_17 Rnand_17) nand_1x
    I5_16 (\~R0_16 \~R1_16 Rnand_16) nand_1x
    I5_15 (\~R0_15 \~R1_15 Rnand_15) nand_1x
    I5_14 (\~R0_14 \~R1_14 Rnand_14) nand_1x
    I5_13 (\~R0_13 \~R1_13 Rnand_13) nand_1x
    I5_12 (\~R0_12 \~R1_12 Rnand_12) nand_1x
    I5_11 (\~R0_11 \~R1_11 Rnand_11) nand_1x
    I5_10 (\~R0_10 \~R1_10 Rnand_10) nand_1x
    I5_9 (\~R0_9 \~R1_9 Rnand_9) nand_1x
    I5_8 (\~R0_8 \~R1_8 Rnand_8) nand_1x
    I5_7 (\~R0_7 \~R1_7 Rnand_7) nand_1x
    I5_6 (\~R0_6 \~R1_6 Rnand_6) nand_1x
    I5_5 (\~R0_5 \~R1_5 Rnand_5) nand_1x
    I5_4 (\~R0_4 \~R1_4 Rnand_4) nand_1x
    I5_3 (\~R0_3 \~R1_3 Rnand_3) nand_1x
    I5_2 (\~R0_2 \~R1_2 Rnand_2) nand_1x
    I5_1 (\~R0_1 \~R1_1 Rnand_1) nand_1x
    I5_0 (\~R0_0 \~R1_0 Rnand_0) nand_1x
    I4_31 (\~W0_31 \~W1_31 Wnand_31) nand_1x
    I4_30 (\~W0_30 \~W1_30 Wnand_30) nand_1x
    I4_29 (\~W0_29 \~W1_29 Wnand_29) nand_1x
    I4_28 (\~W0_28 \~W1_28 Wnand_28) nand_1x
    I4_27 (\~W0_27 \~W1_27 Wnand_27) nand_1x
    I4_26 (\~W0_26 \~W1_26 Wnand_26) nand_1x
    I4_25 (\~W0_25 \~W1_25 Wnand_25) nand_1x
    I4_24 (\~W0_24 \~W1_24 Wnand_24) nand_1x
    I4_23 (\~W0_23 \~W1_23 Wnand_23) nand_1x
    I4_22 (\~W0_22 \~W1_22 Wnand_22) nand_1x
    I4_21 (\~W0_21 \~W1_21 Wnand_21) nand_1x
    I4_20 (\~W0_20 \~W1_20 Wnand_20) nand_1x
    I4_19 (\~W0_19 \~W1_19 Wnand_19) nand_1x
    I4_18 (\~W0_18 \~W1_18 Wnand_18) nand_1x
    I4_17 (\~W0_17 \~W1_17 Wnand_17) nand_1x
    I4_16 (\~W0_16 \~W1_16 Wnand_16) nand_1x
    I4_15 (\~W0_15 \~W1_15 Wnand_15) nand_1x
    I4_14 (\~W0_14 \~W1_14 Wnand_14) nand_1x
    I4_13 (\~W0_13 \~W1_13 Wnand_13) nand_1x
    I4_12 (\~W0_12 \~W1_12 Wnand_12) nand_1x
    I4_11 (\~W0_11 \~W1_11 Wnand_11) nand_1x
    I4_10 (\~W0_10 \~W1_10 Wnand_10) nand_1x
    I4_9 (\~W0_9 \~W1_9 Wnand_9) nand_1x
    I4_8 (\~W0_8 \~W1_8 Wnand_8) nand_1x
    I4_7 (\~W0_7 \~W1_7 Wnand_7) nand_1x
    I4_6 (\~W0_6 \~W1_6 Wnand_6) nand_1x
    I4_5 (\~W0_5 \~W1_5 Wnand_5) nand_1x
    I4_4 (\~W0_4 \~W1_4 Wnand_4) nand_1x
    I4_3 (\~W0_3 \~W1_3 Wnand_3) nand_1x
    I4_2 (\~W0_2 \~W1_2 Wnand_2) nand_1x
    I4_1 (\~W0_1 \~W1_1 Wnand_1) nand_1x
    I4_0 (\~W0_0 \~W1_0 Wnand_0) nand_1x
    I68 (Rnand_0 Rnand_1 Rnand_2 Rnand_3 Rv_0) TH44
    I65 (Rnand_4 Rnand_5 Rnand_6 Rnand_7 Rv_1) TH44
    I62 (\~KRe_0 \~KRe_1 \~KRe_2 \~KRe_3 net088) TH44
    I61 (Rnand_8 Rnand_9 Rnand_10 Rnand_11 Rv_2) TH44
    I58 (Rnand_12 Rnand_13 Rnand_14 Rnand_15 Rv_3) TH44
    I54 (Rnand_16 Rnand_17 Rnand_18 Rnand_19 Rv_4) TH44
    I51 (Rnand_20 Rnand_21 Rnand_22 Rnand_23 Rv_5) TH44
    I48 (\~KRe_4 \~KRe_5 \~KRe_6 \~KRe_7 net087) TH44
    I47 (Rnand_24 Rnand_25 Rnand_26 Rnand_27 Rv_6) TH44
    I44 (Rnand_28 Rnand_29 Rnand_30 Rnand_31 Rv_7) TH44
    I39 (\~KWe_4 \~KWe_5 \~KWe_6 \~KWe_7 net089) TH44
    I38 (\~KWe_0 \~KWe_1 \~KWe_2 \~KWe_3 net090) TH44
    I13 (Wnand_28 Wnand_29 Wnand_30 Wnand_31 Wv_7) TH44
    I12 (Wnand_24 Wnand_25 Wnand_26 Wnand_27 Wv_6) TH44
    I11 (Wnand_20 Wnand_21 Wnand_22 Wnand_23 Wv_5) TH44
    I10 (Wnand_16 Wnand_17 Wnand_18 Wnand_19 Wv_4) TH44
    I9 (Wnand_12 Wnand_13 Wnand_14 Wnand_15 Wv_3) TH44
    I8 (Wnand_8 Wnand_9 Wnand_10 Wnand_11 Wv_2) TH44
    I7 (Wnand_4 Wnand_5 Wnand_6 Wnand_7 Wv_1) TH44
    I6 (Wnand_0 Wnand_1 Wnand_2 Wnand_3 Wv_0) TH44
    I67 (KRv Rv_0 KRve_0) TH22
    I64 (KRv Rv_1 KRve_1) TH22
    I60 (KRv Rv_2 KRve_2) TH22
    I57 (KRv Rv_3 KRve_3) TH22
    I55 (net088 net087 KRe) TH22
    I53 (KRv Rv_4 KRve_4) TH22
    I50 (KRv Rv_5 KRve_5) TH22
    I46 (KRv Rv_6 KRve_6) TH22
    I43 (KRv Rv_7 KRve_7) TH22
    I41 (net090 net089 KWe) TH22
    I23 (Wv_1 KWv KWve_1) TH22
    I24 (Wv_2 KWv KWve_2) TH22
    I25 (Wv_3 KWv KWve_3) TH22
    I26 (Wv_4 KWv KWve_4) TH22
    I22 (Wv_0 KWv KWve_0) TH22
    I27 (Wv_5 KWv KWve_5) TH22
    I28 (Wv_6 KWv KWve_6) TH22
    I29 (Wv_7 KWv KWve_7) TH22
ends _sub138

// 16nm/10T/schematic
//system verilogNetlist schematic cmos.sch cmos_sch veriloga ahdl
subckt _sub139 JRi JWi \~R0 \~R1 \~W0 \~W1
    I3 (Q Qb) inv_1x
    I1 (Qb Q) inv_1x
    M1 (\~R1 JRi net023 0) nfet w=40n l=16n nfin=1 m=1 degradation=no
    M0 (Qb JWi \~W0 0) nfet w=40n l=16n nfin=1 m=1 degradation=no
    M2 (net023 Qb 0 0) nfet w=40n l=16n nfin=1 m=1 degradation=no
    M5 (\~R0 JRi net020 0) nfet w=40n l=16n nfin=1 m=1 degradation=no
    M3 (net020 Q 0 0) nfet w=40n l=16n nfin=1 m=1 degradation=no
    M4 (Q JWi \~W1 0) nfet w=40n l=16n nfin=1 m=1 degradation=no
ends _sub139

// 16nm/10T_4x/schematic
//system verilogNetlist schematic cmos.sch cmos_sch veriloga ahdl
subckt _sub140 JRi JWi \~R0_3 \~R0_2 \~R0_1 \~R0_0 \~R1_3 \~R1_2 \~R1_1 \~R1_0 \~W0_3 \~W0_2 \~W0_1 \~W0_0 \~W1_3 \~W1_2 \~W1_1 \~W1_0
    I3 (JRi JWi \~R0_0 \~R1_0 \~W0_0 \~W1_0) _sub139
    I2 (JRi JWi \~R0_1 \~R1_1 \~W0_1 \~W1_1) _sub139
    I1 (JRi JWi \~R0_2 \~R1_2 \~W0_2 \~W1_2) _sub139
    I0 (JRi JWi \~R0_3 \~R1_3 \~W0_3 \~W1_3) _sub139
ends _sub140

// 16nm/10T_32x32/schematic
//system verilogNetlist schematic cmos.sch cmos_sch veriloga ahdl
subckt _sub141 JR_31 JR_30 JR_29 JR_28 JR_27 JR_26 JR_25 JR_24 JR_23 JR_22 JR_21 JR_20 JR_19 JR_18 JR_17 JR_16 JR_15 JR_14 JR_13 JR_12 JR_11 JR_10 JR_9 JR_8 JR_7 JR_6 JR_5 JR_4 JR_3 JR_2 JR_1 JR_0 JW_31 JW_30 JW_29 JW_28 JW_27 JW_26 JW_25 JW_24 JW_23 JW_22 JW_21 JW_20 JW_19 JW_18 JW_17 JW_16 JW_15 JW_14 JW_13 JW_12 JW_11 JW_10 JW_9 JW_8 JW_7 JW_6 JW_5 JW_4 JW_3 JW_2 JW_1 JW_0 \~R0_31 \~R0_30 \~R0_29 \~R0_28 \~R0_27 \~R0_26 \~R0_25 \~R0_24 \~R0_23 \~R0_22 \~R0_21 \~R0_20 \~R0_19 \~R0_18 \~R0_17 \~R0_16 \~R0_15 \~R0_14 \~R0_13 \~R0_12 \~R0_11 \~R0_10 \~R0_9 \~R0_8 \~R0_7 \~R0_6 \~R0_5 \~R0_4 \~R0_3 \~R0_2 \~R0_1 \~R0_0 \~R1_31 \~R1_30 \~R1_29 \~R1_28 \~R1_27 \~R1_26 \~R1_25 \~R1_24 \~R1_23 \~R1_22 \~R1_21 \~R1_20 \~R1_19 \~R1_18 \~R1_17 \~R1_16 \~R1_15 \~R1_14 \~R1_13 \~R1_12 \~R1_11 \~R1_10 \~R1_9 \~R1_8 \~R1_7 \~R1_6 \~R1_5 \~R1_4 \~R1_3 \~R1_2 \~R1_1 \~R1_0 \~W0_31 \~W0_30 \~W0_29 \~W0_28 \~W0_27 \~W0_26 \~W0_25 \~W0_24 \~W0_23 \~W0_22 \~W0_21 \~W0_20 \~W0_19 \~W0_18 \~W0_17 \~W0_16 \~W0_15 \~W0_14 \~W0_13 \~W0_12 \~W0_11 \~W0_10 \~W0_9 \~W0_8 \~W0_7 \~W0_6 \~W0_5 \~W0_4 \~W0_3 \~W0_2 \~W0_1 \~W0_0 \~W1_31 \~W1_30 \~W1_29 \~W1_28 \~W1_27 \~W1_26 \~W1_25 \~W1_24 \~W1_23 \~W1_22 \~W1_21 \~W1_20 \~W1_19 \~W1_18 \~W1_17 \~W1_16 \~W1_15 \~W1_14 \~W1_13 \~W1_12 \~W1_11 \~W1_10 \~W1_9 \~W1_8 \~W1_7 \~W1_6 \~W1_5 \~W1_4 \~W1_3 \~W1_2 \~W1_1 \~W1_0
    I255 (JR_31 JW_31 \~R0_3 \~R0_2 \~R0_1 \~R0_0 \~R1_3 \~R1_2 \~R1_1 \~R1_0 \~W0_3 \~W0_2 \~W0_1 \~W0_0 \~W1_3 \~W1_2 \~W1_1 \~W1_0) _sub140
    I247 (JR_30 JW_30 \~R0_3 \~R0_2 \~R0_1 \~R0_0 \~R1_3 \~R1_2 \~R1_1 \~R1_0 \~W0_3 \~W0_2 \~W0_1 \~W0_0 \~W1_3 \~W1_2 \~W1_1 \~W1_0) _sub140
    I239 (JR_29 JW_29 \~R0_3 \~R0_2 \~R0_1 \~R0_0 \~R1_3 \~R1_2 \~R1_1 \~R1_0 \~W0_3 \~W0_2 \~W0_1 \~W0_0 \~W1_3 \~W1_2 \~W1_1 \~W1_0) _sub140
    I231 (JR_28 JW_28 \~R0_3 \~R0_2 \~R0_1 \~R0_0 \~R1_3 \~R1_2 \~R1_1 \~R1_0 \~W0_3 \~W0_2 \~W0_1 \~W0_0 \~W1_3 \~W1_2 \~W1_1 \~W1_0) _sub140
    I223 (JR_27 JW_27 \~R0_3 \~R0_2 \~R0_1 \~R0_0 \~R1_3 \~R1_2 \~R1_1 \~R1_0 \~W0_3 \~W0_2 \~W0_1 \~W0_0 \~W1_3 \~W1_2 \~W1_1 \~W1_0) _sub140
    I215 (JR_26 JW_26 \~R0_3 \~R0_2 \~R0_1 \~R0_0 \~R1_3 \~R1_2 \~R1_1 \~R1_0 \~W0_3 \~W0_2 \~W0_1 \~W0_0 \~W1_3 \~W1_2 \~W1_1 \~W1_0) _sub140
    I207 (JR_25 JW_25 \~R0_3 \~R0_2 \~R0_1 \~R0_0 \~R1_3 \~R1_2 \~R1_1 \~R1_0 \~W0_3 \~W0_2 \~W0_1 \~W0_0 \~W1_3 \~W1_2 \~W1_1 \~W1_0) _sub140
    I199 (JR_24 JW_24 \~R0_3 \~R0_2 \~R0_1 \~R0_0 \~R1_3 \~R1_2 \~R1_1 \~R1_0 \~W0_3 \~W0_2 \~W0_1 \~W0_0 \~W1_3 \~W1_2 \~W1_1 \~W1_0) _sub140
    I191 (JR_23 JW_23 \~R0_3 \~R0_2 \~R0_1 \~R0_0 \~R1_3 \~R1_2 \~R1_1 \~R1_0 \~W0_3 \~W0_2 \~W0_1 \~W0_0 \~W1_3 \~W1_2 \~W1_1 \~W1_0) _sub140
    I183 (JR_22 JW_22 \~R0_3 \~R0_2 \~R0_1 \~R0_0 \~R1_3 \~R1_2 \~R1_1 \~R1_0 \~W0_3 \~W0_2 \~W0_1 \~W0_0 \~W1_3 \~W1_2 \~W1_1 \~W1_0) _sub140
    I175 (JR_21 JW_21 \~R0_3 \~R0_2 \~R0_1 \~R0_0 \~R1_3 \~R1_2 \~R1_1 \~R1_0 \~W0_3 \~W0_2 \~W0_1 \~W0_0 \~W1_3 \~W1_2 \~W1_1 \~W1_0) _sub140
    I167 (JR_20 JW_20 \~R0_3 \~R0_2 \~R0_1 \~R0_0 \~R1_3 \~R1_2 \~R1_1 \~R1_0 \~W0_3 \~W0_2 \~W0_1 \~W0_0 \~W1_3 \~W1_2 \~W1_1 \~W1_0) _sub140
    I159 (JR_19 JW_19 \~R0_3 \~R0_2 \~R0_1 \~R0_0 \~R1_3 \~R1_2 \~R1_1 \~R1_0 \~W0_3 \~W0_2 \~W0_1 \~W0_0 \~W1_3 \~W1_2 \~W1_1 \~W1_0) _sub140
    I151 (JR_18 JW_18 \~R0_3 \~R0_2 \~R0_1 \~R0_0 \~R1_3 \~R1_2 \~R1_1 \~R1_0 \~W0_3 \~W0_2 \~W0_1 \~W0_0 \~W1_3 \~W1_2 \~W1_1 \~W1_0) _sub140
    I143 (JR_17 JW_17 \~R0_3 \~R0_2 \~R0_1 \~R0_0 \~R1_3 \~R1_2 \~R1_1 \~R1_0 \~W0_3 \~W0_2 \~W0_1 \~W0_0 \~W1_3 \~W1_2 \~W1_1 \~W1_0) _sub140
    I135 (JR_16 JW_16 \~R0_3 \~R0_2 \~R0_1 \~R0_0 \~R1_3 \~R1_2 \~R1_1 \~R1_0 \~W0_3 \~W0_2 \~W0_1 \~W0_0 \~W1_3 \~W1_2 \~W1_1 \~W1_0) _sub140
    I127 (JR_15 JW_15 \~R0_3 \~R0_2 \~R0_1 \~R0_0 \~R1_3 \~R1_2 \~R1_1 \~R1_0 \~W0_3 \~W0_2 \~W0_1 \~W0_0 \~W1_3 \~W1_2 \~W1_1 \~W1_0) _sub140
    I119 (JR_14 JW_14 \~R0_3 \~R0_2 \~R0_1 \~R0_0 \~R1_3 \~R1_2 \~R1_1 \~R1_0 \~W0_3 \~W0_2 \~W0_1 \~W0_0 \~W1_3 \~W1_2 \~W1_1 \~W1_0) _sub140
    I111 (JR_13 JW_13 \~R0_3 \~R0_2 \~R0_1 \~R0_0 \~R1_3 \~R1_2 \~R1_1 \~R1_0 \~W0_3 \~W0_2 \~W0_1 \~W0_0 \~W1_3 \~W1_2 \~W1_1 \~W1_0) _sub140
    I103 (JR_12 JW_12 \~R0_3 \~R0_2 \~R0_1 \~R0_0 \~R1_3 \~R1_2 \~R1_1 \~R1_0 \~W0_3 \~W0_2 \~W0_1 \~W0_0 \~W1_3 \~W1_2 \~W1_1 \~W1_0) _sub140
    I95 (JR_11 JW_11 \~R0_3 \~R0_2 \~R0_1 \~R0_0 \~R1_3 \~R1_2 \~R1_1 \~R1_0 \~W0_3 \~W0_2 \~W0_1 \~W0_0 \~W1_3 \~W1_2 \~W1_1 \~W1_0) _sub140
    I87 (JR_10 JW_10 \~R0_3 \~R0_2 \~R0_1 \~R0_0 \~R1_3 \~R1_2 \~R1_1 \~R1_0 \~W0_3 \~W0_2 \~W0_1 \~W0_0 \~W1_3 \~W1_2 \~W1_1 \~W1_0) _sub140
    I79 (JR_9 JW_9 \~R0_3 \~R0_2 \~R0_1 \~R0_0 \~R1_3 \~R1_2 \~R1_1 \~R1_0 \~W0_3 \~W0_2 \~W0_1 \~W0_0 \~W1_3 \~W1_2 \~W1_1 \~W1_0) _sub140
    I71 (JR_8 JW_8 \~R0_3 \~R0_2 \~R0_1 \~R0_0 \~R1_3 \~R1_2 \~R1_1 \~R1_0 \~W0_3 \~W0_2 \~W0_1 \~W0_0 \~W1_3 \~W1_2 \~W1_1 \~W1_0) _sub140
    I63 (JR_7 JW_7 \~R0_3 \~R0_2 \~R0_1 \~R0_0 \~R1_3 \~R1_2 \~R1_1 \~R1_0 \~W0_3 \~W0_2 \~W0_1 \~W0_0 \~W1_3 \~W1_2 \~W1_1 \~W1_0) _sub140
    I55 (JR_6 JW_6 \~R0_3 \~R0_2 \~R0_1 \~R0_0 \~R1_3 \~R1_2 \~R1_1 \~R1_0 \~W0_3 \~W0_2 \~W0_1 \~W0_0 \~W1_3 \~W1_2 \~W1_1 \~W1_0) _sub140
    I47 (JR_5 JW_5 \~R0_3 \~R0_2 \~R0_1 \~R0_0 \~R1_3 \~R1_2 \~R1_1 \~R1_0 \~W0_3 \~W0_2 \~W0_1 \~W0_0 \~W1_3 \~W1_2 \~W1_1 \~W1_0) _sub140
    I39 (JR_4 JW_4 \~R0_3 \~R0_2 \~R0_1 \~R0_0 \~R1_3 \~R1_2 \~R1_1 \~R1_0 \~W0_3 \~W0_2 \~W0_1 \~W0_0 \~W1_3 \~W1_2 \~W1_1 \~W1_0) _sub140
    I31 (JR_3 JW_3 \~R0_3 \~R0_2 \~R0_1 \~R0_0 \~R1_3 \~R1_2 \~R1_1 \~R1_0 \~W0_3 \~W0_2 \~W0_1 \~W0_0 \~W1_3 \~W1_2 \~W1_1 \~W1_0) _sub140
    I23 (JR_2 JW_2 \~R0_3 \~R0_2 \~R0_1 \~R0_0 \~R1_3 \~R1_2 \~R1_1 \~R1_0 \~W0_3 \~W0_2 \~W0_1 \~W0_0 \~W1_3 \~W1_2 \~W1_1 \~W1_0) _sub140
    I15 (JR_1 JW_1 \~R0_3 \~R0_2 \~R0_1 \~R0_0 \~R1_3 \~R1_2 \~R1_1 \~R1_0 \~W0_3 \~W0_2 \~W0_1 \~W0_0 \~W1_3 \~W1_2 \~W1_1 \~W1_0) _sub140
    I254 (JR_31 JW_31 \~R0_7 \~R0_6 \~R0_5 \~R0_4 \~R1_7 \~R1_6 \~R1_5 \~R1_4 \~W0_7 \~W0_6 \~W0_5 \~W0_4 \~W1_7 \~W1_6 \~W1_5 \~W1_4) _sub140
    I246 (JR_30 JW_30 \~R0_7 \~R0_6 \~R0_5 \~R0_4 \~R1_7 \~R1_6 \~R1_5 \~R1_4 \~W0_7 \~W0_6 \~W0_5 \~W0_4 \~W1_7 \~W1_6 \~W1_5 \~W1_4) _sub140
    I238 (JR_29 JW_29 \~R0_7 \~R0_6 \~R0_5 \~R0_4 \~R1_7 \~R1_6 \~R1_5 \~R1_4 \~W0_7 \~W0_6 \~W0_5 \~W0_4 \~W1_7 \~W1_6 \~W1_5 \~W1_4) _sub140
    I230 (JR_28 JW_28 \~R0_7 \~R0_6 \~R0_5 \~R0_4 \~R1_7 \~R1_6 \~R1_5 \~R1_4 \~W0_7 \~W0_6 \~W0_5 \~W0_4 \~W1_7 \~W1_6 \~W1_5 \~W1_4) _sub140
    I222 (JR_27 JW_27 \~R0_7 \~R0_6 \~R0_5 \~R0_4 \~R1_7 \~R1_6 \~R1_5 \~R1_4 \~W0_7 \~W0_6 \~W0_5 \~W0_4 \~W1_7 \~W1_6 \~W1_5 \~W1_4) _sub140
    I214 (JR_26 JW_26 \~R0_7 \~R0_6 \~R0_5 \~R0_4 \~R1_7 \~R1_6 \~R1_5 \~R1_4 \~W0_7 \~W0_6 \~W0_5 \~W0_4 \~W1_7 \~W1_6 \~W1_5 \~W1_4) _sub140
    I206 (JR_25 JW_25 \~R0_7 \~R0_6 \~R0_5 \~R0_4 \~R1_7 \~R1_6 \~R1_5 \~R1_4 \~W0_7 \~W0_6 \~W0_5 \~W0_4 \~W1_7 \~W1_6 \~W1_5 \~W1_4) _sub140
    I198 (JR_24 JW_24 \~R0_7 \~R0_6 \~R0_5 \~R0_4 \~R1_7 \~R1_6 \~R1_5 \~R1_4 \~W0_7 \~W0_6 \~W0_5 \~W0_4 \~W1_7 \~W1_6 \~W1_5 \~W1_4) _sub140
    I190 (JR_23 JW_23 \~R0_7 \~R0_6 \~R0_5 \~R0_4 \~R1_7 \~R1_6 \~R1_5 \~R1_4 \~W0_7 \~W0_6 \~W0_5 \~W0_4 \~W1_7 \~W1_6 \~W1_5 \~W1_4) _sub140
    I182 (JR_22 JW_22 \~R0_7 \~R0_6 \~R0_5 \~R0_4 \~R1_7 \~R1_6 \~R1_5 \~R1_4 \~W0_7 \~W0_6 \~W0_5 \~W0_4 \~W1_7 \~W1_6 \~W1_5 \~W1_4) _sub140
    I174 (JR_21 JW_21 \~R0_7 \~R0_6 \~R0_5 \~R0_4 \~R1_7 \~R1_6 \~R1_5 \~R1_4 \~W0_7 \~W0_6 \~W0_5 \~W0_4 \~W1_7 \~W1_6 \~W1_5 \~W1_4) _sub140
    I166 (JR_20 JW_20 \~R0_7 \~R0_6 \~R0_5 \~R0_4 \~R1_7 \~R1_6 \~R1_5 \~R1_4 \~W0_7 \~W0_6 \~W0_5 \~W0_4 \~W1_7 \~W1_6 \~W1_5 \~W1_4) _sub140
    I158 (JR_19 JW_19 \~R0_7 \~R0_6 \~R0_5 \~R0_4 \~R1_7 \~R1_6 \~R1_5 \~R1_4 \~W0_7 \~W0_6 \~W0_5 \~W0_4 \~W1_7 \~W1_6 \~W1_5 \~W1_4) _sub140
    I150 (JR_18 JW_18 \~R0_7 \~R0_6 \~R0_5 \~R0_4 \~R1_7 \~R1_6 \~R1_5 \~R1_4 \~W0_7 \~W0_6 \~W0_5 \~W0_4 \~W1_7 \~W1_6 \~W1_5 \~W1_4) _sub140
    I142 (JR_17 JW_17 \~R0_7 \~R0_6 \~R0_5 \~R0_4 \~R1_7 \~R1_6 \~R1_5 \~R1_4 \~W0_7 \~W0_6 \~W0_5 \~W0_4 \~W1_7 \~W1_6 \~W1_5 \~W1_4) _sub140
    I134 (JR_16 JW_16 \~R0_7 \~R0_6 \~R0_5 \~R0_4 \~R1_7 \~R1_6 \~R1_5 \~R1_4 \~W0_7 \~W0_6 \~W0_5 \~W0_4 \~W1_7 \~W1_6 \~W1_5 \~W1_4) _sub140
    I126 (JR_15 JW_15 \~R0_7 \~R0_6 \~R0_5 \~R0_4 \~R1_7 \~R1_6 \~R1_5 \~R1_4 \~W0_7 \~W0_6 \~W0_5 \~W0_4 \~W1_7 \~W1_6 \~W1_5 \~W1_4) _sub140
    I118 (JR_14 JW_14 \~R0_7 \~R0_6 \~R0_5 \~R0_4 \~R1_7 \~R1_6 \~R1_5 \~R1_4 \~W0_7 \~W0_6 \~W0_5 \~W0_4 \~W1_7 \~W1_6 \~W1_5 \~W1_4) _sub140
    I110 (JR_13 JW_13 \~R0_7 \~R0_6 \~R0_5 \~R0_4 \~R1_7 \~R1_6 \~R1_5 \~R1_4 \~W0_7 \~W0_6 \~W0_5 \~W0_4 \~W1_7 \~W1_6 \~W1_5 \~W1_4) _sub140
    I102 (JR_12 JW_12 \~R0_7 \~R0_6 \~R0_5 \~R0_4 \~R1_7 \~R1_6 \~R1_5 \~R1_4 \~W0_7 \~W0_6 \~W0_5 \~W0_4 \~W1_7 \~W1_6 \~W1_5 \~W1_4) _sub140
    I94 (JR_11 JW_11 \~R0_7 \~R0_6 \~R0_5 \~R0_4 \~R1_7 \~R1_6 \~R1_5 \~R1_4 \~W0_7 \~W0_6 \~W0_5 \~W0_4 \~W1_7 \~W1_6 \~W1_5 \~W1_4) _sub140
    I86 (JR_10 JW_10 \~R0_7 \~R0_6 \~R0_5 \~R0_4 \~R1_7 \~R1_6 \~R1_5 \~R1_4 \~W0_7 \~W0_6 \~W0_5 \~W0_4 \~W1_7 \~W1_6 \~W1_5 \~W1_4) _sub140
    I78 (JR_9 JW_9 \~R0_7 \~R0_6 \~R0_5 \~R0_4 \~R1_7 \~R1_6 \~R1_5 \~R1_4 \~W0_7 \~W0_6 \~W0_5 \~W0_4 \~W1_7 \~W1_6 \~W1_5 \~W1_4) _sub140
    I70 (JR_8 JW_8 \~R0_7 \~R0_6 \~R0_5 \~R0_4 \~R1_7 \~R1_6 \~R1_5 \~R1_4 \~W0_7 \~W0_6 \~W0_5 \~W0_4 \~W1_7 \~W1_6 \~W1_5 \~W1_4) _sub140
    I62 (JR_7 JW_7 \~R0_7 \~R0_6 \~R0_5 \~R0_4 \~R1_7 \~R1_6 \~R1_5 \~R1_4 \~W0_7 \~W0_6 \~W0_5 \~W0_4 \~W1_7 \~W1_6 \~W1_5 \~W1_4) _sub140
    I54 (JR_6 JW_6 \~R0_7 \~R0_6 \~R0_5 \~R0_4 \~R1_7 \~R1_6 \~R1_5 \~R1_4 \~W0_7 \~W0_6 \~W0_5 \~W0_4 \~W1_7 \~W1_6 \~W1_5 \~W1_4) _sub140
    I46 (JR_5 JW_5 \~R0_7 \~R0_6 \~R0_5 \~R0_4 \~R1_7 \~R1_6 \~R1_5 \~R1_4 \~W0_7 \~W0_6 \~W0_5 \~W0_4 \~W1_7 \~W1_6 \~W1_5 \~W1_4) _sub140
    I38 (JR_4 JW_4 \~R0_7 \~R0_6 \~R0_5 \~R0_4 \~R1_7 \~R1_6 \~R1_5 \~R1_4 \~W0_7 \~W0_6 \~W0_5 \~W0_4 \~W1_7 \~W1_6 \~W1_5 \~W1_4) _sub140
    I30 (JR_3 JW_3 \~R0_7 \~R0_6 \~R0_5 \~R0_4 \~R1_7 \~R1_6 \~R1_5 \~R1_4 \~W0_7 \~W0_6 \~W0_5 \~W0_4 \~W1_7 \~W1_6 \~W1_5 \~W1_4) _sub140
    I22 (JR_2 JW_2 \~R0_7 \~R0_6 \~R0_5 \~R0_4 \~R1_7 \~R1_6 \~R1_5 \~R1_4 \~W0_7 \~W0_6 \~W0_5 \~W0_4 \~W1_7 \~W1_6 \~W1_5 \~W1_4) _sub140
    I14 (JR_1 JW_1 \~R0_7 \~R0_6 \~R0_5 \~R0_4 \~R1_7 \~R1_6 \~R1_5 \~R1_4 \~W0_7 \~W0_6 \~W0_5 \~W0_4 \~W1_7 \~W1_6 \~W1_5 \~W1_4) _sub140
    I253 (JR_31 JW_31 \~R0_11 \~R0_10 \~R0_9 \~R0_8 \~R1_11 \~R1_10 \~R1_9 \~R1_8 \~W0_11 \~W0_10 \~W0_9 \~W0_8 \~W1_11 \~W1_10 \~W1_9 \~W1_8) _sub140
    I245 (JR_30 JW_30 \~R0_11 \~R0_10 \~R0_9 \~R0_8 \~R1_11 \~R1_10 \~R1_9 \~R1_8 \~W0_11 \~W0_10 \~W0_9 \~W0_8 \~W1_11 \~W1_10 \~W1_9 \~W1_8) _sub140
    I237 (JR_29 JW_29 \~R0_11 \~R0_10 \~R0_9 \~R0_8 \~R1_11 \~R1_10 \~R1_9 \~R1_8 \~W0_11 \~W0_10 \~W0_9 \~W0_8 \~W1_11 \~W1_10 \~W1_9 \~W1_8) _sub140
    I229 (JR_28 JW_28 \~R0_11 \~R0_10 \~R0_9 \~R0_8 \~R1_11 \~R1_10 \~R1_9 \~R1_8 \~W0_11 \~W0_10 \~W0_9 \~W0_8 \~W1_11 \~W1_10 \~W1_9 \~W1_8) _sub140
    I221 (JR_27 JW_27 \~R0_11 \~R0_10 \~R0_9 \~R0_8 \~R1_11 \~R1_10 \~R1_9 \~R1_8 \~W0_11 \~W0_10 \~W0_9 \~W0_8 \~W1_11 \~W1_10 \~W1_9 \~W1_8) _sub140
    I213 (JR_26 JW_26 \~R0_11 \~R0_10 \~R0_9 \~R0_8 \~R1_11 \~R1_10 \~R1_9 \~R1_8 \~W0_11 \~W0_10 \~W0_9 \~W0_8 \~W1_11 \~W1_10 \~W1_9 \~W1_8) _sub140
    I205 (JR_25 JW_25 \~R0_11 \~R0_10 \~R0_9 \~R0_8 \~R1_11 \~R1_10 \~R1_9 \~R1_8 \~W0_11 \~W0_10 \~W0_9 \~W0_8 \~W1_11 \~W1_10 \~W1_9 \~W1_8) _sub140
    I197 (JR_24 JW_24 \~R0_11 \~R0_10 \~R0_9 \~R0_8 \~R1_11 \~R1_10 \~R1_9 \~R1_8 \~W0_11 \~W0_10 \~W0_9 \~W0_8 \~W1_11 \~W1_10 \~W1_9 \~W1_8) _sub140
    I189 (JR_23 JW_23 \~R0_11 \~R0_10 \~R0_9 \~R0_8 \~R1_11 \~R1_10 \~R1_9 \~R1_8 \~W0_11 \~W0_10 \~W0_9 \~W0_8 \~W1_11 \~W1_10 \~W1_9 \~W1_8) _sub140
    I181 (JR_22 JW_22 \~R0_11 \~R0_10 \~R0_9 \~R0_8 \~R1_11 \~R1_10 \~R1_9 \~R1_8 \~W0_11 \~W0_10 \~W0_9 \~W0_8 \~W1_11 \~W1_10 \~W1_9 \~W1_8) _sub140
    I173 (JR_21 JW_21 \~R0_11 \~R0_10 \~R0_9 \~R0_8 \~R1_11 \~R1_10 \~R1_9 \~R1_8 \~W0_11 \~W0_10 \~W0_9 \~W0_8 \~W1_11 \~W1_10 \~W1_9 \~W1_8) _sub140
    I165 (JR_20 JW_20 \~R0_11 \~R0_10 \~R0_9 \~R0_8 \~R1_11 \~R1_10 \~R1_9 \~R1_8 \~W0_11 \~W0_10 \~W0_9 \~W0_8 \~W1_11 \~W1_10 \~W1_9 \~W1_8) _sub140
    I157 (JR_19 JW_19 \~R0_11 \~R0_10 \~R0_9 \~R0_8 \~R1_11 \~R1_10 \~R1_9 \~R1_8 \~W0_11 \~W0_10 \~W0_9 \~W0_8 \~W1_11 \~W1_10 \~W1_9 \~W1_8) _sub140
    I149 (JR_18 JW_18 \~R0_11 \~R0_10 \~R0_9 \~R0_8 \~R1_11 \~R1_10 \~R1_9 \~R1_8 \~W0_11 \~W0_10 \~W0_9 \~W0_8 \~W1_11 \~W1_10 \~W1_9 \~W1_8) _sub140
    I141 (JR_17 JW_17 \~R0_11 \~R0_10 \~R0_9 \~R0_8 \~R1_11 \~R1_10 \~R1_9 \~R1_8 \~W0_11 \~W0_10 \~W0_9 \~W0_8 \~W1_11 \~W1_10 \~W1_9 \~W1_8) _sub140
    I133 (JR_16 JW_16 \~R0_11 \~R0_10 \~R0_9 \~R0_8 \~R1_11 \~R1_10 \~R1_9 \~R1_8 \~W0_11 \~W0_10 \~W0_9 \~W0_8 \~W1_11 \~W1_10 \~W1_9 \~W1_8) _sub140
    I125 (JR_15 JW_15 \~R0_11 \~R0_10 \~R0_9 \~R0_8 \~R1_11 \~R1_10 \~R1_9 \~R1_8 \~W0_11 \~W0_10 \~W0_9 \~W0_8 \~W1_11 \~W1_10 \~W1_9 \~W1_8) _sub140
    I117 (JR_14 JW_14 \~R0_11 \~R0_10 \~R0_9 \~R0_8 \~R1_11 \~R1_10 \~R1_9 \~R1_8 \~W0_11 \~W0_10 \~W0_9 \~W0_8 \~W1_11 \~W1_10 \~W1_9 \~W1_8) _sub140
    I109 (JR_13 JW_13 \~R0_11 \~R0_10 \~R0_9 \~R0_8 \~R1_11 \~R1_10 \~R1_9 \~R1_8 \~W0_11 \~W0_10 \~W0_9 \~W0_8 \~W1_11 \~W1_10 \~W1_9 \~W1_8) _sub140
    I101 (JR_12 JW_12 \~R0_11 \~R0_10 \~R0_9 \~R0_8 \~R1_11 \~R1_10 \~R1_9 \~R1_8 \~W0_11 \~W0_10 \~W0_9 \~W0_8 \~W1_11 \~W1_10 \~W1_9 \~W1_8) _sub140
    I93 (JR_11 JW_11 \~R0_11 \~R0_10 \~R0_9 \~R0_8 \~R1_11 \~R1_10 \~R1_9 \~R1_8 \~W0_11 \~W0_10 \~W0_9 \~W0_8 \~W1_11 \~W1_10 \~W1_9 \~W1_8) _sub140
    I85 (JR_10 JW_10 \~R0_11 \~R0_10 \~R0_9 \~R0_8 \~R1_11 \~R1_10 \~R1_9 \~R1_8 \~W0_11 \~W0_10 \~W0_9 \~W0_8 \~W1_11 \~W1_10 \~W1_9 \~W1_8) _sub140
    I77 (JR_9 JW_9 \~R0_11 \~R0_10 \~R0_9 \~R0_8 \~R1_11 \~R1_10 \~R1_9 \~R1_8 \~W0_11 \~W0_10 \~W0_9 \~W0_8 \~W1_11 \~W1_10 \~W1_9 \~W1_8) _sub140
    I69 (JR_8 JW_8 \~R0_11 \~R0_10 \~R0_9 \~R0_8 \~R1_11 \~R1_10 \~R1_9 \~R1_8 \~W0_11 \~W0_10 \~W0_9 \~W0_8 \~W1_11 \~W1_10 \~W1_9 \~W1_8) _sub140
    I61 (JR_7 JW_7 \~R0_11 \~R0_10 \~R0_9 \~R0_8 \~R1_11 \~R1_10 \~R1_9 \~R1_8 \~W0_11 \~W0_10 \~W0_9 \~W0_8 \~W1_11 \~W1_10 \~W1_9 \~W1_8) _sub140
    I53 (JR_6 JW_6 \~R0_11 \~R0_10 \~R0_9 \~R0_8 \~R1_11 \~R1_10 \~R1_9 \~R1_8 \~W0_11 \~W0_10 \~W0_9 \~W0_8 \~W1_11 \~W1_10 \~W1_9 \~W1_8) _sub140
    I45 (JR_5 JW_5 \~R0_11 \~R0_10 \~R0_9 \~R0_8 \~R1_11 \~R1_10 \~R1_9 \~R1_8 \~W0_11 \~W0_10 \~W0_9 \~W0_8 \~W1_11 \~W1_10 \~W1_9 \~W1_8) _sub140
    I37 (JR_4 JW_4 \~R0_11 \~R0_10 \~R0_9 \~R0_8 \~R1_11 \~R1_10 \~R1_9 \~R1_8 \~W0_11 \~W0_10 \~W0_9 \~W0_8 \~W1_11 \~W1_10 \~W1_9 \~W1_8) _sub140
    I29 (JR_3 JW_3 \~R0_11 \~R0_10 \~R0_9 \~R0_8 \~R1_11 \~R1_10 \~R1_9 \~R1_8 \~W0_11 \~W0_10 \~W0_9 \~W0_8 \~W1_11 \~W1_10 \~W1_9 \~W1_8) _sub140
    I21 (JR_2 JW_2 \~R0_11 \~R0_10 \~R0_9 \~R0_8 \~R1_11 \~R1_10 \~R1_9 \~R1_8 \~W0_11 \~W0_10 \~W0_9 \~W0_8 \~W1_11 \~W1_10 \~W1_9 \~W1_8) _sub140
    I13 (JR_1 JW_1 \~R0_11 \~R0_10 \~R0_9 \~R0_8 \~R1_11 \~R1_10 \~R1_9 \~R1_8 \~W0_11 \~W0_10 \~W0_9 \~W0_8 \~W1_11 \~W1_10 \~W1_9 \~W1_8) _sub140
    I252 (JR_31 JW_31 \~R0_15 \~R0_14 \~R0_13 \~R0_12 \~R1_15 \~R1_14 \~R1_13 \~R1_12 \~W0_15 \~W0_14 \~W0_13 \~W0_12 \~W1_15 \~W1_14 \~W1_13 \~W1_12) _sub140
    I244 (JR_30 JW_30 \~R0_15 \~R0_14 \~R0_13 \~R0_12 \~R1_15 \~R1_14 \~R1_13 \~R1_12 \~W0_15 \~W0_14 \~W0_13 \~W0_12 \~W1_15 \~W1_14 \~W1_13 \~W1_12) _sub140
    I236 (JR_29 JW_29 \~R0_15 \~R0_14 \~R0_13 \~R0_12 \~R1_15 \~R1_14 \~R1_13 \~R1_12 \~W0_15 \~W0_14 \~W0_13 \~W0_12 \~W1_15 \~W1_14 \~W1_13 \~W1_12) _sub140
    I228 (JR_28 JW_28 \~R0_15 \~R0_14 \~R0_13 \~R0_12 \~R1_15 \~R1_14 \~R1_13 \~R1_12 \~W0_15 \~W0_14 \~W0_13 \~W0_12 \~W1_15 \~W1_14 \~W1_13 \~W1_12) _sub140
    I220 (JR_27 JW_27 \~R0_15 \~R0_14 \~R0_13 \~R0_12 \~R1_15 \~R1_14 \~R1_13 \~R1_12 \~W0_15 \~W0_14 \~W0_13 \~W0_12 \~W1_15 \~W1_14 \~W1_13 \~W1_12) _sub140
    I212 (JR_26 JW_26 \~R0_15 \~R0_14 \~R0_13 \~R0_12 \~R1_15 \~R1_14 \~R1_13 \~R1_12 \~W0_15 \~W0_14 \~W0_13 \~W0_12 \~W1_15 \~W1_14 \~W1_13 \~W1_12) _sub140
    I204 (JR_25 JW_25 \~R0_15 \~R0_14 \~R0_13 \~R0_12 \~R1_15 \~R1_14 \~R1_13 \~R1_12 \~W0_15 \~W0_14 \~W0_13 \~W0_12 \~W1_15 \~W1_14 \~W1_13 \~W1_12) _sub140
    I196 (JR_24 JW_24 \~R0_15 \~R0_14 \~R0_13 \~R0_12 \~R1_15 \~R1_14 \~R1_13 \~R1_12 \~W0_15 \~W0_14 \~W0_13 \~W0_12 \~W1_15 \~W1_14 \~W1_13 \~W1_12) _sub140
    I188 (JR_23 JW_23 \~R0_15 \~R0_14 \~R0_13 \~R0_12 \~R1_15 \~R1_14 \~R1_13 \~R1_12 \~W0_15 \~W0_14 \~W0_13 \~W0_12 \~W1_15 \~W1_14 \~W1_13 \~W1_12) _sub140
    I180 (JR_22 JW_22 \~R0_15 \~R0_14 \~R0_13 \~R0_12 \~R1_15 \~R1_14 \~R1_13 \~R1_12 \~W0_15 \~W0_14 \~W0_13 \~W0_12 \~W1_15 \~W1_14 \~W1_13 \~W1_12) _sub140
    I172 (JR_21 JW_21 \~R0_15 \~R0_14 \~R0_13 \~R0_12 \~R1_15 \~R1_14 \~R1_13 \~R1_12 \~W0_15 \~W0_14 \~W0_13 \~W0_12 \~W1_15 \~W1_14 \~W1_13 \~W1_12) _sub140
    I164 (JR_20 JW_20 \~R0_15 \~R0_14 \~R0_13 \~R0_12 \~R1_15 \~R1_14 \~R1_13 \~R1_12 \~W0_15 \~W0_14 \~W0_13 \~W0_12 \~W1_15 \~W1_14 \~W1_13 \~W1_12) _sub140
    I156 (JR_19 JW_19 \~R0_15 \~R0_14 \~R0_13 \~R0_12 \~R1_15 \~R1_14 \~R1_13 \~R1_12 \~W0_15 \~W0_14 \~W0_13 \~W0_12 \~W1_15 \~W1_14 \~W1_13 \~W1_12) _sub140
    I148 (JR_18 JW_18 \~R0_15 \~R0_14 \~R0_13 \~R0_12 \~R1_15 \~R1_14 \~R1_13 \~R1_12 \~W0_15 \~W0_14 \~W0_13 \~W0_12 \~W1_15 \~W1_14 \~W1_13 \~W1_12) _sub140
    I140 (JR_17 JW_17 \~R0_15 \~R0_14 \~R0_13 \~R0_12 \~R1_15 \~R1_14 \~R1_13 \~R1_12 \~W0_15 \~W0_14 \~W0_13 \~W0_12 \~W1_15 \~W1_14 \~W1_13 \~W1_12) _sub140
    I132 (JR_16 JW_16 \~R0_15 \~R0_14 \~R0_13 \~R0_12 \~R1_15 \~R1_14 \~R1_13 \~R1_12 \~W0_15 \~W0_14 \~W0_13 \~W0_12 \~W1_15 \~W1_14 \~W1_13 \~W1_12) _sub140
    I124 (JR_15 JW_15 \~R0_15 \~R0_14 \~R0_13 \~R0_12 \~R1_15 \~R1_14 \~R1_13 \~R1_12 \~W0_15 \~W0_14 \~W0_13 \~W0_12 \~W1_15 \~W1_14 \~W1_13 \~W1_12) _sub140
    I116 (JR_14 JW_14 \~R0_15 \~R0_14 \~R0_13 \~R0_12 \~R1_15 \~R1_14 \~R1_13 \~R1_12 \~W0_15 \~W0_14 \~W0_13 \~W0_12 \~W1_15 \~W1_14 \~W1_13 \~W1_12) _sub140
    I108 (JR_13 JW_13 \~R0_15 \~R0_14 \~R0_13 \~R0_12 \~R1_15 \~R1_14 \~R1_13 \~R1_12 \~W0_15 \~W0_14 \~W0_13 \~W0_12 \~W1_15 \~W1_14 \~W1_13 \~W1_12) _sub140
    I100 (JR_12 JW_12 \~R0_15 \~R0_14 \~R0_13 \~R0_12 \~R1_15 \~R1_14 \~R1_13 \~R1_12 \~W0_15 \~W0_14 \~W0_13 \~W0_12 \~W1_15 \~W1_14 \~W1_13 \~W1_12) _sub140
    I92 (JR_11 JW_11 \~R0_15 \~R0_14 \~R0_13 \~R0_12 \~R1_15 \~R1_14 \~R1_13 \~R1_12 \~W0_15 \~W0_14 \~W0_13 \~W0_12 \~W1_15 \~W1_14 \~W1_13 \~W1_12) _sub140
    I84 (JR_10 JW_10 \~R0_15 \~R0_14 \~R0_13 \~R0_12 \~R1_15 \~R1_14 \~R1_13 \~R1_12 \~W0_15 \~W0_14 \~W0_13 \~W0_12 \~W1_15 \~W1_14 \~W1_13 \~W1_12) _sub140
    I76 (JR_9 JW_9 \~R0_15 \~R0_14 \~R0_13 \~R0_12 \~R1_15 \~R1_14 \~R1_13 \~R1_12 \~W0_15 \~W0_14 \~W0_13 \~W0_12 \~W1_15 \~W1_14 \~W1_13 \~W1_12) _sub140
    I68 (JR_8 JW_8 \~R0_15 \~R0_14 \~R0_13 \~R0_12 \~R1_15 \~R1_14 \~R1_13 \~R1_12 \~W0_15 \~W0_14 \~W0_13 \~W0_12 \~W1_15 \~W1_14 \~W1_13 \~W1_12) _sub140
    I60 (JR_7 JW_7 \~R0_15 \~R0_14 \~R0_13 \~R0_12 \~R1_15 \~R1_14 \~R1_13 \~R1_12 \~W0_15 \~W0_14 \~W0_13 \~W0_12 \~W1_15 \~W1_14 \~W1_13 \~W1_12) _sub140
    I52 (JR_6 JW_6 \~R0_15 \~R0_14 \~R0_13 \~R0_12 \~R1_15 \~R1_14 \~R1_13 \~R1_12 \~W0_15 \~W0_14 \~W0_13 \~W0_12 \~W1_15 \~W1_14 \~W1_13 \~W1_12) _sub140
    I44 (JR_5 JW_5 \~R0_15 \~R0_14 \~R0_13 \~R0_12 \~R1_15 \~R1_14 \~R1_13 \~R1_12 \~W0_15 \~W0_14 \~W0_13 \~W0_12 \~W1_15 \~W1_14 \~W1_13 \~W1_12) _sub140
    I36 (JR_4 JW_4 \~R0_15 \~R0_14 \~R0_13 \~R0_12 \~R1_15 \~R1_14 \~R1_13 \~R1_12 \~W0_15 \~W0_14 \~W0_13 \~W0_12 \~W1_15 \~W1_14 \~W1_13 \~W1_12) _sub140
    I28 (JR_3 JW_3 \~R0_15 \~R0_14 \~R0_13 \~R0_12 \~R1_15 \~R1_14 \~R1_13 \~R1_12 \~W0_15 \~W0_14 \~W0_13 \~W0_12 \~W1_15 \~W1_14 \~W1_13 \~W1_12) _sub140
    I20 (JR_2 JW_2 \~R0_15 \~R0_14 \~R0_13 \~R0_12 \~R1_15 \~R1_14 \~R1_13 \~R1_12 \~W0_15 \~W0_14 \~W0_13 \~W0_12 \~W1_15 \~W1_14 \~W1_13 \~W1_12) _sub140
    I12 (JR_1 JW_1 \~R0_15 \~R0_14 \~R0_13 \~R0_12 \~R1_15 \~R1_14 \~R1_13 \~R1_12 \~W0_15 \~W0_14 \~W0_13 \~W0_12 \~W1_15 \~W1_14 \~W1_13 \~W1_12) _sub140
    I251 (JR_31 JW_31 \~R0_19 \~R0_18 \~R0_17 \~R0_16 \~R1_19 \~R1_18 \~R1_17 \~R1_16 \~W0_19 \~W0_18 \~W0_17 \~W0_16 \~W1_19 \~W1_18 \~W1_17 \~W1_16) _sub140
    I243 (JR_30 JW_30 \~R0_19 \~R0_18 \~R0_17 \~R0_16 \~R1_19 \~R1_18 \~R1_17 \~R1_16 \~W0_19 \~W0_18 \~W0_17 \~W0_16 \~W1_19 \~W1_18 \~W1_17 \~W1_16) _sub140
    I235 (JR_29 JW_29 \~R0_19 \~R0_18 \~R0_17 \~R0_16 \~R1_19 \~R1_18 \~R1_17 \~R1_16 \~W0_19 \~W0_18 \~W0_17 \~W0_16 \~W1_19 \~W1_18 \~W1_17 \~W1_16) _sub140
    I227 (JR_28 JW_28 \~R0_19 \~R0_18 \~R0_17 \~R0_16 \~R1_19 \~R1_18 \~R1_17 \~R1_16 \~W0_19 \~W0_18 \~W0_17 \~W0_16 \~W1_19 \~W1_18 \~W1_17 \~W1_16) _sub140
    I219 (JR_27 JW_27 \~R0_19 \~R0_18 \~R0_17 \~R0_16 \~R1_19 \~R1_18 \~R1_17 \~R1_16 \~W0_19 \~W0_18 \~W0_17 \~W0_16 \~W1_19 \~W1_18 \~W1_17 \~W1_16) _sub140
    I211 (JR_26 JW_26 \~R0_19 \~R0_18 \~R0_17 \~R0_16 \~R1_19 \~R1_18 \~R1_17 \~R1_16 \~W0_19 \~W0_18 \~W0_17 \~W0_16 \~W1_19 \~W1_18 \~W1_17 \~W1_16) _sub140
    I203 (JR_25 JW_25 \~R0_19 \~R0_18 \~R0_17 \~R0_16 \~R1_19 \~R1_18 \~R1_17 \~R1_16 \~W0_19 \~W0_18 \~W0_17 \~W0_16 \~W1_19 \~W1_18 \~W1_17 \~W1_16) _sub140
    I195 (JR_24 JW_24 \~R0_19 \~R0_18 \~R0_17 \~R0_16 \~R1_19 \~R1_18 \~R1_17 \~R1_16 \~W0_19 \~W0_18 \~W0_17 \~W0_16 \~W1_19 \~W1_18 \~W1_17 \~W1_16) _sub140
    I187 (JR_23 JW_23 \~R0_19 \~R0_18 \~R0_17 \~R0_16 \~R1_19 \~R1_18 \~R1_17 \~R1_16 \~W0_19 \~W0_18 \~W0_17 \~W0_16 \~W1_19 \~W1_18 \~W1_17 \~W1_16) _sub140
    I179 (JR_22 JW_22 \~R0_19 \~R0_18 \~R0_17 \~R0_16 \~R1_19 \~R1_18 \~R1_17 \~R1_16 \~W0_19 \~W0_18 \~W0_17 \~W0_16 \~W1_19 \~W1_18 \~W1_17 \~W1_16) _sub140
    I171 (JR_21 JW_21 \~R0_19 \~R0_18 \~R0_17 \~R0_16 \~R1_19 \~R1_18 \~R1_17 \~R1_16 \~W0_19 \~W0_18 \~W0_17 \~W0_16 \~W1_19 \~W1_18 \~W1_17 \~W1_16) _sub140
    I163 (JR_20 JW_20 \~R0_19 \~R0_18 \~R0_17 \~R0_16 \~R1_19 \~R1_18 \~R1_17 \~R1_16 \~W0_19 \~W0_18 \~W0_17 \~W0_16 \~W1_19 \~W1_18 \~W1_17 \~W1_16) _sub140
    I155 (JR_19 JW_19 \~R0_19 \~R0_18 \~R0_17 \~R0_16 \~R1_19 \~R1_18 \~R1_17 \~R1_16 \~W0_19 \~W0_18 \~W0_17 \~W0_16 \~W1_19 \~W1_18 \~W1_17 \~W1_16) _sub140
    I147 (JR_18 JW_18 \~R0_19 \~R0_18 \~R0_17 \~R0_16 \~R1_19 \~R1_18 \~R1_17 \~R1_16 \~W0_19 \~W0_18 \~W0_17 \~W0_16 \~W1_19 \~W1_18 \~W1_17 \~W1_16) _sub140
    I139 (JR_17 JW_17 \~R0_19 \~R0_18 \~R0_17 \~R0_16 \~R1_19 \~R1_18 \~R1_17 \~R1_16 \~W0_19 \~W0_18 \~W0_17 \~W0_16 \~W1_19 \~W1_18 \~W1_17 \~W1_16) _sub140
    I131 (JR_16 JW_16 \~R0_19 \~R0_18 \~R0_17 \~R0_16 \~R1_19 \~R1_18 \~R1_17 \~R1_16 \~W0_19 \~W0_18 \~W0_17 \~W0_16 \~W1_19 \~W1_18 \~W1_17 \~W1_16) _sub140
    I123 (JR_15 JW_15 \~R0_19 \~R0_18 \~R0_17 \~R0_16 \~R1_19 \~R1_18 \~R1_17 \~R1_16 \~W0_19 \~W0_18 \~W0_17 \~W0_16 \~W1_19 \~W1_18 \~W1_17 \~W1_16) _sub140
    I115 (JR_14 JW_14 \~R0_19 \~R0_18 \~R0_17 \~R0_16 \~R1_19 \~R1_18 \~R1_17 \~R1_16 \~W0_19 \~W0_18 \~W0_17 \~W0_16 \~W1_19 \~W1_18 \~W1_17 \~W1_16) _sub140
    I107 (JR_13 JW_13 \~R0_19 \~R0_18 \~R0_17 \~R0_16 \~R1_19 \~R1_18 \~R1_17 \~R1_16 \~W0_19 \~W0_18 \~W0_17 \~W0_16 \~W1_19 \~W1_18 \~W1_17 \~W1_16) _sub140
    I99 (JR_12 JW_12 \~R0_19 \~R0_18 \~R0_17 \~R0_16 \~R1_19 \~R1_18 \~R1_17 \~R1_16 \~W0_19 \~W0_18 \~W0_17 \~W0_16 \~W1_19 \~W1_18 \~W1_17 \~W1_16) _sub140
    I91 (JR_11 JW_11 \~R0_19 \~R0_18 \~R0_17 \~R0_16 \~R1_19 \~R1_18 \~R1_17 \~R1_16 \~W0_19 \~W0_18 \~W0_17 \~W0_16 \~W1_19 \~W1_18 \~W1_17 \~W1_16) _sub140
    I83 (JR_10 JW_10 \~R0_19 \~R0_18 \~R0_17 \~R0_16 \~R1_19 \~R1_18 \~R1_17 \~R1_16 \~W0_19 \~W0_18 \~W0_17 \~W0_16 \~W1_19 \~W1_18 \~W1_17 \~W1_16) _sub140
    I75 (JR_9 JW_9 \~R0_19 \~R0_18 \~R0_17 \~R0_16 \~R1_19 \~R1_18 \~R1_17 \~R1_16 \~W0_19 \~W0_18 \~W0_17 \~W0_16 \~W1_19 \~W1_18 \~W1_17 \~W1_16) _sub140
    I67 (JR_8 JW_8 \~R0_19 \~R0_18 \~R0_17 \~R0_16 \~R1_19 \~R1_18 \~R1_17 \~R1_16 \~W0_19 \~W0_18 \~W0_17 \~W0_16 \~W1_19 \~W1_18 \~W1_17 \~W1_16) _sub140
    I59 (JR_7 JW_7 \~R0_19 \~R0_18 \~R0_17 \~R0_16 \~R1_19 \~R1_18 \~R1_17 \~R1_16 \~W0_19 \~W0_18 \~W0_17 \~W0_16 \~W1_19 \~W1_18 \~W1_17 \~W1_16) _sub140
    I51 (JR_6 JW_6 \~R0_19 \~R0_18 \~R0_17 \~R0_16 \~R1_19 \~R1_18 \~R1_17 \~R1_16 \~W0_19 \~W0_18 \~W0_17 \~W0_16 \~W1_19 \~W1_18 \~W1_17 \~W1_16) _sub140
    I43 (JR_5 JW_5 \~R0_19 \~R0_18 \~R0_17 \~R0_16 \~R1_19 \~R1_18 \~R1_17 \~R1_16 \~W0_19 \~W0_18 \~W0_17 \~W0_16 \~W1_19 \~W1_18 \~W1_17 \~W1_16) _sub140
    I35 (JR_4 JW_4 \~R0_19 \~R0_18 \~R0_17 \~R0_16 \~R1_19 \~R1_18 \~R1_17 \~R1_16 \~W0_19 \~W0_18 \~W0_17 \~W0_16 \~W1_19 \~W1_18 \~W1_17 \~W1_16) _sub140
    I27 (JR_3 JW_3 \~R0_19 \~R0_18 \~R0_17 \~R0_16 \~R1_19 \~R1_18 \~R1_17 \~R1_16 \~W0_19 \~W0_18 \~W0_17 \~W0_16 \~W1_19 \~W1_18 \~W1_17 \~W1_16) _sub140
    I19 (JR_2 JW_2 \~R0_19 \~R0_18 \~R0_17 \~R0_16 \~R1_19 \~R1_18 \~R1_17 \~R1_16 \~W0_19 \~W0_18 \~W0_17 \~W0_16 \~W1_19 \~W1_18 \~W1_17 \~W1_16) _sub140
    I11 (JR_1 JW_1 \~R0_19 \~R0_18 \~R0_17 \~R0_16 \~R1_19 \~R1_18 \~R1_17 \~R1_16 \~W0_19 \~W0_18 \~W0_17 \~W0_16 \~W1_19 \~W1_18 \~W1_17 \~W1_16) _sub140
    I250 (JR_31 JW_31 \~R0_23 \~R0_22 \~R0_21 \~R0_20 \~R1_23 \~R1_22 \~R1_21 \~R1_20 \~W0_23 \~W0_22 \~W0_21 \~W0_20 \~W1_23 \~W1_22 \~W1_21 \~W1_20) _sub140
    I242 (JR_30 JW_30 \~R0_23 \~R0_22 \~R0_21 \~R0_20 \~R1_23 \~R1_22 \~R1_21 \~R1_20 \~W0_23 \~W0_22 \~W0_21 \~W0_20 \~W1_23 \~W1_22 \~W1_21 \~W1_20) _sub140
    I234 (JR_29 JW_29 \~R0_23 \~R0_22 \~R0_21 \~R0_20 \~R1_23 \~R1_22 \~R1_21 \~R1_20 \~W0_23 \~W0_22 \~W0_21 \~W0_20 \~W1_23 \~W1_22 \~W1_21 \~W1_20) _sub140
    I226 (JR_28 JW_28 \~R0_23 \~R0_22 \~R0_21 \~R0_20 \~R1_23 \~R1_22 \~R1_21 \~R1_20 \~W0_23 \~W0_22 \~W0_21 \~W0_20 \~W1_23 \~W1_22 \~W1_21 \~W1_20) _sub140
    I218 (JR_27 JW_27 \~R0_23 \~R0_22 \~R0_21 \~R0_20 \~R1_23 \~R1_22 \~R1_21 \~R1_20 \~W0_23 \~W0_22 \~W0_21 \~W0_20 \~W1_23 \~W1_22 \~W1_21 \~W1_20) _sub140
    I210 (JR_26 JW_26 \~R0_23 \~R0_22 \~R0_21 \~R0_20 \~R1_23 \~R1_22 \~R1_21 \~R1_20 \~W0_23 \~W0_22 \~W0_21 \~W0_20 \~W1_23 \~W1_22 \~W1_21 \~W1_20) _sub140
    I202 (JR_25 JW_25 \~R0_23 \~R0_22 \~R0_21 \~R0_20 \~R1_23 \~R1_22 \~R1_21 \~R1_20 \~W0_23 \~W0_22 \~W0_21 \~W0_20 \~W1_23 \~W1_22 \~W1_21 \~W1_20) _sub140
    I194 (JR_24 JW_24 \~R0_23 \~R0_22 \~R0_21 \~R0_20 \~R1_23 \~R1_22 \~R1_21 \~R1_20 \~W0_23 \~W0_22 \~W0_21 \~W0_20 \~W1_23 \~W1_22 \~W1_21 \~W1_20) _sub140
    I186 (JR_23 JW_23 \~R0_23 \~R0_22 \~R0_21 \~R0_20 \~R1_23 \~R1_22 \~R1_21 \~R1_20 \~W0_23 \~W0_22 \~W0_21 \~W0_20 \~W1_23 \~W1_22 \~W1_21 \~W1_20) _sub140
    I178 (JR_22 JW_22 \~R0_23 \~R0_22 \~R0_21 \~R0_20 \~R1_23 \~R1_22 \~R1_21 \~R1_20 \~W0_23 \~W0_22 \~W0_21 \~W0_20 \~W1_23 \~W1_22 \~W1_21 \~W1_20) _sub140
    I170 (JR_21 JW_21 \~R0_23 \~R0_22 \~R0_21 \~R0_20 \~R1_23 \~R1_22 \~R1_21 \~R1_20 \~W0_23 \~W0_22 \~W0_21 \~W0_20 \~W1_23 \~W1_22 \~W1_21 \~W1_20) _sub140
    I162 (JR_20 JW_20 \~R0_23 \~R0_22 \~R0_21 \~R0_20 \~R1_23 \~R1_22 \~R1_21 \~R1_20 \~W0_23 \~W0_22 \~W0_21 \~W0_20 \~W1_23 \~W1_22 \~W1_21 \~W1_20) _sub140
    I154 (JR_19 JW_19 \~R0_23 \~R0_22 \~R0_21 \~R0_20 \~R1_23 \~R1_22 \~R1_21 \~R1_20 \~W0_23 \~W0_22 \~W0_21 \~W0_20 \~W1_23 \~W1_22 \~W1_21 \~W1_20) _sub140
    I146 (JR_18 JW_18 \~R0_23 \~R0_22 \~R0_21 \~R0_20 \~R1_23 \~R1_22 \~R1_21 \~R1_20 \~W0_23 \~W0_22 \~W0_21 \~W0_20 \~W1_23 \~W1_22 \~W1_21 \~W1_20) _sub140
    I138 (JR_17 JW_17 \~R0_23 \~R0_22 \~R0_21 \~R0_20 \~R1_23 \~R1_22 \~R1_21 \~R1_20 \~W0_23 \~W0_22 \~W0_21 \~W0_20 \~W1_23 \~W1_22 \~W1_21 \~W1_20) _sub140
    I130 (JR_16 JW_16 \~R0_23 \~R0_22 \~R0_21 \~R0_20 \~R1_23 \~R1_22 \~R1_21 \~R1_20 \~W0_23 \~W0_22 \~W0_21 \~W0_20 \~W1_23 \~W1_22 \~W1_21 \~W1_20) _sub140
    I122 (JR_15 JW_15 \~R0_23 \~R0_22 \~R0_21 \~R0_20 \~R1_23 \~R1_22 \~R1_21 \~R1_20 \~W0_23 \~W0_22 \~W0_21 \~W0_20 \~W1_23 \~W1_22 \~W1_21 \~W1_20) _sub140
    I114 (JR_14 JW_14 \~R0_23 \~R0_22 \~R0_21 \~R0_20 \~R1_23 \~R1_22 \~R1_21 \~R1_20 \~W0_23 \~W0_22 \~W0_21 \~W0_20 \~W1_23 \~W1_22 \~W1_21 \~W1_20) _sub140
    I106 (JR_13 JW_13 \~R0_23 \~R0_22 \~R0_21 \~R0_20 \~R1_23 \~R1_22 \~R1_21 \~R1_20 \~W0_23 \~W0_22 \~W0_21 \~W0_20 \~W1_23 \~W1_22 \~W1_21 \~W1_20) _sub140
    I98 (JR_12 JW_12 \~R0_23 \~R0_22 \~R0_21 \~R0_20 \~R1_23 \~R1_22 \~R1_21 \~R1_20 \~W0_23 \~W0_22 \~W0_21 \~W0_20 \~W1_23 \~W1_22 \~W1_21 \~W1_20) _sub140
    I90 (JR_11 JW_11 \~R0_23 \~R0_22 \~R0_21 \~R0_20 \~R1_23 \~R1_22 \~R1_21 \~R1_20 \~W0_23 \~W0_22 \~W0_21 \~W0_20 \~W1_23 \~W1_22 \~W1_21 \~W1_20) _sub140
    I82 (JR_10 JW_10 \~R0_23 \~R0_22 \~R0_21 \~R0_20 \~R1_23 \~R1_22 \~R1_21 \~R1_20 \~W0_23 \~W0_22 \~W0_21 \~W0_20 \~W1_23 \~W1_22 \~W1_21 \~W1_20) _sub140
    I74 (JR_9 JW_9 \~R0_23 \~R0_22 \~R0_21 \~R0_20 \~R1_23 \~R1_22 \~R1_21 \~R1_20 \~W0_23 \~W0_22 \~W0_21 \~W0_20 \~W1_23 \~W1_22 \~W1_21 \~W1_20) _sub140
    I66 (JR_8 JW_8 \~R0_23 \~R0_22 \~R0_21 \~R0_20 \~R1_23 \~R1_22 \~R1_21 \~R1_20 \~W0_23 \~W0_22 \~W0_21 \~W0_20 \~W1_23 \~W1_22 \~W1_21 \~W1_20) _sub140
    I58 (JR_7 JW_7 \~R0_23 \~R0_22 \~R0_21 \~R0_20 \~R1_23 \~R1_22 \~R1_21 \~R1_20 \~W0_23 \~W0_22 \~W0_21 \~W0_20 \~W1_23 \~W1_22 \~W1_21 \~W1_20) _sub140
    I50 (JR_6 JW_6 \~R0_23 \~R0_22 \~R0_21 \~R0_20 \~R1_23 \~R1_22 \~R1_21 \~R1_20 \~W0_23 \~W0_22 \~W0_21 \~W0_20 \~W1_23 \~W1_22 \~W1_21 \~W1_20) _sub140
    I42 (JR_5 JW_5 \~R0_23 \~R0_22 \~R0_21 \~R0_20 \~R1_23 \~R1_22 \~R1_21 \~R1_20 \~W0_23 \~W0_22 \~W0_21 \~W0_20 \~W1_23 \~W1_22 \~W1_21 \~W1_20) _sub140
    I34 (JR_4 JW_4 \~R0_23 \~R0_22 \~R0_21 \~R0_20 \~R1_23 \~R1_22 \~R1_21 \~R1_20 \~W0_23 \~W0_22 \~W0_21 \~W0_20 \~W1_23 \~W1_22 \~W1_21 \~W1_20) _sub140
    I26 (JR_3 JW_3 \~R0_23 \~R0_22 \~R0_21 \~R0_20 \~R1_23 \~R1_22 \~R1_21 \~R1_20 \~W0_23 \~W0_22 \~W0_21 \~W0_20 \~W1_23 \~W1_22 \~W1_21 \~W1_20) _sub140
    I18 (JR_2 JW_2 \~R0_23 \~R0_22 \~R0_21 \~R0_20 \~R1_23 \~R1_22 \~R1_21 \~R1_20 \~W0_23 \~W0_22 \~W0_21 \~W0_20 \~W1_23 \~W1_22 \~W1_21 \~W1_20) _sub140
    I10 (JR_1 JW_1 \~R0_23 \~R0_22 \~R0_21 \~R0_20 \~R1_23 \~R1_22 \~R1_21 \~R1_20 \~W0_23 \~W0_22 \~W0_21 \~W0_20 \~W1_23 \~W1_22 \~W1_21 \~W1_20) _sub140
    I249 (JR_31 JW_31 \~R0_27 \~R0_26 \~R0_25 \~R0_24 \~R1_27 \~R1_26 \~R1_25 \~R1_24 \~W0_27 \~W0_26 \~W0_25 \~W0_24 \~W1_27 \~W1_26 \~W1_25 \~W1_24) _sub140
    I241 (JR_30 JW_30 \~R0_27 \~R0_26 \~R0_25 \~R0_24 \~R1_27 \~R1_26 \~R1_25 \~R1_24 \~W0_27 \~W0_26 \~W0_25 \~W0_24 \~W1_27 \~W1_26 \~W1_25 \~W1_24) _sub140
    I233 (JR_29 JW_29 \~R0_27 \~R0_26 \~R0_25 \~R0_24 \~R1_27 \~R1_26 \~R1_25 \~R1_24 \~W0_27 \~W0_26 \~W0_25 \~W0_24 \~W1_27 \~W1_26 \~W1_25 \~W1_24) _sub140
    I225 (JR_28 JW_28 \~R0_27 \~R0_26 \~R0_25 \~R0_24 \~R1_27 \~R1_26 \~R1_25 \~R1_24 \~W0_27 \~W0_26 \~W0_25 \~W0_24 \~W1_27 \~W1_26 \~W1_25 \~W1_24) _sub140
    I217 (JR_27 JW_27 \~R0_27 \~R0_26 \~R0_25 \~R0_24 \~R1_27 \~R1_26 \~R1_25 \~R1_24 \~W0_27 \~W0_26 \~W0_25 \~W0_24 \~W1_27 \~W1_26 \~W1_25 \~W1_24) _sub140
    I209 (JR_26 JW_26 \~R0_27 \~R0_26 \~R0_25 \~R0_24 \~R1_27 \~R1_26 \~R1_25 \~R1_24 \~W0_27 \~W0_26 \~W0_25 \~W0_24 \~W1_27 \~W1_26 \~W1_25 \~W1_24) _sub140
    I201 (JR_25 JW_25 \~R0_27 \~R0_26 \~R0_25 \~R0_24 \~R1_27 \~R1_26 \~R1_25 \~R1_24 \~W0_27 \~W0_26 \~W0_25 \~W0_24 \~W1_27 \~W1_26 \~W1_25 \~W1_24) _sub140
    I193 (JR_24 JW_24 \~R0_27 \~R0_26 \~R0_25 \~R0_24 \~R1_27 \~R1_26 \~R1_25 \~R1_24 \~W0_27 \~W0_26 \~W0_25 \~W0_24 \~W1_27 \~W1_26 \~W1_25 \~W1_24) _sub140
    I185 (JR_23 JW_23 \~R0_27 \~R0_26 \~R0_25 \~R0_24 \~R1_27 \~R1_26 \~R1_25 \~R1_24 \~W0_27 \~W0_26 \~W0_25 \~W0_24 \~W1_27 \~W1_26 \~W1_25 \~W1_24) _sub140
    I177 (JR_22 JW_22 \~R0_27 \~R0_26 \~R0_25 \~R0_24 \~R1_27 \~R1_26 \~R1_25 \~R1_24 \~W0_27 \~W0_26 \~W0_25 \~W0_24 \~W1_27 \~W1_26 \~W1_25 \~W1_24) _sub140
    I169 (JR_21 JW_21 \~R0_27 \~R0_26 \~R0_25 \~R0_24 \~R1_27 \~R1_26 \~R1_25 \~R1_24 \~W0_27 \~W0_26 \~W0_25 \~W0_24 \~W1_27 \~W1_26 \~W1_25 \~W1_24) _sub140
    I161 (JR_20 JW_20 \~R0_27 \~R0_26 \~R0_25 \~R0_24 \~R1_27 \~R1_26 \~R1_25 \~R1_24 \~W0_27 \~W0_26 \~W0_25 \~W0_24 \~W1_27 \~W1_26 \~W1_25 \~W1_24) _sub140
    I153 (JR_19 JW_19 \~R0_27 \~R0_26 \~R0_25 \~R0_24 \~R1_27 \~R1_26 \~R1_25 \~R1_24 \~W0_27 \~W0_26 \~W0_25 \~W0_24 \~W1_27 \~W1_26 \~W1_25 \~W1_24) _sub140
    I145 (JR_18 JW_18 \~R0_27 \~R0_26 \~R0_25 \~R0_24 \~R1_27 \~R1_26 \~R1_25 \~R1_24 \~W0_27 \~W0_26 \~W0_25 \~W0_24 \~W1_27 \~W1_26 \~W1_25 \~W1_24) _sub140
    I137 (JR_17 JW_17 \~R0_27 \~R0_26 \~R0_25 \~R0_24 \~R1_27 \~R1_26 \~R1_25 \~R1_24 \~W0_27 \~W0_26 \~W0_25 \~W0_24 \~W1_27 \~W1_26 \~W1_25 \~W1_24) _sub140
    I129 (JR_16 JW_16 \~R0_27 \~R0_26 \~R0_25 \~R0_24 \~R1_27 \~R1_26 \~R1_25 \~R1_24 \~W0_27 \~W0_26 \~W0_25 \~W0_24 \~W1_27 \~W1_26 \~W1_25 \~W1_24) _sub140
    I121 (JR_15 JW_15 \~R0_27 \~R0_26 \~R0_25 \~R0_24 \~R1_27 \~R1_26 \~R1_25 \~R1_24 \~W0_27 \~W0_26 \~W0_25 \~W0_24 \~W1_27 \~W1_26 \~W1_25 \~W1_24) _sub140
    I113 (JR_14 JW_14 \~R0_27 \~R0_26 \~R0_25 \~R0_24 \~R1_27 \~R1_26 \~R1_25 \~R1_24 \~W0_27 \~W0_26 \~W0_25 \~W0_24 \~W1_27 \~W1_26 \~W1_25 \~W1_24) _sub140
    I105 (JR_13 JW_13 \~R0_27 \~R0_26 \~R0_25 \~R0_24 \~R1_27 \~R1_26 \~R1_25 \~R1_24 \~W0_27 \~W0_26 \~W0_25 \~W0_24 \~W1_27 \~W1_26 \~W1_25 \~W1_24) _sub140
    I97 (JR_12 JW_12 \~R0_27 \~R0_26 \~R0_25 \~R0_24 \~R1_27 \~R1_26 \~R1_25 \~R1_24 \~W0_27 \~W0_26 \~W0_25 \~W0_24 \~W1_27 \~W1_26 \~W1_25 \~W1_24) _sub140
    I89 (JR_11 JW_11 \~R0_27 \~R0_26 \~R0_25 \~R0_24 \~R1_27 \~R1_26 \~R1_25 \~R1_24 \~W0_27 \~W0_26 \~W0_25 \~W0_24 \~W1_27 \~W1_26 \~W1_25 \~W1_24) _sub140
    I81 (JR_10 JW_10 \~R0_27 \~R0_26 \~R0_25 \~R0_24 \~R1_27 \~R1_26 \~R1_25 \~R1_24 \~W0_27 \~W0_26 \~W0_25 \~W0_24 \~W1_27 \~W1_26 \~W1_25 \~W1_24) _sub140
    I73 (JR_9 JW_9 \~R0_27 \~R0_26 \~R0_25 \~R0_24 \~R1_27 \~R1_26 \~R1_25 \~R1_24 \~W0_27 \~W0_26 \~W0_25 \~W0_24 \~W1_27 \~W1_26 \~W1_25 \~W1_24) _sub140
    I65 (JR_8 JW_8 \~R0_27 \~R0_26 \~R0_25 \~R0_24 \~R1_27 \~R1_26 \~R1_25 \~R1_24 \~W0_27 \~W0_26 \~W0_25 \~W0_24 \~W1_27 \~W1_26 \~W1_25 \~W1_24) _sub140
    I57 (JR_7 JW_7 \~R0_27 \~R0_26 \~R0_25 \~R0_24 \~R1_27 \~R1_26 \~R1_25 \~R1_24 \~W0_27 \~W0_26 \~W0_25 \~W0_24 \~W1_27 \~W1_26 \~W1_25 \~W1_24) _sub140
    I49 (JR_6 JW_6 \~R0_27 \~R0_26 \~R0_25 \~R0_24 \~R1_27 \~R1_26 \~R1_25 \~R1_24 \~W0_27 \~W0_26 \~W0_25 \~W0_24 \~W1_27 \~W1_26 \~W1_25 \~W1_24) _sub140
    I41 (JR_5 JW_5 \~R0_27 \~R0_26 \~R0_25 \~R0_24 \~R1_27 \~R1_26 \~R1_25 \~R1_24 \~W0_27 \~W0_26 \~W0_25 \~W0_24 \~W1_27 \~W1_26 \~W1_25 \~W1_24) _sub140
    I33 (JR_4 JW_4 \~R0_27 \~R0_26 \~R0_25 \~R0_24 \~R1_27 \~R1_26 \~R1_25 \~R1_24 \~W0_27 \~W0_26 \~W0_25 \~W0_24 \~W1_27 \~W1_26 \~W1_25 \~W1_24) _sub140
    I25 (JR_3 JW_3 \~R0_27 \~R0_26 \~R0_25 \~R0_24 \~R1_27 \~R1_26 \~R1_25 \~R1_24 \~W0_27 \~W0_26 \~W0_25 \~W0_24 \~W1_27 \~W1_26 \~W1_25 \~W1_24) _sub140
    I17 (JR_2 JW_2 \~R0_27 \~R0_26 \~R0_25 \~R0_24 \~R1_27 \~R1_26 \~R1_25 \~R1_24 \~W0_27 \~W0_26 \~W0_25 \~W0_24 \~W1_27 \~W1_26 \~W1_25 \~W1_24) _sub140
    I9 (JR_1 JW_1 \~R0_27 \~R0_26 \~R0_25 \~R0_24 \~R1_27 \~R1_26 \~R1_25 \~R1_24 \~W0_27 \~W0_26 \~W0_25 \~W0_24 \~W1_27 \~W1_26 \~W1_25 \~W1_24) _sub140
    I248 (JR_31 JW_31 \~R0_31 \~R0_30 \~R0_29 \~R0_28 \~R1_31 \~R1_30 \~R1_29 \~R1_28 \~W0_31 \~W0_30 \~W0_29 \~W0_28 \~W1_31 \~W1_30 \~W1_29 \~W1_28) _sub140
    I240 (JR_30 JW_30 \~R0_31 \~R0_30 \~R0_29 \~R0_28 \~R1_31 \~R1_30 \~R1_29 \~R1_28 \~W0_31 \~W0_30 \~W0_29 \~W0_28 \~W1_31 \~W1_30 \~W1_29 \~W1_28) _sub140
    I232 (JR_29 JW_29 \~R0_31 \~R0_30 \~R0_29 \~R0_28 \~R1_31 \~R1_30 \~R1_29 \~R1_28 \~W0_31 \~W0_30 \~W0_29 \~W0_28 \~W1_31 \~W1_30 \~W1_29 \~W1_28) _sub140
    I224 (JR_28 JW_28 \~R0_31 \~R0_30 \~R0_29 \~R0_28 \~R1_31 \~R1_30 \~R1_29 \~R1_28 \~W0_31 \~W0_30 \~W0_29 \~W0_28 \~W1_31 \~W1_30 \~W1_29 \~W1_28) _sub140
    I216 (JR_27 JW_27 \~R0_31 \~R0_30 \~R0_29 \~R0_28 \~R1_31 \~R1_30 \~R1_29 \~R1_28 \~W0_31 \~W0_30 \~W0_29 \~W0_28 \~W1_31 \~W1_30 \~W1_29 \~W1_28) _sub140
    I208 (JR_26 JW_26 \~R0_31 \~R0_30 \~R0_29 \~R0_28 \~R1_31 \~R1_30 \~R1_29 \~R1_28 \~W0_31 \~W0_30 \~W0_29 \~W0_28 \~W1_31 \~W1_30 \~W1_29 \~W1_28) _sub140
    I200 (JR_25 JW_25 \~R0_31 \~R0_30 \~R0_29 \~R0_28 \~R1_31 \~R1_30 \~R1_29 \~R1_28 \~W0_31 \~W0_30 \~W0_29 \~W0_28 \~W1_31 \~W1_30 \~W1_29 \~W1_28) _sub140
    I192 (JR_24 JW_24 \~R0_31 \~R0_30 \~R0_29 \~R0_28 \~R1_31 \~R1_30 \~R1_29 \~R1_28 \~W0_31 \~W0_30 \~W0_29 \~W0_28 \~W1_31 \~W1_30 \~W1_29 \~W1_28) _sub140
    I184 (JR_23 JW_23 \~R0_31 \~R0_30 \~R0_29 \~R0_28 \~R1_31 \~R1_30 \~R1_29 \~R1_28 \~W0_31 \~W0_30 \~W0_29 \~W0_28 \~W1_31 \~W1_30 \~W1_29 \~W1_28) _sub140
    I176 (JR_22 JW_22 \~R0_31 \~R0_30 \~R0_29 \~R0_28 \~R1_31 \~R1_30 \~R1_29 \~R1_28 \~W0_31 \~W0_30 \~W0_29 \~W0_28 \~W1_31 \~W1_30 \~W1_29 \~W1_28) _sub140
    I168 (JR_21 JW_21 \~R0_31 \~R0_30 \~R0_29 \~R0_28 \~R1_31 \~R1_30 \~R1_29 \~R1_28 \~W0_31 \~W0_30 \~W0_29 \~W0_28 \~W1_31 \~W1_30 \~W1_29 \~W1_28) _sub140
    I160 (JR_20 JW_20 \~R0_31 \~R0_30 \~R0_29 \~R0_28 \~R1_31 \~R1_30 \~R1_29 \~R1_28 \~W0_31 \~W0_30 \~W0_29 \~W0_28 \~W1_31 \~W1_30 \~W1_29 \~W1_28) _sub140
    I152 (JR_19 JW_19 \~R0_31 \~R0_30 \~R0_29 \~R0_28 \~R1_31 \~R1_30 \~R1_29 \~R1_28 \~W0_31 \~W0_30 \~W0_29 \~W0_28 \~W1_31 \~W1_30 \~W1_29 \~W1_28) _sub140
    I144 (JR_18 JW_18 \~R0_31 \~R0_30 \~R0_29 \~R0_28 \~R1_31 \~R1_30 \~R1_29 \~R1_28 \~W0_31 \~W0_30 \~W0_29 \~W0_28 \~W1_31 \~W1_30 \~W1_29 \~W1_28) _sub140
    I136 (JR_17 JW_17 \~R0_31 \~R0_30 \~R0_29 \~R0_28 \~R1_31 \~R1_30 \~R1_29 \~R1_28 \~W0_31 \~W0_30 \~W0_29 \~W0_28 \~W1_31 \~W1_30 \~W1_29 \~W1_28) _sub140
    I128 (JR_16 JW_16 \~R0_31 \~R0_30 \~R0_29 \~R0_28 \~R1_31 \~R1_30 \~R1_29 \~R1_28 \~W0_31 \~W0_30 \~W0_29 \~W0_28 \~W1_31 \~W1_30 \~W1_29 \~W1_28) _sub140
    I120 (JR_15 JW_15 \~R0_31 \~R0_30 \~R0_29 \~R0_28 \~R1_31 \~R1_30 \~R1_29 \~R1_28 \~W0_31 \~W0_30 \~W0_29 \~W0_28 \~W1_31 \~W1_30 \~W1_29 \~W1_28) _sub140
    I112 (JR_14 JW_14 \~R0_31 \~R0_30 \~R0_29 \~R0_28 \~R1_31 \~R1_30 \~R1_29 \~R1_28 \~W0_31 \~W0_30 \~W0_29 \~W0_28 \~W1_31 \~W1_30 \~W1_29 \~W1_28) _sub140
    I104 (JR_13 JW_13 \~R0_31 \~R0_30 \~R0_29 \~R0_28 \~R1_31 \~R1_30 \~R1_29 \~R1_28 \~W0_31 \~W0_30 \~W0_29 \~W0_28 \~W1_31 \~W1_30 \~W1_29 \~W1_28) _sub140
    I96 (JR_12 JW_12 \~R0_31 \~R0_30 \~R0_29 \~R0_28 \~R1_31 \~R1_30 \~R1_29 \~R1_28 \~W0_31 \~W0_30 \~W0_29 \~W0_28 \~W1_31 \~W1_30 \~W1_29 \~W1_28) _sub140
    I88 (JR_11 JW_11 \~R0_31 \~R0_30 \~R0_29 \~R0_28 \~R1_31 \~R1_30 \~R1_29 \~R1_28 \~W0_31 \~W0_30 \~W0_29 \~W0_28 \~W1_31 \~W1_30 \~W1_29 \~W1_28) _sub140
    I80 (JR_10 JW_10 \~R0_31 \~R0_30 \~R0_29 \~R0_28 \~R1_31 \~R1_30 \~R1_29 \~R1_28 \~W0_31 \~W0_30 \~W0_29 \~W0_28 \~W1_31 \~W1_30 \~W1_29 \~W1_28) _sub140
    I72 (JR_9 JW_9 \~R0_31 \~R0_30 \~R0_29 \~R0_28 \~R1_31 \~R1_30 \~R1_29 \~R1_28 \~W0_31 \~W0_30 \~W0_29 \~W0_28 \~W1_31 \~W1_30 \~W1_29 \~W1_28) _sub140
    I64 (JR_8 JW_8 \~R0_31 \~R0_30 \~R0_29 \~R0_28 \~R1_31 \~R1_30 \~R1_29 \~R1_28 \~W0_31 \~W0_30 \~W0_29 \~W0_28 \~W1_31 \~W1_30 \~W1_29 \~W1_28) _sub140
    I56 (JR_7 JW_7 \~R0_31 \~R0_30 \~R0_29 \~R0_28 \~R1_31 \~R1_30 \~R1_29 \~R1_28 \~W0_31 \~W0_30 \~W0_29 \~W0_28 \~W1_31 \~W1_30 \~W1_29 \~W1_28) _sub140
    I48 (JR_6 JW_6 \~R0_31 \~R0_30 \~R0_29 \~R0_28 \~R1_31 \~R1_30 \~R1_29 \~R1_28 \~W0_31 \~W0_30 \~W0_29 \~W0_28 \~W1_31 \~W1_30 \~W1_29 \~W1_28) _sub140
    I40 (JR_5 JW_5 \~R0_31 \~R0_30 \~R0_29 \~R0_28 \~R1_31 \~R1_30 \~R1_29 \~R1_28 \~W0_31 \~W0_30 \~W0_29 \~W0_28 \~W1_31 \~W1_30 \~W1_29 \~W1_28) _sub140
    I32 (JR_4 JW_4 \~R0_31 \~R0_30 \~R0_29 \~R0_28 \~R1_31 \~R1_30 \~R1_29 \~R1_28 \~W0_31 \~W0_30 \~W0_29 \~W0_28 \~W1_31 \~W1_30 \~W1_29 \~W1_28) _sub140
    I24 (JR_3 JW_3 \~R0_31 \~R0_30 \~R0_29 \~R0_28 \~R1_31 \~R1_30 \~R1_29 \~R1_28 \~W0_31 \~W0_30 \~W0_29 \~W0_28 \~W1_31 \~W1_30 \~W1_29 \~W1_28) _sub140
    I16 (JR_2 JW_2 \~R0_31 \~R0_30 \~R0_29 \~R0_28 \~R1_31 \~R1_30 \~R1_29 \~R1_28 \~W0_31 \~W0_30 \~W0_29 \~W0_28 \~W1_31 \~W1_30 \~W1_29 \~W1_28) _sub140
    I8 (JR_1 JW_1 \~R0_31 \~R0_30 \~R0_29 \~R0_28 \~R1_31 \~R1_30 \~R1_29 \~R1_28 \~W0_31 \~W0_30 \~W0_29 \~W0_28 \~W1_31 \~W1_30 \~W1_29 \~W1_28) _sub140
    I7 (JR_0 JW_0 \~R0_3 \~R0_2 \~R0_1 \~R0_0 \~R1_3 \~R1_2 \~R1_1 \~R1_0 \~W0_3 \~W0_2 \~W0_1 \~W0_0 \~W1_3 \~W1_2 \~W1_1 \~W1_0) _sub140
    I6 (JR_0 JW_0 \~R0_7 \~R0_6 \~R0_5 \~R0_4 \~R1_7 \~R1_6 \~R1_5 \~R1_4 \~W0_7 \~W0_6 \~W0_5 \~W0_4 \~W1_7 \~W1_6 \~W1_5 \~W1_4) _sub140
    I5 (JR_0 JW_0 \~R0_11 \~R0_10 \~R0_9 \~R0_8 \~R1_11 \~R1_10 \~R1_9 \~R1_8 \~W0_11 \~W0_10 \~W0_9 \~W0_8 \~W1_11 \~W1_10 \~W1_9 \~W1_8) _sub140
    I4 (JR_0 JW_0 \~R0_15 \~R0_14 \~R0_13 \~R0_12 \~R1_15 \~R1_14 \~R1_13 \~R1_12 \~W0_15 \~W0_14 \~W0_13 \~W0_12 \~W1_15 \~W1_14 \~W1_13 \~W1_12) _sub140
    I3 (JR_0 JW_0 \~R0_19 \~R0_18 \~R0_17 \~R0_16 \~R1_19 \~R1_18 \~R1_17 \~R1_16 \~W0_19 \~W0_18 \~W0_17 \~W0_16 \~W1_19 \~W1_18 \~W1_17 \~W1_16) _sub140
    I2 (JR_0 JW_0 \~R0_23 \~R0_22 \~R0_21 \~R0_20 \~R1_23 \~R1_22 \~R1_21 \~R1_20 \~W0_23 \~W0_22 \~W0_21 \~W0_20 \~W1_23 \~W1_22 \~W1_21 \~W1_20) _sub140
    I1 (JR_0 JW_0 \~R0_27 \~R0_26 \~R0_25 \~R0_24 \~R1_27 \~R1_26 \~R1_25 \~R1_24 \~W0_27 \~W0_26 \~W0_25 \~W0_24 \~W1_27 \~W1_26 \~W1_25 \~W1_24) _sub140
    I0 (JR_0 JW_0 \~R0_31 \~R0_30 \~R0_29 \~R0_28 \~R1_31 \~R1_30 \~R1_29 \~R1_28 \~W0_31 \~W0_30 \~W0_29 \~W0_28 \~W1_31 \~W1_30 \~W1_29 \~W1_28) _sub140
ends _sub141

// 16nm/and2/schematic
//system verilogNetlist schematic cmos.sch cmos_sch veriloga ahdl
subckt and2 A B Y
    I8 (ntYbar Y) inv_1x
    I7 (A B ntYbar) nand_1x
ends and2

// 16nm/nand3_1x/schematic
//system verilogNetlist schematic cmos.sch cmos_sch veriloga ahdl
subckt nand3_1x A B C Y
    M4 (Y C vdd! vdd!) pfet w=100n l=20n nfin=1 m=1 degradation=yes
    M1 (Y B vdd! vdd!) pfet w=100n l=20n nfin=1 m=1 degradation=yes
    M0 (Y A vdd! vdd!) pfet w=100n l=20n nfin=1 m=1 degradation=yes
    M6 (net026 C 0 0) nfet w=180n l=20n nfin=1 m=1 degradation=no
    M3 (net22 B net026 0) nfet w=180n l=20n nfin=1 m=1 degradation=no
    M2 (Y A net22 0) nfet w=180n l=20n nfin=1 m=1 degradation=no
ends nand3_1x

// 16nm/Decode_4to16/schematic
//system verilogNetlist schematic cmos.sch cmos_sch veriloga ahdl
subckt Decode_4to16 A_15 A_14 A_13 A_12 A_11 A_10 A_9 A_8 A_7 A_6 A_5 A_4 A_3 A_2 A_1 A_0 En I_3 I_2 I_1 I_0 Reset
    I7 (net5 net11 net1) and2
    I6 (I_0 net11 net064) and2
    I5 (net5 I_1 net062) and2
    I4 (I_0 I_1 net068) and2
    I3 (net37 net14 net079) and2
    I2 (I_2 net14 net069) and2
    I1 (net37 I_3 net19) and2
    I0 (I_2 I_3 net055) and2
    I76 (Reset net050) inv_1x
    I11 (I_0 net5) inv_1x
    I10 (I_1 net11) inv_1x
    I9 (I_2 net37) inv_1x
    I8 (I_3 net14) inv_1x
    I59 (net068 net055 En net015) nand3_1x
    I58 (net062 net055 En net014) nand3_1x
    I57 (net064 net055 En net013) nand3_1x
    I56 (net1 net055 En net012) nand3_1x
    I55 (net068 net19 En net011) nand3_1x
    I54 (net062 net19 En net016) nand3_1x
    I53 (net064 net19 En net017) nand3_1x
    I52 (net1 net19 En net018) nand3_1x
    I51 (net068 net069 En net019) nand3_1x
    I50 (net062 net069 En net020) nand3_1x
    I49 (net064 net069 En net021) nand3_1x
    I48 (net1 net069 En net022) nand3_1x
    I47 (net068 net079 En net023) nand3_1x
    I46 (net062 net079 En net024) nand3_1x
    I45 (net064 net079 En net099) nand3_1x
    I44 (net1 net079 En net0100) nand3_1x
    I75 (net050 net015 A_15) nand_1x
    I74 (net050 net014 A_14) nand_1x
    I73 (net050 net013 A_13) nand_1x
    I72 (net050 net012 A_12) nand_1x
    I71 (net050 net011 A_11) nand_1x
    I70 (net050 net016 A_10) nand_1x
    I69 (net050 net017 A_9) nand_1x
    I68 (net050 net018 A_8) nand_1x
    I67 (net050 net019 A_7) nand_1x
    I66 (net050 net020 A_6) nand_1x
    I65 (net050 net021 A_5) nand_1x
    I64 (net050 net022 A_4) nand_1x
    I63 (net050 net023 A_3) nand_1x
    I62 (net050 net024 A_2) nand_1x
    I61 (net050 net099 A_1) nand_1x
    I60 (net050 net0100 A_0) nand_1x
ends Decode_4to16

// 16nm/Decode_1to2/schematic
//system verilogNetlist schematic cmos.sch cmos_sch veriloga ahdl
subckt Decode_1to2 En I Sel_1 Sel_0
    I6 (net8 net11) inv_1x
    I4 (I net8) inv_1x
    I0 (net8 En Sel_0) and2
    I1 (net11 En Sel_1) and2
ends Decode_1to2

// 16nm/nand4_1x/schematic
//system verilogNetlist schematic cmos.sch cmos_sch veriloga ahdl
subckt nand4_1x A B C D Y
    M5 (Y D vdd! vdd!) pfet w=100n l=20n nfin=1 m=1 degradation=no
    M4 (Y C vdd! vdd!) pfet w=100n l=20n nfin=1 m=1 degradation=no
    M1 (Y B vdd! vdd!) pfet w=100n l=20n nfin=1 m=1 degradation=no
    M0 (Y A vdd! vdd!) pfet w=100n l=20n nfin=1 m=1 degradation=no
    M7 (net23 D 0 0) nfet w=240n l=20n nfin=1 m=1 degradation=no
    M6 (net25 C net23 0) nfet w=240n l=20n nfin=1 m=1 degradation=no
    M3 (net24 B net25 0) nfet w=240n l=20n nfin=1 m=1 degradation=no
    M2 (Y A net24 0) nfet w=240n l=20n nfin=1 m=1 degradation=no
ends nand4_1x

// 16nm/and4_1x/schematic
//system verilogNetlist schematic cmos.sch cmos_sch veriloga ahdl
subckt and4_1x A B C D Y
    I15 (A B C D net1) nand4_1x
    I16 (net1 Y) inv_1x
ends and4_1x

// 16nm/nor4_1x/schematic
//system verilogNetlist schematic cmos.sch cmos_sch veriloga ahdl
subckt nor4_1x A B C D Y
    M5 (net017 C net21 vdd!) pfet w=400n l=20n nfin=1 m=1 degradation=yes
    M4 (Y D net017 vdd!) pfet w=400n l=20n nfin=1 m=1 degradation=yes
    M3 (net21 B net018 vdd!) pfet w=400n l=20n nfin=1 m=1 degradation=yes
    M2 (net018 A vdd! vdd!) pfet w=400n l=20n nfin=1 m=1 degradation=yes
    M7 (Y D 0 0) nfet w=60n l=20n nfin=1 m=1 degradation=no
    M6 (Y C 0 0) nfet w=60n l=20n nfin=1 m=1 degradation=no
    M1 (Y A 0 0) nfet w=60n l=20n nfin=1 m=1 degradation=no
    M0 (Y B 0 0) nfet w=60n l=20n nfin=1 m=1 degradation=no
ends nor4_1x

// 16nm/10T_DUAL_SRAM_AddrCtrl_aValid/schematic
//system verilogNetlist schematic cmos.sch cmos_sch veriloga ahdl
subckt _sub142 GoR GoW I_Read_4 I_Read_3 I_Read_2 I_Read_1 I_Read_0 I_Write_4 I_Write_3 I_Write_2 I_Write_1 I_Write_0 JRi_31 JRi_30 JRi_29 JRi_28 JRi_27 JRi_26 JRi_25 JRi_24 JRi_23 JRi_22 JRi_21 JRi_20 JRi_19 JRi_18 JRi_17 JRi_16 JRi_15 JRi_14 JRi_13 JRi_12 JRi_11 JRi_10 JRi_9 JRi_8 JRi_7 JRi_6 JRi_5 JRi_4 JRi_3 JRi_2 JRi_1 JRi_0 JWi_31 JWi_30 JWi_29 JWi_28 JWi_27 JWi_26 JWi_25 JWi_24 JWi_23 JWi_22 JWi_21 JWi_20 JWi_19 JWi_18 JWi_17 JWi_16 JWi_15 JWi_14 JWi_13 JWi_12 JWi_11 JWi_10 JWi_9 JWi_8 JWi_7 JWi_6 JWi_5 JWi_4 JWi_3 JWi_2 JWi_1 JWi_0 KRv KWv Reset
    I19 (JRi_15 JRi_14 JRi_13 JRi_12 JRi_11 JRi_10 JRi_9 JRi_8 JRi_7 JRi_6 JRi_5 JRi_4 JRi_3 JRi_2 JRi_1 JRi_0 RSel_0 I_Read_3 I_Read_2 I_Read_1 I_Read_0 net20) Decode_4to16
    I25 (JRi_31 JRi_30 JRi_29 JRi_28 JRi_27 JRi_26 JRi_25 JRi_24 JRi_23 JRi_22 JRi_21 JRi_20 JRi_19 JRi_18 JRi_17 JRi_16 RSel_1 I_Read_3 I_Read_2 I_Read_1 I_Read_0 net21) Decode_4to16
    I11 (JWi_31 JWi_30 JWi_29 JWi_28 JWi_27 JWi_26 JWi_25 JWi_24 JWi_23 JWi_22 JWi_21 JWi_20 JWi_19 JWi_18 JWi_17 JWi_16 WSel_1 I_Write_3 I_Write_2 I_Write_1 I_Write_0 Reset) Decode_4to16
    I5 (JWi_15 JWi_14 JWi_13 JWi_12 JWi_11 JWi_10 JWi_9 JWi_8 JWi_7 JWi_6 JWi_5 JWi_4 JWi_3 JWi_2 JWi_1 JWi_0 WSel_0 I_Write_3 I_Write_2 I_Write_1 I_Write_0 Reset) Decode_4to16
    I16 (GoR I_Read_4 RSel_1 RSel_0) Decode_1to2
    I2 (GoW I_Write_4 WSel_1 WSel_0) Decode_1to2
    I17 (rn1 rn2 rn3 rn4 rn9) and4_1x
    I24 (rn5 rn6 rn7 rn8 rn10) and4_1x
    I3 (wn1 wn2 wn3 wn4 wn9) and4_1x
    I10 (wn5 wn6 wn7 wn8 wn10) and4_1x
    I14 (JRi_0 JRi_1 JRi_2 JRi_3 rn1) nor4_1x
    I15 (JRi_4 JRi_5 JRi_6 JRi_7 rn2) nor4_1x
    I18 (JRi_8 JRi_9 JRi_10 JRi_11 rn3) nor4_1x
    I20 (JRi_12 JRi_13 JRi_14 JRi_15 rn4) nor4_1x
    I22 (JRi_16 JRi_17 JRi_18 JRi_19 rn5) nor4_1x
    I23 (JRi_20 JRi_21 JRi_22 JRi_23 rn6) nor4_1x
    I26 (JRi_24 JRi_25 JRi_26 JRi_27 rn7) nor4_1x
    I13 (JWi_28 JWi_29 JWi_30 JWi_31 wn8) nor4_1x
    I12 (JWi_24 JWi_25 JWi_26 JWi_27 wn7) nor4_1x
    I9 (JWi_20 JWi_21 JWi_22 JWi_23 wn6) nor4_1x
    I8 (JWi_16 JWi_17 JWi_18 JWi_19 wn5) nor4_1x
    I6 (JWi_12 JWi_13 JWi_14 JWi_15 wn4) nor4_1x
    I4 (JWi_8 JWi_9 JWi_10 JWi_11 wn3) nor4_1x
    I0 (JWi_0 JWi_1 JWi_2 JWi_3 wn1) nor4_1x
    I1 (JWi_4 JWi_5 JWi_6 JWi_7 wn2) nor4_1x
    I27 (JRi_28 JRi_29 JRi_30 JRi_31 rn8) nor4_1x
    I21 (rn9 rn10 KRv) nand_1x
    I7 (wn9 wn10 KWv) nand_1x
ends _sub142

// 16nm/10T_RPrecharge/schematic
//system verilogNetlist schematic cmos.sch cmos_sch veriloga ahdl
subckt _sub143 Re Re2 \~R0 \~R1
    I1 (\~R1 Pch vdd! vdd!) pfet w=100n l=20n nfin=1 m=1 degradation=yes
    I0 (\~R0 Pch vdd! vdd!) pfet w=100n l=20n nfin=1 m=1 degradation=yes
    I3 (Re2 Re Pch) TH22
ends _sub143

// 16nm/10T_DUAL_SRAM_RPrecharge/schematic
//system verilogNetlist schematic cmos.sch cmos_sch veriloga ahdl
subckt _sub144 Re Re2_7 Re2_6 Re2_5 Re2_4 Re2_3 Re2_2 Re2_1 Re2_0 \~R0_31 \~R0_30 \~R0_29 \~R0_28 \~R0_27 \~R0_26 \~R0_25 \~R0_24 \~R0_23 \~R0_22 \~R0_21 \~R0_20 \~R0_19 \~R0_18 \~R0_17 \~R0_16 \~R0_15 \~R0_14 \~R0_13 \~R0_12 \~R0_11 \~R0_10 \~R0_9 \~R0_8 \~R0_7 \~R0_6 \~R0_5 \~R0_4 \~R0_3 \~R0_2 \~R0_1 \~R0_0 \~R1_31 \~R1_30 \~R1_29 \~R1_28 \~R1_27 \~R1_26 \~R1_25 \~R1_24 \~R1_23 \~R1_22 \~R1_21 \~R1_20 \~R1_19 \~R1_18 \~R1_17 \~R1_16 \~R1_15 \~R1_14 \~R1_13 \~R1_12 \~R1_11 \~R1_10 \~R1_9 \~R1_8 \~R1_7 \~R1_6 \~R1_5 \~R1_4 \~R1_3 \~R1_2 \~R1_1 \~R1_0
    I3_3 (Re Re2_0 \~R0_3 \~R1_3) _sub143
    I3_2 (Re Re2_0 \~R0_2 \~R1_2) _sub143
    I3_1 (Re Re2_0 \~R0_1 \~R1_1) _sub143
    I3_0 (Re Re2_0 \~R0_0 \~R1_0) _sub143
    I4_3 (Re Re2_1 \~R0_7 \~R1_7) _sub143
    I4_2 (Re Re2_1 \~R0_6 \~R1_6) _sub143
    I4_1 (Re Re2_1 \~R0_5 \~R1_5) _sub143
    I4_0 (Re Re2_1 \~R0_4 \~R1_4) _sub143
    I5_3 (Re Re2_2 \~R0_11 \~R1_11) _sub143
    I5_2 (Re Re2_2 \~R0_10 \~R1_10) _sub143
    I5_1 (Re Re2_2 \~R0_9 \~R1_9) _sub143
    I5_0 (Re Re2_2 \~R0_8 \~R1_8) _sub143
    I6_3 (Re Re2_3 \~R0_15 \~R1_15) _sub143
    I6_2 (Re Re2_3 \~R0_14 \~R1_14) _sub143
    I6_1 (Re Re2_3 \~R0_13 \~R1_13) _sub143
    I6_0 (Re Re2_3 \~R0_12 \~R1_12) _sub143
    I7_3 (Re Re2_4 \~R0_19 \~R1_19) _sub143
    I7_2 (Re Re2_4 \~R0_18 \~R1_18) _sub143
    I7_1 (Re Re2_4 \~R0_17 \~R1_17) _sub143
    I7_0 (Re Re2_4 \~R0_16 \~R1_16) _sub143
    I8_3 (Re Re2_5 \~R0_23 \~R1_23) _sub143
    I8_2 (Re Re2_5 \~R0_22 \~R1_22) _sub143
    I8_1 (Re Re2_5 \~R0_21 \~R1_21) _sub143
    I8_0 (Re Re2_5 \~R0_20 \~R1_20) _sub143
    I9_3 (Re Re2_6 \~R0_27 \~R1_27) _sub143
    I9_2 (Re Re2_6 \~R0_26 \~R1_26) _sub143
    I9_1 (Re Re2_6 \~R0_25 \~R1_25) _sub143
    I9_0 (Re Re2_6 \~R0_24 \~R1_24) _sub143
    I10_3 (Re Re2_7 \~R0_31 \~R1_31) _sub143
    I10_2 (Re Re2_7 \~R0_30 \~R1_30) _sub143
    I10_1 (Re Re2_7 \~R0_29 \~R1_29) _sub143
    I10_0 (Re Re2_7 \~R0_28 \~R1_28) _sub143
ends _sub144

// 16nm/10T_DUAL_SRAM_REGFILE/schematic
//system verilogNetlist schematic cmos.sch cmos_sch veriloga ahdl
subckt _sub145 GoR GoW KRe KWe R0_31 R0_30 R0_29 R0_28 R0_27 R0_26 R0_25 R0_24 R0_23 R0_22 R0_21 R0_20 R0_19 R0_18 R0_17 R0_16 R0_15 R0_14 R0_13 R0_12 R0_11 R0_10 R0_9 R0_8 R0_7 R0_6 R0_5 R0_4 R0_3 R0_2 R0_1 R0_0 R1_31 R1_30 R1_29 R1_28 R1_27 R1_26 R1_25 R1_24 R1_23 R1_22 R1_21 R1_20 R1_19 R1_18 R1_17 R1_16 R1_15 R1_14 R1_13 R1_12 R1_11 R1_10 R1_9 R1_8 R1_7 R1_6 R1_5 R1_4 R1_3 R1_2 R1_1 R1_0 R_Addr_4 R_Addr_3 R_Addr_2 R_Addr_1 R_Addr_0 Re Reset W0_31 W0_30 W0_29 W0_28 W0_27 W0_26 W0_25 W0_24 W0_23 W0_22 W0_21 W0_20 W0_19 W0_18 W0_17 W0_16 W0_15 W0_14 W0_13 W0_12 W0_11 W0_10 W0_9 W0_8 W0_7 W0_6 W0_5 W0_4 W0_3 W0_2 W0_1 W0_0 W1_31 W1_30 W1_29 W1_28 W1_27 W1_26 W1_25 W1_24 W1_23 W1_22 W1_21 W1_20 W1_19 W1_18 W1_17 W1_16 W1_15 W1_14 W1_13 W1_12 W1_11 W1_10 W1_9 W1_8 W1_7 W1_6 W1_5 W1_4 W1_3 W1_2 W1_1 W1_0 W_Addr_4 W_Addr_3 W_Addr_2 W_Addr_1 W_Addr_0 We_7 We_6 We_5 We_4 We_3 We_2 We_1 We_0
    I0 (KRe KRv KWe KWv R0_31 R0_30 R0_29 R0_28 R0_27 R0_26 R0_25 R0_24 R0_23 R0_22 R0_21 R0_20 R0_19 R0_18 R0_17 R0_16 R0_15 R0_14 R0_13 R0_12 R0_11 R0_10 R0_9 R0_8 R0_7 R0_6 R0_5 R0_4 R0_3 R0_2 R0_1 R0_0 R1_31 R1_30 R1_29 R1_28 R1_27 R1_26 R1_25 R1_24 R1_23 R1_22 R1_21 R1_20 R1_19 R1_18 R1_17 R1_16 R1_15 R1_14 R1_13 R1_12 R1_11 R1_10 R1_9 R1_8 R1_7 R1_6 R1_5 R1_4 R1_3 R1_2 R1_1 R1_0 Re2_7 Re2_6 Re2_5 Re2_4 Re2_3 Re2_2 Re2_1 Re2_0 W0_31 W0_30 W0_29 W0_28 W0_27 W0_26 W0_25 W0_24 W0_23 W0_22 W0_21 W0_20 W0_19 W0_18 W0_17 W0_16 W0_15 W0_14 W0_13 W0_12 W0_11 W0_10 W0_9 W0_8 W0_7 W0_6 W0_5 W0_4 W0_3 W0_2 W0_1 W0_0 W1_31 W1_30 W1_29 W1_28 W1_27 W1_26 W1_25 W1_24 W1_23 W1_22 W1_21 W1_20 W1_19 W1_18 W1_17 W1_16 W1_15 W1_14 W1_13 W1_12 W1_11 W1_10 W1_9 W1_8 W1_7 W1_6 W1_5 W1_4 W1_3 W1_2 W1_1 W1_0 We_7 We_6 We_5 We_4 We_3 We_2 We_1 We_0 \~R0_31 \~R0_30 \~R0_29 \~R0_28 \~R0_27 \~R0_26 \~R0_25 \~R0_24 \~R0_23 \~R0_22 \~R0_21 \~R0_20 \~R0_19 \~R0_18 \~R0_17 \~R0_16 \~R0_15 \~R0_14 \~R0_13 \~R0_12 \~R0_11 \~R0_10 \~R0_9 \~R0_8 \~R0_7 \~R0_6 \~R0_5 \~R0_4 \~R0_3 \~R0_2 \~R0_1 \~R0_0 \~R1_31 \~R1_30 \~R1_29 \~R1_28 \~R1_27 \~R1_26 \~R1_25 \~R1_24 \~R1_23 \~R1_22 \~R1_21 \~R1_20 \~R1_19 \~R1_18 \~R1_17 \~R1_16 \~R1_15 \~R1_14 \~R1_13 \~R1_12 \~R1_11 \~R1_10 \~R1_9 \~R1_8 \~R1_7 \~R1_6 \~R1_5 \~R1_4 \~R1_3 \~R1_2 \~R1_1 \~R1_0 \~W0_31 \~W0_30 \~W0_29 \~W0_28 \~W0_27 \~W0_26 \~W0_25 \~W0_24 \~W0_23 \~W0_22 \~W0_21 \~W0_20 \~W0_19 \~W0_18 \~W0_17 \~W0_16 \~W0_15 \~W0_14 \~W0_13 \~W0_12 \~W0_11 \~W0_10 \~W0_9 \~W0_8 \~W0_7 \~W0_6 \~W0_5 \~W0_4 \~W0_3 \~W0_2 \~W0_1 \~W0_0 \~W1_31 \~W1_30 \~W1_29 \~W1_28 \~W1_27 \~W1_26 \~W1_25 \~W1_24 \~W1_23 \~W1_22 \~W1_21 \~W1_20 \~W1_19 \~W1_18 \~W1_17 \~W1_16 \~W1_15 \~W1_14 \~W1_13 \~W1_12 \~W1_11 \~W1_10 \~W1_9 \~W1_8 \~W1_7 \~W1_6 \~W1_5 \~W1_4 \~W1_3 \~W1_2 \~W1_1 \~W1_0) _sub138
    I1 (JRi_31 JRi_30 JRi_29 JRi_28 JRi_27 JRi_26 JRi_25 JRi_24 JRi_23 JRi_22 JRi_21 JRi_20 JRi_19 JRi_18 JRi_17 JRi_16 JRi_15 JRi_14 JRi_13 JRi_12 JRi_11 JRi_10 JRi_9 JRi_8 JRi_7 JRi_6 JRi_5 JRi_4 JRi_3 JRi_2 JRi_1 JRi_0 JWi_31 JWi_30 JWi_29 JWi_28 JWi_27 JWi_26 JWi_25 JWi_24 JWi_23 JWi_22 JWi_21 JWi_20 JWi_19 JWi_18 JWi_17 JWi_16 JWi_15 JWi_14 JWi_13 JWi_12 JWi_11 JWi_10 JWi_9 JWi_8 JWi_7 JWi_6 JWi_5 JWi_4 JWi_3 JWi_2 JWi_1 JWi_0 \~R0_31 \~R0_30 \~R0_29 \~R0_28 \~R0_27 \~R0_26 \~R0_25 \~R0_24 \~R0_23 \~R0_22 \~R0_21 \~R0_20 \~R0_19 \~R0_18 \~R0_17 \~R0_16 \~R0_15 \~R0_14 \~R0_13 \~R0_12 \~R0_11 \~R0_10 \~R0_9 \~R0_8 \~R0_7 \~R0_6 \~R0_5 \~R0_4 \~R0_3 \~R0_2 \~R0_1 \~R0_0 \~R1_31 \~R1_30 \~R1_29 \~R1_28 \~R1_27 \~R1_26 \~R1_25 \~R1_24 \~R1_23 \~R1_22 \~R1_21 \~R1_20 \~R1_19 \~R1_18 \~R1_17 \~R1_16 \~R1_15 \~R1_14 \~R1_13 \~R1_12 \~R1_11 \~R1_10 \~R1_9 \~R1_8 \~R1_7 \~R1_6 \~R1_5 \~R1_4 \~R1_3 \~R1_2 \~R1_1 \~R1_0 \~W0_31 \~W0_30 \~W0_29 \~W0_28 \~W0_27 \~W0_26 \~W0_25 \~W0_24 \~W0_23 \~W0_22 \~W0_21 \~W0_20 \~W0_19 \~W0_18 \~W0_17 \~W0_16 \~W0_15 \~W0_14 \~W0_13 \~W0_12 \~W0_11 \~W0_10 \~W0_9 \~W0_8 \~W0_7 \~W0_6 \~W0_5 \~W0_4 \~W0_3 \~W0_2 \~W0_1 \~W0_0 \~W1_31 \~W1_30 \~W1_29 \~W1_28 \~W1_27 \~W1_26 \~W1_25 \~W1_24 \~W1_23 \~W1_22 \~W1_21 \~W1_20 \~W1_19 \~W1_18 \~W1_17 \~W1_16 \~W1_15 \~W1_14 \~W1_13 \~W1_12 \~W1_11 \~W1_10 \~W1_9 \~W1_8 \~W1_7 \~W1_6 \~W1_5 \~W1_4 \~W1_3 \~W1_2 \~W1_1 \~W1_0) _sub141
    I2 (GoR GoW R_Addr_4 R_Addr_3 R_Addr_2 R_Addr_1 R_Addr_0 W_Addr_4 W_Addr_3 W_Addr_2 W_Addr_1 W_Addr_0 JRi_31 JRi_30 JRi_29 JRi_28 JRi_27 JRi_26 JRi_25 JRi_24 JRi_23 JRi_22 JRi_21 JRi_20 JRi_19 JRi_18 JRi_17 JRi_16 JRi_15 JRi_14 JRi_13 JRi_12 JRi_11 JRi_10 JRi_9 JRi_8 JRi_7 JRi_6 JRi_5 JRi_4 JRi_3 JRi_2 JRi_1 JRi_0 JWi_31 JWi_30 JWi_29 JWi_28 JWi_27 JWi_26 JWi_25 JWi_24 JWi_23 JWi_22 JWi_21 JWi_20 JWi_19 JWi_18 JWi_17 JWi_16 JWi_15 JWi_14 JWi_13 JWi_12 JWi_11 JWi_10 JWi_9 JWi_8 JWi_7 JWi_6 JWi_5 JWi_4 JWi_3 JWi_2 JWi_1 JWi_0 KRv KWv Reset) _sub142
    I3 (Re Re2_7 Re2_6 Re2_5 Re2_4 Re2_3 Re2_2 Re2_1 Re2_0 \~R0_31 \~R0_30 \~R0_29 \~R0_28 \~R0_27 \~R0_26 \~R0_25 \~R0_24 \~R0_23 \~R0_22 \~R0_21 \~R0_20 \~R0_19 \~R0_18 \~R0_17 \~R0_16 \~R0_15 \~R0_14 \~R0_13 \~R0_12 \~R0_11 \~R0_10 \~R0_9 \~R0_8 \~R0_7 \~R0_6 \~R0_5 \~R0_4 \~R0_3 \~R0_2 \~R0_1 \~R0_0 \~R1_31 \~R1_30 \~R1_29 \~R1_28 \~R1_27 \~R1_26 \~R1_25 \~R1_24 \~R1_23 \~R1_22 \~R1_21 \~R1_20 \~R1_19 \~R1_18 \~R1_17 \~R1_16 \~R1_15 \~R1_14 \~R1_13 \~R1_12 \~R1_11 \~R1_10 \~R1_9 \~R1_8 \~R1_7 \~R1_6 \~R1_5 \~R1_4 \~R1_3 \~R1_2 \~R1_1 \~R1_0) _sub144
ends _sub145

// 16nm/and3_1x/schematic
//system verilogNetlist schematic cmos.sch cmos_sch veriloga ahdl
subckt and3_1x A B C Y
    I6 (A B C net1) nand3_1x
    I7 (net1 Y) inv_1x
ends and3_1x

// 16nm/Decode_2to4/schematic
//system verilogNetlist schematic cmos.sch cmos_sch veriloga ahdl
subckt Decode_2to4 I_1 I_0 Sel_3 Sel_2 Sel_1 Sel_0 En
    I5 (I_1 net6) inv_1x
    I4 (I_0 net10) inv_1x
    I3 (I_0 En I_1 Sel_3) and3_1x
    I2 (net10 En I_1 Sel_2) and3_1x
    I1 (I_0 En net6 Sel_1) and3_1x
    I0 (net10 En net6 Sel_0) and3_1x
ends Decode_2to4

// 16nm/Mux_128to32/schematic
//system verilogNetlist schematic cmos.sch cmos_sch veriloga ahdl
subckt Mux_128to32 En S_1 S_0 X1_31 X1_30 X1_29 X1_28 X1_27 X1_26 X1_25 X1_24 X1_23 X1_22 X1_21 X1_20 X1_19 X1_18 X1_17 X1_16 X1_15 X1_14 X1_13 X1_12 X1_11 X1_10 X1_9 X1_8 X1_7 X1_6 X1_5 X1_4 X1_3 X1_2 X1_1 X1_0 X2_31 X2_30 X2_29 X2_28 X2_27 X2_26 X2_25 X2_24 X2_23 X2_22 X2_21 X2_20 X2_19 X2_18 X2_17 X2_16 X2_15 X2_14 X2_13 X2_12 X2_11 X2_10 X2_9 X2_8 X2_7 X2_6 X2_5 X2_4 X2_3 X2_2 X2_1 X2_0 X3_31 X3_30 X3_29 X3_28 X3_27 X3_26 X3_25 X3_24 X3_23 X3_22 X3_21 X3_20 X3_19 X3_18 X3_17 X3_16 X3_15 X3_14 X3_13 X3_12 X3_11 X3_10 X3_9 X3_8 X3_7 X3_6 X3_5 X3_4 X3_3 X3_2 X3_1 X3_0 X4_31 X4_30 X4_29 X4_28 X4_27 X4_26 X4_25 X4_24 X4_23 X4_22 X4_21 X4_20 X4_19 X4_18 X4_17 X4_16 X4_15 X4_14 X4_13 X4_12 X4_11 X4_10 X4_9 X4_8 X4_7 X4_6 X4_5 X4_4 X4_3 X4_2 X4_1 X4_0 Y_31 Y_30 Y_29 Y_28 Y_27 Y_26 Y_25 Y_24 Y_23 Y_22 Y_21 Y_20 Y_19 Y_18 Y_17 Y_16 Y_15 Y_14 Y_13 Y_12 Y_11 Y_10 Y_9 Y_8 Y_7 Y_6 Y_5 Y_4 Y_3 Y_2 Y_1 Y_0
    I4_1 (S_1 \~S_1) inv_1x
    I4_0 (S_0 \~S_0) inv_1x
    I0_31 (X1_31 En \~S_0 \~S_1 net25_0) nand4_1x
    I0_30 (X1_30 En \~S_0 \~S_1 net25_1) nand4_1x
    I0_29 (X1_29 En \~S_0 \~S_1 net25_2) nand4_1x
    I0_28 (X1_28 En \~S_0 \~S_1 net25_3) nand4_1x
    I0_27 (X1_27 En \~S_0 \~S_1 net25_4) nand4_1x
    I0_26 (X1_26 En \~S_0 \~S_1 net25_5) nand4_1x
    I0_25 (X1_25 En \~S_0 \~S_1 net25_6) nand4_1x
    I0_24 (X1_24 En \~S_0 \~S_1 net25_7) nand4_1x
    I0_23 (X1_23 En \~S_0 \~S_1 net25_8) nand4_1x
    I0_22 (X1_22 En \~S_0 \~S_1 net25_9) nand4_1x
    I0_21 (X1_21 En \~S_0 \~S_1 net25_10) nand4_1x
    I0_20 (X1_20 En \~S_0 \~S_1 net25_11) nand4_1x
    I0_19 (X1_19 En \~S_0 \~S_1 net25_12) nand4_1x
    I0_18 (X1_18 En \~S_0 \~S_1 net25_13) nand4_1x
    I0_17 (X1_17 En \~S_0 \~S_1 net25_14) nand4_1x
    I0_16 (X1_16 En \~S_0 \~S_1 net25_15) nand4_1x
    I0_15 (X1_15 En \~S_0 \~S_1 net25_16) nand4_1x
    I0_14 (X1_14 En \~S_0 \~S_1 net25_17) nand4_1x
    I0_13 (X1_13 En \~S_0 \~S_1 net25_18) nand4_1x
    I0_12 (X1_12 En \~S_0 \~S_1 net25_19) nand4_1x
    I0_11 (X1_11 En \~S_0 \~S_1 net25_20) nand4_1x
    I0_10 (X1_10 En \~S_0 \~S_1 net25_21) nand4_1x
    I0_9 (X1_9 En \~S_0 \~S_1 net25_22) nand4_1x
    I0_8 (X1_8 En \~S_0 \~S_1 net25_23) nand4_1x
    I0_7 (X1_7 En \~S_0 \~S_1 net25_24) nand4_1x
    I0_6 (X1_6 En \~S_0 \~S_1 net25_25) nand4_1x
    I0_5 (X1_5 En \~S_0 \~S_1 net25_26) nand4_1x
    I0_4 (X1_4 En \~S_0 \~S_1 net25_27) nand4_1x
    I0_3 (X1_3 En \~S_0 \~S_1 net25_28) nand4_1x
    I0_2 (X1_2 En \~S_0 \~S_1 net25_29) nand4_1x
    I0_1 (X1_1 En \~S_0 \~S_1 net25_30) nand4_1x
    I0_0 (X1_0 En \~S_0 \~S_1 net25_31) nand4_1x
    I6_31 (net25_0 net24_0 net23_0 net22_0 Y_31) nand4_1x
    I6_30 (net25_1 net24_1 net23_1 net22_1 Y_30) nand4_1x
    I6_29 (net25_2 net24_2 net23_2 net22_2 Y_29) nand4_1x
    I6_28 (net25_3 net24_3 net23_3 net22_3 Y_28) nand4_1x
    I6_27 (net25_4 net24_4 net23_4 net22_4 Y_27) nand4_1x
    I6_26 (net25_5 net24_5 net23_5 net22_5 Y_26) nand4_1x
    I6_25 (net25_6 net24_6 net23_6 net22_6 Y_25) nand4_1x
    I6_24 (net25_7 net24_7 net23_7 net22_7 Y_24) nand4_1x
    I6_23 (net25_8 net24_8 net23_8 net22_8 Y_23) nand4_1x
    I6_22 (net25_9 net24_9 net23_9 net22_9 Y_22) nand4_1x
    I6_21 (net25_10 net24_10 net23_10 net22_10 Y_21) nand4_1x
    I6_20 (net25_11 net24_11 net23_11 net22_11 Y_20) nand4_1x
    I6_19 (net25_12 net24_12 net23_12 net22_12 Y_19) nand4_1x
    I6_18 (net25_13 net24_13 net23_13 net22_13 Y_18) nand4_1x
    I6_17 (net25_14 net24_14 net23_14 net22_14 Y_17) nand4_1x
    I6_16 (net25_15 net24_15 net23_15 net22_15 Y_16) nand4_1x
    I6_15 (net25_16 net24_16 net23_16 net22_16 Y_15) nand4_1x
    I6_14 (net25_17 net24_17 net23_17 net22_17 Y_14) nand4_1x
    I6_13 (net25_18 net24_18 net23_18 net22_18 Y_13) nand4_1x
    I6_12 (net25_19 net24_19 net23_19 net22_19 Y_12) nand4_1x
    I6_11 (net25_20 net24_20 net23_20 net22_20 Y_11) nand4_1x
    I6_10 (net25_21 net24_21 net23_21 net22_21 Y_10) nand4_1x
    I6_9 (net25_22 net24_22 net23_22 net22_22 Y_9) nand4_1x
    I6_8 (net25_23 net24_23 net23_23 net22_23 Y_8) nand4_1x
    I6_7 (net25_24 net24_24 net23_24 net22_24 Y_7) nand4_1x
    I6_6 (net25_25 net24_25 net23_25 net22_25 Y_6) nand4_1x
    I6_5 (net25_26 net24_26 net23_26 net22_26 Y_5) nand4_1x
    I6_4 (net25_27 net24_27 net23_27 net22_27 Y_4) nand4_1x
    I6_3 (net25_28 net24_28 net23_28 net22_28 Y_3) nand4_1x
    I6_2 (net25_29 net24_29 net23_29 net22_29 Y_2) nand4_1x
    I6_1 (net25_30 net24_30 net23_30 net22_30 Y_1) nand4_1x
    I6_0 (net25_31 net24_31 net23_31 net22_31 Y_0) nand4_1x
    I3_31 (X4_31 En S_0 S_1 net22_0) nand4_1x
    I3_30 (X4_30 En S_0 S_1 net22_1) nand4_1x
    I3_29 (X4_29 En S_0 S_1 net22_2) nand4_1x
    I3_28 (X4_28 En S_0 S_1 net22_3) nand4_1x
    I3_27 (X4_27 En S_0 S_1 net22_4) nand4_1x
    I3_26 (X4_26 En S_0 S_1 net22_5) nand4_1x
    I3_25 (X4_25 En S_0 S_1 net22_6) nand4_1x
    I3_24 (X4_24 En S_0 S_1 net22_7) nand4_1x
    I3_23 (X4_23 En S_0 S_1 net22_8) nand4_1x
    I3_22 (X4_22 En S_0 S_1 net22_9) nand4_1x
    I3_21 (X4_21 En S_0 S_1 net22_10) nand4_1x
    I3_20 (X4_20 En S_0 S_1 net22_11) nand4_1x
    I3_19 (X4_19 En S_0 S_1 net22_12) nand4_1x
    I3_18 (X4_18 En S_0 S_1 net22_13) nand4_1x
    I3_17 (X4_17 En S_0 S_1 net22_14) nand4_1x
    I3_16 (X4_16 En S_0 S_1 net22_15) nand4_1x
    I3_15 (X4_15 En S_0 S_1 net22_16) nand4_1x
    I3_14 (X4_14 En S_0 S_1 net22_17) nand4_1x
    I3_13 (X4_13 En S_0 S_1 net22_18) nand4_1x
    I3_12 (X4_12 En S_0 S_1 net22_19) nand4_1x
    I3_11 (X4_11 En S_0 S_1 net22_20) nand4_1x
    I3_10 (X4_10 En S_0 S_1 net22_21) nand4_1x
    I3_9 (X4_9 En S_0 S_1 net22_22) nand4_1x
    I3_8 (X4_8 En S_0 S_1 net22_23) nand4_1x
    I3_7 (X4_7 En S_0 S_1 net22_24) nand4_1x
    I3_6 (X4_6 En S_0 S_1 net22_25) nand4_1x
    I3_5 (X4_5 En S_0 S_1 net22_26) nand4_1x
    I3_4 (X4_4 En S_0 S_1 net22_27) nand4_1x
    I3_3 (X4_3 En S_0 S_1 net22_28) nand4_1x
    I3_2 (X4_2 En S_0 S_1 net22_29) nand4_1x
    I3_1 (X4_1 En S_0 S_1 net22_30) nand4_1x
    I3_0 (X4_0 En S_0 S_1 net22_31) nand4_1x
    I2_31 (X3_31 En \~S_0 S_1 net23_0) nand4_1x
    I2_30 (X3_30 En \~S_0 S_1 net23_1) nand4_1x
    I2_29 (X3_29 En \~S_0 S_1 net23_2) nand4_1x
    I2_28 (X3_28 En \~S_0 S_1 net23_3) nand4_1x
    I2_27 (X3_27 En \~S_0 S_1 net23_4) nand4_1x
    I2_26 (X3_26 En \~S_0 S_1 net23_5) nand4_1x
    I2_25 (X3_25 En \~S_0 S_1 net23_6) nand4_1x
    I2_24 (X3_24 En \~S_0 S_1 net23_7) nand4_1x
    I2_23 (X3_23 En \~S_0 S_1 net23_8) nand4_1x
    I2_22 (X3_22 En \~S_0 S_1 net23_9) nand4_1x
    I2_21 (X3_21 En \~S_0 S_1 net23_10) nand4_1x
    I2_20 (X3_20 En \~S_0 S_1 net23_11) nand4_1x
    I2_19 (X3_19 En \~S_0 S_1 net23_12) nand4_1x
    I2_18 (X3_18 En \~S_0 S_1 net23_13) nand4_1x
    I2_17 (X3_17 En \~S_0 S_1 net23_14) nand4_1x
    I2_16 (X3_16 En \~S_0 S_1 net23_15) nand4_1x
    I2_15 (X3_15 En \~S_0 S_1 net23_16) nand4_1x
    I2_14 (X3_14 En \~S_0 S_1 net23_17) nand4_1x
    I2_13 (X3_13 En \~S_0 S_1 net23_18) nand4_1x
    I2_12 (X3_12 En \~S_0 S_1 net23_19) nand4_1x
    I2_11 (X3_11 En \~S_0 S_1 net23_20) nand4_1x
    I2_10 (X3_10 En \~S_0 S_1 net23_21) nand4_1x
    I2_9 (X3_9 En \~S_0 S_1 net23_22) nand4_1x
    I2_8 (X3_8 En \~S_0 S_1 net23_23) nand4_1x
    I2_7 (X3_7 En \~S_0 S_1 net23_24) nand4_1x
    I2_6 (X3_6 En \~S_0 S_1 net23_25) nand4_1x
    I2_5 (X3_5 En \~S_0 S_1 net23_26) nand4_1x
    I2_4 (X3_4 En \~S_0 S_1 net23_27) nand4_1x
    I2_3 (X3_3 En \~S_0 S_1 net23_28) nand4_1x
    I2_2 (X3_2 En \~S_0 S_1 net23_29) nand4_1x
    I2_1 (X3_1 En \~S_0 S_1 net23_30) nand4_1x
    I2_0 (X3_0 En \~S_0 S_1 net23_31) nand4_1x
    I1_31 (X2_31 En S_0 \~S_1 net24_0) nand4_1x
    I1_30 (X2_30 En S_0 \~S_1 net24_1) nand4_1x
    I1_29 (X2_29 En S_0 \~S_1 net24_2) nand4_1x
    I1_28 (X2_28 En S_0 \~S_1 net24_3) nand4_1x
    I1_27 (X2_27 En S_0 \~S_1 net24_4) nand4_1x
    I1_26 (X2_26 En S_0 \~S_1 net24_5) nand4_1x
    I1_25 (X2_25 En S_0 \~S_1 net24_6) nand4_1x
    I1_24 (X2_24 En S_0 \~S_1 net24_7) nand4_1x
    I1_23 (X2_23 En S_0 \~S_1 net24_8) nand4_1x
    I1_22 (X2_22 En S_0 \~S_1 net24_9) nand4_1x
    I1_21 (X2_21 En S_0 \~S_1 net24_10) nand4_1x
    I1_20 (X2_20 En S_0 \~S_1 net24_11) nand4_1x
    I1_19 (X2_19 En S_0 \~S_1 net24_12) nand4_1x
    I1_18 (X2_18 En S_0 \~S_1 net24_13) nand4_1x
    I1_17 (X2_17 En S_0 \~S_1 net24_14) nand4_1x
    I1_16 (X2_16 En S_0 \~S_1 net24_15) nand4_1x
    I1_15 (X2_15 En S_0 \~S_1 net24_16) nand4_1x
    I1_14 (X2_14 En S_0 \~S_1 net24_17) nand4_1x
    I1_13 (X2_13 En S_0 \~S_1 net24_18) nand4_1x
    I1_12 (X2_12 En S_0 \~S_1 net24_19) nand4_1x
    I1_11 (X2_11 En S_0 \~S_1 net24_20) nand4_1x
    I1_10 (X2_10 En S_0 \~S_1 net24_21) nand4_1x
    I1_9 (X2_9 En S_0 \~S_1 net24_22) nand4_1x
    I1_8 (X2_8 En S_0 \~S_1 net24_23) nand4_1x
    I1_7 (X2_7 En S_0 \~S_1 net24_24) nand4_1x
    I1_6 (X2_6 En S_0 \~S_1 net24_25) nand4_1x
    I1_5 (X2_5 En S_0 \~S_1 net24_26) nand4_1x
    I1_4 (X2_4 En S_0 \~S_1 net24_27) nand4_1x
    I1_3 (X2_3 En S_0 \~S_1 net24_28) nand4_1x
    I1_2 (X2_2 En S_0 \~S_1 net24_29) nand4_1x
    I1_1 (X2_1 En S_0 \~S_1 net24_30) nand4_1x
    I1_0 (X2_0 En S_0 \~S_1 net24_31) nand4_1x
ends Mux_128to32

// 16nm/Dcache_TagMem/schematic
//system verilogNetlist schematic cmos.sch cmos_sch veriloga ahdl
subckt Dcache_TagMem GoR GoW \~KRe \~KWe R1_31 R1_30 R1_29 R1_28 R1_27 R1_26 R1_25 R1_24 R1_23 R1_22 R1_21 R1_20 R1_19 R1_18 R1_17 R1_16 R1_15 R1_14 R1_13 R1_12 R1_11 R1_10 R1_9 R1_8 R1_7 R1_6 R1_5 R1_4 R1_3 R1_2 R1_1 R1_0 R_Addr_6 R_Addr_5 R_Addr_4 R_Addr_3 R_Addr_2 R_Addr_1 R_Addr_0 Reset W0_31 W0_30 W0_29 W0_28 W0_27 W0_26 W0_25 W0_24 W0_23 W0_22 W0_21 W0_20 W0_19 W0_18 W0_17 W0_16 W0_15 W0_14 W0_13 W0_12 W0_11 W0_10 W0_9 W0_8 W0_7 W0_6 W0_5 W0_4 W0_3 W0_2 W0_1 W0_0 W1_31 W1_30 W1_29 W1_28 W1_27 W1_26 W1_25 W1_24 W1_23 W1_22 W1_21 W1_20 W1_19 W1_18 W1_17 W1_16 W1_15 W1_14 W1_13 W1_12 W1_11 W1_10 W1_9 W1_8 W1_7 W1_6 W1_5 W1_4 W1_3 W1_2 W1_1 W1_0 W_Addr_6 W_Addr_5 W_Addr_4 W_Addr_3 W_Addr_2 W_Addr_1 W_Addr_0 R0_31 R0_30 R0_29 R0_28 R0_27 R0_26 R0_25 R0_24 R0_23 R0_22 R0_21 R0_20 R0_19 R0_18 R0_17 R0_16 R0_15 R0_14 R0_13 R0_12 R0_11 R0_10 R0_9 R0_8 R0_7 R0_6 R0_5 R0_4 R0_3 R0_2 R0_1 R0_0
    I0 (Rs_0 Ws_0 KR_0 KW_0 RO_Reg1_31 RO_Reg1_30 RO_Reg1_29 RO_Reg1_28 RO_Reg1_27 RO_Reg1_26 RO_Reg1_25 RO_Reg1_24 RO_Reg1_23 RO_Reg1_22 RO_Reg1_21 RO_Reg1_20 RO_Reg1_19 RO_Reg1_18 RO_Reg1_17 RO_Reg1_16 RO_Reg1_15 RO_Reg1_14 RO_Reg1_13 RO_Reg1_12 RO_Reg1_11 RO_Reg1_10 RO_Reg1_9 RO_Reg1_8 RO_Reg1_7 RO_Reg1_6 RO_Reg1_5 RO_Reg1_4 RO_Reg1_3 RO_Reg1_2 RO_Reg1_1 RO_Reg1_0 R1_Reg1_31 R1_Reg1_30 R1_Reg1_29 R1_Reg1_28 R1_Reg1_27 R1_Reg1_26 R1_Reg1_25 R1_Reg1_24 R1_Reg1_23 R1_Reg1_22 R1_Reg1_21 R1_Reg1_20 R1_Reg1_19 R1_Reg1_18 R1_Reg1_17 R1_Reg1_16 R1_Reg1_15 R1_Reg1_14 R1_Reg1_13 R1_Reg1_12 R1_Reg1_11 R1_Reg1_10 R1_Reg1_9 R1_Reg1_8 R1_Reg1_7 R1_Reg1_6 R1_Reg1_5 R1_Reg1_4 R1_Reg1_3 R1_Reg1_2 R1_Reg1_1 R1_Reg1_0 R_Addr_4 R_Addr_3 R_Addr_2 R_Addr_1 R_Addr_0 Rs_0 Reset W0_31 W0_30 W0_29 W0_28 W0_27 W0_26 W0_25 W0_24 W0_23 W0_22 W0_21 W0_20 W0_19 W0_18 W0_17 W0_16 W0_15 W0_14 W0_13 W0_12 W0_11 W0_10 W0_9 W0_8 W0_7 W0_6 W0_5 W0_4 W0_3 W0_2 W0_1 W0_0 W1_31 W1_30 W1_29 W1_28 W1_27 W1_26 W1_25 W1_24 W1_23 W1_22 W1_21 W1_20 W1_19 W1_18 W1_17 W1_16 W1_15 W1_14 W1_13 W1_12 W1_11 W1_10 W1_9 W1_8 W1_7 W1_6 W1_5 W1_4 W1_3 W1_2 W1_1 W1_0 W_Addr_4 W_Addr_3 W_Addr_2 W_Addr_1 W_Addr_0 net59_0 net59_1 net59_2 net59_3 net59_4 net59_5 net59_6 net59_7) _sub145
    I2 (Rs_1 Ws_1 KR_1 KW_1 RO_Reg2_31 RO_Reg2_30 RO_Reg2_29 RO_Reg2_28 RO_Reg2_27 RO_Reg2_26 RO_Reg2_25 RO_Reg2_24 RO_Reg2_23 RO_Reg2_22 RO_Reg2_21 RO_Reg2_20 RO_Reg2_19 RO_Reg2_18 RO_Reg2_17 RO_Reg2_16 RO_Reg2_15 RO_Reg2_14 RO_Reg2_13 RO_Reg2_12 RO_Reg2_11 RO_Reg2_10 RO_Reg2_9 RO_Reg2_8 RO_Reg2_7 RO_Reg2_6 RO_Reg2_5 RO_Reg2_4 RO_Reg2_3 RO_Reg2_2 RO_Reg2_1 RO_Reg2_0 R1_Reg2_31 R1_Reg2_30 R1_Reg2_29 R1_Reg2_28 R1_Reg2_27 R1_Reg2_26 R1_Reg2_25 R1_Reg2_24 R1_Reg2_23 R1_Reg2_22 R1_Reg2_21 R1_Reg2_20 R1_Reg2_19 R1_Reg2_18 R1_Reg2_17 R1_Reg2_16 R1_Reg2_15 R1_Reg2_14 R1_Reg2_13 R1_Reg2_12 R1_Reg2_11 R1_Reg2_10 R1_Reg2_9 R1_Reg2_8 R1_Reg2_7 R1_Reg2_6 R1_Reg2_5 R1_Reg2_4 R1_Reg2_3 R1_Reg2_2 R1_Reg2_1 R1_Reg2_0 R_Addr_4 R_Addr_3 R_Addr_2 R_Addr_1 R_Addr_0 Rs_1 Reset W0_31 W0_30 W0_29 W0_28 W0_27 W0_26 W0_25 W0_24 W0_23 W0_22 W0_21 W0_20 W0_19 W0_18 W0_17 W0_16 W0_15 W0_14 W0_13 W0_12 W0_11 W0_10 W0_9 W0_8 W0_7 W0_6 W0_5 W0_4 W0_3 W0_2 W0_1 W0_0 W1_31 W1_30 W1_29 W1_28 W1_27 W1_26 W1_25 W1_24 W1_23 W1_22 W1_21 W1_20 W1_19 W1_18 W1_17 W1_16 W1_15 W1_14 W1_13 W1_12 W1_11 W1_10 W1_9 W1_8 W1_7 W1_6 W1_5 W1_4 W1_3 W1_2 W1_1 W1_0 W_Addr_4 W_Addr_3 W_Addr_2 W_Addr_1 W_Addr_0 net61_0 net61_1 net61_2 net61_3 net61_4 net61_5 net61_6 net61_7) _sub145
    I6 (Rs_2 Ws_2 KR_2 KW_2 R0_Reg3_31 R0_Reg3_30 R0_Reg3_29 R0_Reg3_28 R0_Reg3_27 R0_Reg3_26 R0_Reg3_25 R0_Reg3_24 R0_Reg3_23 R0_Reg3_22 R0_Reg3_21 R0_Reg3_20 R0_Reg3_19 R0_Reg3_18 R0_Reg3_17 R0_Reg3_16 R0_Reg3_15 R0_Reg3_14 R0_Reg3_13 R0_Reg3_12 R0_Reg3_11 R0_Reg3_10 R0_Reg3_9 R0_Reg3_8 R0_Reg3_7 R0_Reg3_6 R0_Reg3_5 R0_Reg3_4 R0_Reg3_3 R0_Reg3_2 R0_Reg3_1 R0_Reg3_0 R1_Reg3_31 R1_Reg3_30 R1_Reg3_29 R1_Reg3_28 R1_Reg3_27 R1_Reg3_26 R1_Reg3_25 R1_Reg3_24 R1_Reg3_23 R1_Reg3_22 R1_Reg3_21 R1_Reg3_20 R1_Reg3_19 R1_Reg3_18 R1_Reg3_17 R1_Reg3_16 R1_Reg3_15 R1_Reg3_14 R1_Reg3_13 R1_Reg3_12 R1_Reg3_11 R1_Reg3_10 R1_Reg3_9 R1_Reg3_8 R1_Reg3_7 R1_Reg3_6 R1_Reg3_5 R1_Reg3_4 R1_Reg3_3 R1_Reg3_2 R1_Reg3_1 R1_Reg3_0 R_Addr_4 R_Addr_3 R_Addr_2 R_Addr_1 R_Addr_0 Rs_2 Reset W0_31 W0_30 W0_29 W0_28 W0_27 W0_26 W0_25 W0_24 W0_23 W0_22 W0_21 W0_20 W0_19 W0_18 W0_17 W0_16 W0_15 W0_14 W0_13 W0_12 W0_11 W0_10 W0_9 W0_8 W0_7 W0_6 W0_5 W0_4 W0_3 W0_2 W0_1 W0_0 W1_31 W1_30 W1_29 W1_28 W1_27 W1_26 W1_25 W1_24 W1_23 W1_22 W1_21 W1_20 W1_19 W1_18 W1_17 W1_16 W1_15 W1_14 W1_13 W1_12 W1_11 W1_10 W1_9 W1_8 W1_7 W1_6 W1_5 W1_4 W1_3 W1_2 W1_1 W1_0 W_Addr_4 W_Addr_3 W_Addr_2 W_Addr_1 W_Addr_0 net63_0 net63_1 net63_2 net63_3 net63_4 net63_5 net63_6 net63_7) _sub145
    I8 (Rs_3 Ws_3 KR_3 KW_3 R0_Reg4_31 R0_Reg4_30 R0_Reg4_29 R0_Reg4_28 R0_Reg4_27 R0_Reg4_26 R0_Reg4_25 R0_Reg4_24 R0_Reg4_23 R0_Reg4_22 R0_Reg4_21 R0_Reg4_20 R0_Reg4_19 R0_Reg4_18 R0_Reg4_17 R0_Reg4_16 R0_Reg4_15 R0_Reg4_14 R0_Reg4_13 R0_Reg4_12 R0_Reg4_11 R0_Reg4_10 R0_Reg4_9 R0_Reg4_8 R0_Reg4_7 R0_Reg4_6 R0_Reg4_5 R0_Reg4_4 R0_Reg4_3 R0_Reg4_2 R0_Reg4_1 R0_Reg4_0 R1_Reg4_31 R1_Reg4_30 R1_Reg4_29 R1_Reg4_28 R1_Reg4_27 R1_Reg4_26 R1_Reg4_25 R1_Reg4_24 R1_Reg4_23 R1_Reg4_22 R1_Reg4_21 R1_Reg4_20 R1_Reg4_19 R1_Reg4_18 R1_Reg4_17 R1_Reg4_16 R1_Reg4_15 R1_Reg4_14 R1_Reg4_13 R1_Reg4_12 R1_Reg4_11 R1_Reg4_10 R1_Reg4_9 R1_Reg4_8 R1_Reg4_7 R1_Reg4_6 R1_Reg4_5 R1_Reg4_4 R1_Reg4_3 R1_Reg4_2 R1_Reg4_1 R1_Reg4_0 R_Addr_4 R_Addr_3 R_Addr_2 R_Addr_1 R_Addr_0 Rs_3 Reset W0_31 W0_30 W0_29 W0_28 W0_27 W0_26 W0_25 W0_24 W0_23 W0_22 W0_21 W0_20 W0_19 W0_18 W0_17 W0_16 W0_15 W0_14 W0_13 W0_12 W0_11 W0_10 W0_9 W0_8 W0_7 W0_6 W0_5 W0_4 W0_3 W0_2 W0_1 W0_0 W1_31 W1_30 W1_29 W1_28 W1_27 W1_26 W1_25 W1_24 W1_23 W1_22 W1_21 W1_20 W1_19 W1_18 W1_17 W1_16 W1_15 W1_14 W1_13 W1_12 W1_11 W1_10 W1_9 W1_8 W1_7 W1_6 W1_5 W1_4 W1_3 W1_2 W1_1 W1_0 W_Addr_4 W_Addr_3 W_Addr_2 W_Addr_1 W_Addr_0 net65_0 net65_1 net65_2 net65_3 net65_4 net65_5 net65_6 net65_7) _sub145
    I4 (R_Addr_6 R_Addr_5 Rs_3 Rs_2 Rs_1 Rs_0 GoR) Decode_2to4
    I1 (W_Addr_6 W_Addr_5 Ws_3 Ws_2 Ws_1 Ws_0 GoW) Decode_2to4
    I10 (KW_0 KW_1 KW_2 KW_3 \~KWe) nand4_1x
    I11 (KR_0 KR_1 KR_2 KR_3 \~KRe) nand4_1x
    I9 (REnOut net059_0 net059_1 RO_Reg1_31 RO_Reg1_30 RO_Reg1_29 RO_Reg1_28 RO_Reg1_27 RO_Reg1_26 RO_Reg1_25 RO_Reg1_24 RO_Reg1_23 RO_Reg1_22 RO_Reg1_21 RO_Reg1_20 RO_Reg1_19 RO_Reg1_18 RO_Reg1_17 RO_Reg1_16 RO_Reg1_15 RO_Reg1_14 RO_Reg1_13 RO_Reg1_12 RO_Reg1_11 RO_Reg1_10 RO_Reg1_9 RO_Reg1_8 RO_Reg1_7 RO_Reg1_6 RO_Reg1_5 RO_Reg1_4 RO_Reg1_3 RO_Reg1_2 RO_Reg1_1 RO_Reg1_0 RO_Reg2_31 RO_Reg2_30 RO_Reg2_29 RO_Reg2_28 RO_Reg2_27 RO_Reg2_26 RO_Reg2_25 RO_Reg2_24 RO_Reg2_23 RO_Reg2_22 RO_Reg2_21 RO_Reg2_20 RO_Reg2_19 RO_Reg2_18 RO_Reg2_17 RO_Reg2_16 RO_Reg2_15 RO_Reg2_14 RO_Reg2_13 RO_Reg2_12 RO_Reg2_11 RO_Reg2_10 RO_Reg2_9 RO_Reg2_8 RO_Reg2_7 RO_Reg2_6 RO_Reg2_5 RO_Reg2_4 RO_Reg2_3 RO_Reg2_2 RO_Reg2_1 RO_Reg2_0 R0_Reg3_31 R0_Reg3_30 R0_Reg3_29 R0_Reg3_28 R0_Reg3_27 R0_Reg3_26 R0_Reg3_25 R0_Reg3_24 R0_Reg3_23 R0_Reg3_22 R0_Reg3_21 R0_Reg3_20 R0_Reg3_19 R0_Reg3_18 R0_Reg3_17 R0_Reg3_16 R0_Reg3_15 R0_Reg3_14 R0_Reg3_13 R0_Reg3_12 R0_Reg3_11 R0_Reg3_10 R0_Reg3_9 R0_Reg3_8 R0_Reg3_7 R0_Reg3_6 R0_Reg3_5 R0_Reg3_4 R0_Reg3_3 R0_Reg3_2 R0_Reg3_1 R0_Reg3_0 R0_Reg4_31 R0_Reg4_30 R0_Reg4_29 R0_Reg4_28 R0_Reg4_27 R0_Reg4_26 R0_Reg4_25 R0_Reg4_24 R0_Reg4_23 R0_Reg4_22 R0_Reg4_21 R0_Reg4_20 R0_Reg4_19 R0_Reg4_18 R0_Reg4_17 R0_Reg4_16 R0_Reg4_15 R0_Reg4_14 R0_Reg4_13 R0_Reg4_12 R0_Reg4_11 R0_Reg4_10 R0_Reg4_9 R0_Reg4_8 R0_Reg4_7 R0_Reg4_6 R0_Reg4_5 R0_Reg4_4 R0_Reg4_3 R0_Reg4_2 R0_Reg4_1 R0_Reg4_0 R0_31 R0_30 R0_29 R0_28 R0_27 R0_26 R0_25 R0_24 R0_23 R0_22 R0_21 R0_20 R0_19 R0_18 R0_17 R0_16 R0_15 R0_14 R0_13 R0_12 R0_11 R0_10 R0_9 R0_8 R0_7 R0_6 R0_5 R0_4 R0_3 R0_2 R0_1 R0_0) Mux_128to32
    I7 (REnOut net059_0 net059_1 R1_Reg1_31 R1_Reg1_30 R1_Reg1_29 R1_Reg1_28 R1_Reg1_27 R1_Reg1_26 R1_Reg1_25 R1_Reg1_24 R1_Reg1_23 R1_Reg1_22 R1_Reg1_21 R1_Reg1_20 R1_Reg1_19 R1_Reg1_18 R1_Reg1_17 R1_Reg1_16 R1_Reg1_15 R1_Reg1_14 R1_Reg1_13 R1_Reg1_12 R1_Reg1_11 R1_Reg1_10 R1_Reg1_9 R1_Reg1_8 R1_Reg1_7 R1_Reg1_6 R1_Reg1_5 R1_Reg1_4 R1_Reg1_3 R1_Reg1_2 R1_Reg1_1 R1_Reg1_0 R1_Reg2_31 R1_Reg2_30 R1_Reg2_29 R1_Reg2_28 R1_Reg2_27 R1_Reg2_26 R1_Reg2_25 R1_Reg2_24 R1_Reg2_23 R1_Reg2_22 R1_Reg2_21 R1_Reg2_20 R1_Reg2_19 R1_Reg2_18 R1_Reg2_17 R1_Reg2_16 R1_Reg2_15 R1_Reg2_14 R1_Reg2_13 R1_Reg2_12 R1_Reg2_11 R1_Reg2_10 R1_Reg2_9 R1_Reg2_8 R1_Reg2_7 R1_Reg2_6 R1_Reg2_5 R1_Reg2_4 R1_Reg2_3 R1_Reg2_2 R1_Reg2_1 R1_Reg2_0 R1_Reg3_31 R1_Reg3_30 R1_Reg3_29 R1_Reg3_28 R1_Reg3_27 R1_Reg3_26 R1_Reg3_25 R1_Reg3_24 R1_Reg3_23 R1_Reg3_22 R1_Reg3_21 R1_Reg3_20 R1_Reg3_19 R1_Reg3_18 R1_Reg3_17 R1_Reg3_16 R1_Reg3_15 R1_Reg3_14 R1_Reg3_13 R1_Reg3_12 R1_Reg3_11 R1_Reg3_10 R1_Reg3_9 R1_Reg3_8 R1_Reg3_7 R1_Reg3_6 R1_Reg3_5 R1_Reg3_4 R1_Reg3_3 R1_Reg3_2 R1_Reg3_1 R1_Reg3_0 R1_Reg4_31 R1_Reg4_30 R1_Reg4_29 R1_Reg4_28 R1_Reg4_27 R1_Reg4_26 R1_Reg4_25 R1_Reg4_24 R1_Reg4_23 R1_Reg4_22 R1_Reg4_21 R1_Reg4_20 R1_Reg4_19 R1_Reg4_18 R1_Reg4_17 R1_Reg4_16 R1_Reg4_15 R1_Reg4_14 R1_Reg4_13 R1_Reg4_12 R1_Reg4_11 R1_Reg4_10 R1_Reg4_9 R1_Reg4_8 R1_Reg4_7 R1_Reg4_6 R1_Reg4_5 R1_Reg4_4 R1_Reg4_3 R1_Reg4_2 R1_Reg4_1 R1_Reg4_0 R1_31 R1_30 R1_29 R1_28 R1_27 R1_26 R1_25 R1_24 R1_23 R1_22 R1_21 R1_20 R1_19 R1_18 R1_17 R1_16 R1_15 R1_14 R1_13 R1_12 R1_11 R1_10 R1_9 R1_8 R1_7 R1_6 R1_5 R1_4 R1_3 R1_2 R1_1 R1_0) Mux_128to32
    I24_1 (R_Addr_6 net058_0) inv_1x
    I24_0 (R_Addr_5 net058_1) inv_1x
    I25_1 (net058_0 net059_0) inv_1x
    I25_0 (net058_1 net059_1) inv_1x
    I23 (net056 REnOut) inv_1x
    I22 (GoR net056) inv_1x
ends Dcache_TagMem

// 16nm/inv_1xt/schematic
//system verilogNetlist schematic cmos.sch cmos_sch veriloga ahdl
subckt inv_1xt A Y
    M0 (Y A 0 0) nfet w=60n l=20n nfin=1 m=1 degradation=no
    M1 (Y A vcc! vcc!) pfet w=100n l=20n nfin=1 m=1 degradation=no
ends inv_1xt

// 16nm_Tests/10T_TagMem_Test/schematic
// system verilogNetlist schematic cmos.sch cmos_sch veriloga ahdl
I36 (GoRT GoWT KReT KWeT R1T_31 R1T_30 R1T_29 R1T_28 R1T_27 R1T_26 R1T_25 R1T_24 R1T_23 R1T_22 R1T_21 R1T_20 R1T_19 R1T_18 R1T_17 R1T_16 R1T_15 R1T_14 R1T_13 R1T_12 R1T_11 R1T_10 R1T_9 R1T_8 R1T_7 R1T_6 R1T_5 R1T_4 R1T_3 R1T_2 R1T_1 R1T_0 R_AddrT_6 R_AddrT_5 R_AddrT_4 R_AddrT_3 R_AddrT_2 R_AddrT_1 R_AddrT_0 ResetT W0T_31 W0T_30 W0T_29 W0T_28 W0T_27 W0T_26 W0T_25 W0T_24 W0T_23 W0T_22 W0T_21 W0T_20 W0T_19 W0T_18 W0T_17 W0T_16 W0T_15 W0T_14 W0T_13 W0T_12 W0T_11 W0T_10 W0T_9 W0T_8 W0T_7 W0T_6 W0T_5 W0T_4 W0T_3 W0T_2 W0T_1 W0T_0 W1T_31 W1T_30 W1T_29 W1T_28 W1T_27 W1T_26 W1T_25 W1T_24 W1T_23 W1T_22 W1T_21 W1T_20 W1T_19 W1T_18 W1T_17 W1T_16 W1T_15 W1T_14 W1T_13 W1T_12 W1T_11 W1T_10 W1T_9 W1T_8 W1T_7 W1T_6 W1T_5 W1T_4 W1T_3 W1T_2 W1T_1 W1T_0 W_AddrT_6 W_AddrT_5 W_AddrT_4 W_AddrT_3 W_AddrT_2 W_AddrT_1 W_AddrT_0 R0T_31 R0T_30 R0T_29 R0T_28 R0T_27 R0T_26 R0T_25 R0T_24 R0T_23 R0T_22 R0T_21 R0T_20 R0T_19 R0T_18 R0T_17 R0T_16 R0T_15 R0T_14 R0T_13 R0T_12 R0T_11 R0T_10 R0T_9 R0T_8 R0T_7 R0T_6 R0T_5 R0T_4 R0T_3 R0T_2 R0T_1 R0T_0) Dcache_TagMem
V0 (vcc! 0) vsource type=dc dc=vcc
V1 (vdd! 0) vsource type=dc dc=vdd
I17 (\~GoR GoRT) inv_1xt
I15 (\~GoW GoWT) inv_1xt
I7 (\~Reset ResetT) inv_1xt
I26 (KReT \~R_ack) inv_1xt
I25 (KWeT \~W_ack) inv_1xt
I39_6 (\~W_Addr_6 W_AddrT_6) inv_1xt
I39_5 (\~W_Addr_5 W_AddrT_5) inv_1xt
I39_4 (\~W_Addr_4 W_AddrT_4) inv_1xt
I39_3 (\~W_Addr_3 W_AddrT_3) inv_1xt
I39_2 (\~W_Addr_2 W_AddrT_2) inv_1xt
I39_1 (\~W_Addr_1 W_AddrT_1) inv_1xt
I39_0 (\~W_Addr_0 W_AddrT_0) inv_1xt
I38_6 (\~R_Addr_6 R_AddrT_6) inv_1xt
I38_5 (\~R_Addr_5 R_AddrT_5) inv_1xt
I38_4 (\~R_Addr_4 R_AddrT_4) inv_1xt
I38_3 (\~R_Addr_3 R_AddrT_3) inv_1xt
I38_2 (\~R_Addr_2 R_AddrT_2) inv_1xt
I38_1 (\~R_Addr_1 R_AddrT_1) inv_1xt
I38_0 (\~R_Addr_0 R_AddrT_0) inv_1xt
I24_31 (R1T_31 \~R1_31) inv_1xt
I24_30 (R1T_30 \~R1_30) inv_1xt
I24_29 (R1T_29 \~R1_29) inv_1xt
I24_28 (R1T_28 \~R1_28) inv_1xt
I24_27 (R1T_27 \~R1_27) inv_1xt
I24_26 (R1T_26 \~R1_26) inv_1xt
I24_25 (R1T_25 \~R1_25) inv_1xt
I24_24 (R1T_24 \~R1_24) inv_1xt
I24_23 (R1T_23 \~R1_23) inv_1xt
I24_22 (R1T_22 \~R1_22) inv_1xt
I24_21 (R1T_21 \~R1_21) inv_1xt
I24_20 (R1T_20 \~R1_20) inv_1xt
I24_19 (R1T_19 \~R1_19) inv_1xt
I24_18 (R1T_18 \~R1_18) inv_1xt
I24_17 (R1T_17 \~R1_17) inv_1xt
I24_16 (R1T_16 \~R1_16) inv_1xt
I24_15 (R1T_15 \~R1_15) inv_1xt
I24_14 (R1T_14 \~R1_14) inv_1xt
I24_13 (R1T_13 \~R1_13) inv_1xt
I24_12 (R1T_12 \~R1_12) inv_1xt
I24_11 (R1T_11 \~R1_11) inv_1xt
I24_10 (R1T_10 \~R1_10) inv_1xt
I24_9 (R1T_9 \~R1_9) inv_1xt
I24_8 (R1T_8 \~R1_8) inv_1xt
I24_7 (R1T_7 \~R1_7) inv_1xt
I24_6 (R1T_6 \~R1_6) inv_1xt
I24_5 (R1T_5 \~R1_5) inv_1xt
I24_4 (R1T_4 \~R1_4) inv_1xt
I24_3 (R1T_3 \~R1_3) inv_1xt
I24_2 (R1T_2 \~R1_2) inv_1xt
I24_1 (R1T_1 \~R1_1) inv_1xt
I24_0 (R1T_0 \~R1_0) inv_1xt
I42_31 (R0T_31 \~R0_31) inv_1xt
I42_30 (R0T_30 \~R0_30) inv_1xt
I42_29 (R0T_29 \~R0_29) inv_1xt
I42_28 (R0T_28 \~R0_28) inv_1xt
I42_27 (R0T_27 \~R0_27) inv_1xt
I42_26 (R0T_26 \~R0_26) inv_1xt
I42_25 (R0T_25 \~R0_25) inv_1xt
I42_24 (R0T_24 \~R0_24) inv_1xt
I42_23 (R0T_23 \~R0_23) inv_1xt
I42_22 (R0T_22 \~R0_22) inv_1xt
I42_21 (R0T_21 \~R0_21) inv_1xt
I42_20 (R0T_20 \~R0_20) inv_1xt
I42_19 (R0T_19 \~R0_19) inv_1xt
I42_18 (R0T_18 \~R0_18) inv_1xt
I42_17 (R0T_17 \~R0_17) inv_1xt
I42_16 (R0T_16 \~R0_16) inv_1xt
I42_15 (R0T_15 \~R0_15) inv_1xt
I42_14 (R0T_14 \~R0_14) inv_1xt
I42_13 (R0T_13 \~R0_13) inv_1xt
I42_12 (R0T_12 \~R0_12) inv_1xt
I42_11 (R0T_11 \~R0_11) inv_1xt
I42_10 (R0T_10 \~R0_10) inv_1xt
I42_9 (R0T_9 \~R0_9) inv_1xt
I42_8 (R0T_8 \~R0_8) inv_1xt
I42_7 (R0T_7 \~R0_7) inv_1xt
I42_6 (R0T_6 \~R0_6) inv_1xt
I42_5 (R0T_5 \~R0_5) inv_1xt
I42_4 (R0T_4 \~R0_4) inv_1xt
I42_3 (R0T_3 \~R0_3) inv_1xt
I42_2 (R0T_2 \~R0_2) inv_1xt
I42_1 (R0T_1 \~R0_1) inv_1xt
I42_0 (R0T_0 \~R0_0) inv_1xt
I11_31 (\~W1_31 W1T_31) inv_1xt
I11_30 (\~W1_30 W1T_30) inv_1xt
I11_29 (\~W1_29 W1T_29) inv_1xt
I11_28 (\~W1_28 W1T_28) inv_1xt
I11_27 (\~W1_27 W1T_27) inv_1xt
I11_26 (\~W1_26 W1T_26) inv_1xt
I11_25 (\~W1_25 W1T_25) inv_1xt
I11_24 (\~W1_24 W1T_24) inv_1xt
I11_23 (\~W1_23 W1T_23) inv_1xt
I11_22 (\~W1_22 W1T_22) inv_1xt
I11_21 (\~W1_21 W1T_21) inv_1xt
I11_20 (\~W1_20 W1T_20) inv_1xt
I11_19 (\~W1_19 W1T_19) inv_1xt
I11_18 (\~W1_18 W1T_18) inv_1xt
I11_17 (\~W1_17 W1T_17) inv_1xt
I11_16 (\~W1_16 W1T_16) inv_1xt
I11_15 (\~W1_15 W1T_15) inv_1xt
I11_14 (\~W1_14 W1T_14) inv_1xt
I11_13 (\~W1_13 W1T_13) inv_1xt
I11_12 (\~W1_12 W1T_12) inv_1xt
I11_11 (\~W1_11 W1T_11) inv_1xt
I11_10 (\~W1_10 W1T_10) inv_1xt
I11_9 (\~W1_9 W1T_9) inv_1xt
I11_8 (\~W1_8 W1T_8) inv_1xt
I11_7 (\~W1_7 W1T_7) inv_1xt
I11_6 (\~W1_6 W1T_6) inv_1xt
I11_5 (\~W1_5 W1T_5) inv_1xt
I11_4 (\~W1_4 W1T_4) inv_1xt
I11_3 (\~W1_3 W1T_3) inv_1xt
I11_2 (\~W1_2 W1T_2) inv_1xt
I11_1 (\~W1_1 W1T_1) inv_1xt
I11_0 (\~W1_0 W1T_0) inv_1xt
I9_31 (\~W0_31 W0T_31) inv_1xt
I9_30 (\~W0_30 W0T_30) inv_1xt
I9_29 (\~W0_29 W0T_29) inv_1xt
I9_28 (\~W0_28 W0T_28) inv_1xt
I9_27 (\~W0_27 W0T_27) inv_1xt
I9_26 (\~W0_26 W0T_26) inv_1xt
I9_25 (\~W0_25 W0T_25) inv_1xt
I9_24 (\~W0_24 W0T_24) inv_1xt
I9_23 (\~W0_23 W0T_23) inv_1xt
I9_22 (\~W0_22 W0T_22) inv_1xt
I9_21 (\~W0_21 W0T_21) inv_1xt
I9_20 (\~W0_20 W0T_20) inv_1xt
I9_19 (\~W0_19 W0T_19) inv_1xt
I9_18 (\~W0_18 W0T_18) inv_1xt
I9_17 (\~W0_17 W0T_17) inv_1xt
I9_16 (\~W0_16 W0T_16) inv_1xt
I9_15 (\~W0_15 W0T_15) inv_1xt
I9_14 (\~W0_14 W0T_14) inv_1xt
I9_13 (\~W0_13 W0T_13) inv_1xt
I9_12 (\~W0_12 W0T_12) inv_1xt
I9_11 (\~W0_11 W0T_11) inv_1xt
I9_10 (\~W0_10 W0T_10) inv_1xt
I9_9 (\~W0_9 W0T_9) inv_1xt
I9_8 (\~W0_8 W0T_8) inv_1xt
I9_7 (\~W0_7 W0T_7) inv_1xt
I9_6 (\~W0_6 W0T_6) inv_1xt
I9_5 (\~W0_5 W0T_5) inv_1xt
I9_4 (\~W0_4 W0T_4) inv_1xt
I9_3 (\~W0_3 W0T_3) inv_1xt
I9_2 (\~W0_2 W0T_2) inv_1xt
I9_1 (\~W0_1 W0T_1) inv_1xt
I9_0 (\~W0_0 W0T_0) inv_1xt
// BEGIN Hierarchical Interface Elements
_ie99853 (\~W1_26 0) d2a src="99853" val0=0.0 val1=vdd valx=vdd/2 rise=2p fall=2p
_ie99854 (\~W_Addr_0 0) d2a src="99854" val0=0.0 val1=vdd valx=vdd/2 rise=2p fall=2p
_ie99855 (\~R_Addr_1 0) d2a src="99855" val0=0.0 val1=vdd valx=vdd/2 rise=2p fall=2p
_ie99856 (\~W1_29 0) d2a src="99856" val0=0.0 val1=vdd valx=vdd/2 rise=2p fall=2p
_ie99857 (\~R0_2 0) a2d dest="99857" vl=0.3*vdd vh=0.7*vdd timex=20n
_ie99858 (\~W0_15 0) d2a src="99858" val0=0.0 val1=vdd valx=vdd/2 rise=2p fall=2p
_ie99859 (\~W1_11 0) d2a src="99859" val0=0.0 val1=vdd valx=vdd/2 rise=2p fall=2p
_ie99860 (\~R0_14 0) a2d dest="99860" vl=0.3*vdd vh=0.7*vdd timex=20n
_ie99861 (\~R1_1 0) a2d dest="99861" vl=0.3*vdd vh=0.7*vdd timex=20n
_ie99862 (\~R0_15 0) a2d dest="99862" vl=0.3*vdd vh=0.7*vdd timex=20n
_ie99863 (\~R0_16 0) a2d dest="99863" vl=0.3*vdd vh=0.7*vdd timex=20n
_ie99864 (\~R0_3 0) a2d dest="99864" vl=0.3*vdd vh=0.7*vdd timex=20n
_ie99865 (\~GoW 0) d2a src="99865" val0=0.0 val1=vdd valx=vdd/2 rise=2p fall=2p
_ie99866 (\~W_Addr_1 0) d2a src="99866" val0=0.0 val1=vdd valx=vdd/2 rise=2p fall=2p
_ie99867 (\~W1_6 0) d2a src="99867" val0=0.0 val1=vdd valx=vdd/2 rise=2p fall=2p
_ie99868 (\~R0_17 0) a2d dest="99868" vl=0.3*vdd vh=0.7*vdd timex=20n
_ie99869 (\~W0_2 0) d2a src="99869" val0=0.0 val1=vdd valx=vdd/2 rise=2p fall=2p
_ie99870 (\~W1_12 0) d2a src="99870" val0=0.0 val1=vdd valx=vdd/2 rise=2p fall=2p
_ie99871 (\~W1_13 0) d2a src="99871" val0=0.0 val1=vdd valx=vdd/2 rise=2p fall=2p
_ie99872 (\~W0_31 0) d2a src="99872" val0=0.0 val1=vdd valx=vdd/2 rise=2p fall=2p
_ie99873 (\~W1_14 0) d2a src="99873" val0=0.0 val1=vdd valx=vdd/2 rise=2p fall=2p
_ie99874 (\~R1_0 0) a2d dest="99874" vl=0.3*vdd vh=0.7*vdd timex=20n
_ie99875 (\~W_Addr_2 0) d2a src="99875" val0=0.0 val1=vdd valx=vdd/2 rise=2p fall=2p
_ie99876 (\~R0_24 0) a2d dest="99876" vl=0.3*vdd vh=0.7*vdd timex=20n
_ie99877 (\~W1_30 0) d2a src="99877" val0=0.0 val1=vdd valx=vdd/2 rise=2p fall=2p
_ie99878 (\~R0_27 0) a2d dest="99878" vl=0.3*vdd vh=0.7*vdd timex=20n
_ie99879 (\~R0_25 0) a2d dest="99879" vl=0.3*vdd vh=0.7*vdd timex=20n
_ie99880 (\~W1_31 0) d2a src="99880" val0=0.0 val1=vdd valx=vdd/2 rise=2p fall=2p
_ie99881 (\~R0_26 0) a2d dest="99881" vl=0.3*vdd vh=0.7*vdd timex=20n
_ie99882 (\~Reset 0) d2a src="99882" val0=0.0 val1=vdd valx=vdd/2 rise=2p fall=2p
_ie99883 (\~W0_24 0) d2a src="99883" val0=0.0 val1=vdd valx=vdd/2 rise=2p fall=2p
_ie99884 (\~R1_8 0) a2d dest="99884" vl=0.3*vdd vh=0.7*vdd timex=20n
_ie99885 (\~R_Addr_3 0) d2a src="99885" val0=0.0 val1=vdd valx=vdd/2 rise=2p fall=2p
_ie99886 (\~W0_19 0) d2a src="99886" val0=0.0 val1=vdd valx=vdd/2 rise=2p fall=2p
_ie99887 (\~W0_0 0) d2a src="99887" val0=0.0 val1=vdd valx=vdd/2 rise=2p fall=2p
_ie99888 (\~W1_5 0) d2a src="99888" val0=0.0 val1=vdd valx=vdd/2 rise=2p fall=2p
_ie99889 (\~R1_22 0) a2d dest="99889" vl=0.3*vdd vh=0.7*vdd timex=20n
_ie99890 (\~W1_15 0) d2a src="99890" val0=0.0 val1=vdd valx=vdd/2 rise=2p fall=2p
_ie99891 (\~W1_0 0) d2a src="99891" val0=0.0 val1=vdd valx=vdd/2 rise=2p fall=2p
_ie99892 (\~R1_7 0) a2d dest="99892" vl=0.3*vdd vh=0.7*vdd timex=20n
_ie99893 (\~W1_16 0) d2a src="99893" val0=0.0 val1=vdd valx=vdd/2 rise=2p fall=2p
_ie99894 (\~W0_20 0) d2a src="99894" val0=0.0 val1=vdd valx=vdd/2 rise=2p fall=2p
_ie99895 (\~R1_5 0) a2d dest="99895" vl=0.3*vdd vh=0.7*vdd timex=20n
_ie99896 (\~W0_1 0) d2a src="99896" val0=0.0 val1=vdd valx=vdd/2 rise=2p fall=2p
_ie99897 (\~W1_1 0) d2a src="99897" val0=0.0 val1=vdd valx=vdd/2 rise=2p fall=2p
_ie99898 (\~R0_18 0) a2d dest="99898" vl=0.3*vdd vh=0.7*vdd timex=20n
_ie99899 (\~W0_18 0) d2a src="99899" val0=0.0 val1=vdd valx=vdd/2 rise=2p fall=2p
_ie99900 (\~R0_5 0) a2d dest="99900" vl=0.3*vdd vh=0.7*vdd timex=20n
_ie99901 (\~R1_2 0) a2d dest="99901" vl=0.3*vdd vh=0.7*vdd timex=20n
_ie99902 (\~W1_19 0) d2a src="99902" val0=0.0 val1=vdd valx=vdd/2 rise=2p fall=2p
_ie99903 (\~R0_4 0) a2d dest="99903" vl=0.3*vdd vh=0.7*vdd timex=20n
_ie99904 (\~R0_6 0) a2d dest="99904" vl=0.3*vdd vh=0.7*vdd timex=20n
_ie99905 (\~R0_7 0) a2d dest="99905" vl=0.3*vdd vh=0.7*vdd timex=20n
_ie99906 (\~W0_25 0) d2a src="99906" val0=0.0 val1=vdd valx=vdd/2 rise=2p fall=2p
_ie99907 (\~R0_8 0) a2d dest="99907" vl=0.3*vdd vh=0.7*vdd timex=20n
_ie99908 (\~W0_21 0) d2a src="99908" val0=0.0 val1=vdd valx=vdd/2 rise=2p fall=2p
_ie99909 (\~W_Addr_6 0) d2a src="99909" val0=0.0 val1=vdd valx=vdd/2 rise=2p fall=2p
_ie99910 (\~R0_9 0) a2d dest="99910" vl=0.3*vdd vh=0.7*vdd timex=20n
_ie99911 (\~R0_10 0) a2d dest="99911" vl=0.3*vdd vh=0.7*vdd timex=20n
_ie99912 (\~R0_11 0) a2d dest="99912" vl=0.3*vdd vh=0.7*vdd timex=20n
_ie99913 (\~W1_2 0) d2a src="99913" val0=0.0 val1=vdd valx=vdd/2 rise=2p fall=2p
_ie99914 (\~W0_30 0) d2a src="99914" val0=0.0 val1=vdd valx=vdd/2 rise=2p fall=2p
_ie99915 (\~W0_26 0) d2a src="99915" val0=0.0 val1=vdd valx=vdd/2 rise=2p fall=2p
_ie99916 (\~R0_12 0) a2d dest="99916" vl=0.3*vdd vh=0.7*vdd timex=20n
_ie99917 (\~W0_29 0) d2a src="99917" val0=0.0 val1=vdd valx=vdd/2 rise=2p fall=2p
_ie99918 (\~R0_19 0) a2d dest="99918" vl=0.3*vdd vh=0.7*vdd timex=20n
_ie99919 (\~W1_3 0) d2a src="99919" val0=0.0 val1=vdd valx=vdd/2 rise=2p fall=2p
_ie99920 (\~R0_20 0) a2d dest="99920" vl=0.3*vdd vh=0.7*vdd timex=20n
_ie99921 (\~R1_3 0) a2d dest="99921" vl=0.3*vdd vh=0.7*vdd timex=20n
_ie99922 (\~R1_4 0) a2d dest="99922" vl=0.3*vdd vh=0.7*vdd timex=20n
_ie99923 (\~W0_27 0) d2a src="99923" val0=0.0 val1=vdd valx=vdd/2 rise=2p fall=2p
_ie99924 (\~R0_29 0) a2d dest="99924" vl=0.3*vdd vh=0.7*vdd timex=20n
_ie99925 (\~R1_15 0) a2d dest="99925" vl=0.3*vdd vh=0.7*vdd timex=20n
_ie99926 (\~W1_8 0) d2a src="99926" val0=0.0 val1=vdd valx=vdd/2 rise=2p fall=2p
_ie99927 (\~W_Addr_3 0) d2a src="99927" val0=0.0 val1=vdd valx=vdd/2 rise=2p fall=2p
_ie99928 (\~R1_12 0) a2d dest="99928" vl=0.3*vdd vh=0.7*vdd timex=20n
_ie99929 (\~W1_4 0) d2a src="99929" val0=0.0 val1=vdd valx=vdd/2 rise=2p fall=2p
_ie99930 (\~W_Addr_4 0) d2a src="99930" val0=0.0 val1=vdd valx=vdd/2 rise=2p fall=2p
_ie99931 (\~R1_16 0) a2d dest="99931" vl=0.3*vdd vh=0.7*vdd timex=20n
_ie99932 (\~W1_27 0) d2a src="99932" val0=0.0 val1=vdd valx=vdd/2 rise=2p fall=2p
_ie99933 (\~R0_30 0) a2d dest="99933" vl=0.3*vdd vh=0.7*vdd timex=20n
_ie99934 (\~W1_9 0) d2a src="99934" val0=0.0 val1=vdd valx=vdd/2 rise=2p fall=2p
_ie99935 (\~R_Addr_2 0) d2a src="99935" val0=0.0 val1=vdd valx=vdd/2 rise=2p fall=2p
_ie99936 (\~W1_10 0) d2a src="99936" val0=0.0 val1=vdd valx=vdd/2 rise=2p fall=2p
_ie99937 (\~W0_6 0) d2a src="99937" val0=0.0 val1=vdd valx=vdd/2 rise=2p fall=2p
_ie99938 (\~W0_7 0) d2a src="99938" val0=0.0 val1=vdd valx=vdd/2 rise=2p fall=2p
_ie99939 (\~R_Addr_4 0) d2a src="99939" val0=0.0 val1=vdd valx=vdd/2 rise=2p fall=2p
_ie99940 (\~R0_28 0) a2d dest="99940" vl=0.3*vdd vh=0.7*vdd timex=20n
_ie99941 (\~R1_17 0) a2d dest="99941" vl=0.3*vdd vh=0.7*vdd timex=20n
_ie99942 (\~W0_8 0) d2a src="99942" val0=0.0 val1=vdd valx=vdd/2 rise=2p fall=2p
_ie99943 (\~R0_31 0) a2d dest="99943" vl=0.3*vdd vh=0.7*vdd timex=20n
_ie99944 (\~R1_9 0) a2d dest="99944" vl=0.3*vdd vh=0.7*vdd timex=20n
_ie99945 (\~R1_13 0) a2d dest="99945" vl=0.3*vdd vh=0.7*vdd timex=20n
_ie99946 (\~R1_18 0) a2d dest="99946" vl=0.3*vdd vh=0.7*vdd timex=20n
_ie99947 (\~W0_28 0) d2a src="99947" val0=0.0 val1=vdd valx=vdd/2 rise=2p fall=2p
_ie99948 (\~R_Addr_5 0) d2a src="99948" val0=0.0 val1=vdd valx=vdd/2 rise=2p fall=2p
_ie99949 (\~W1_17 0) d2a src="99949" val0=0.0 val1=vdd valx=vdd/2 rise=2p fall=2p
_ie99950 (\~R0_21 0) a2d dest="99950" vl=0.3*vdd vh=0.7*vdd timex=20n
_ie99951 (\~R1_19 0) a2d dest="99951" vl=0.3*vdd vh=0.7*vdd timex=20n
_ie99952 (\~R0_22 0) a2d dest="99952" vl=0.3*vdd vh=0.7*vdd timex=20n
_ie99953 (\~R0_13 0) a2d dest="99953" vl=0.3*vdd vh=0.7*vdd timex=20n
_ie99954 (\~R1_10 0) a2d dest="99954" vl=0.3*vdd vh=0.7*vdd timex=20n
_ie99955 (\~W0_9 0) d2a src="99955" val0=0.0 val1=vdd valx=vdd/2 rise=2p fall=2p
_ie99956 (\~W0_10 0) d2a src="99956" val0=0.0 val1=vdd valx=vdd/2 rise=2p fall=2p
_ie99957 (\~W0_5 0) d2a src="99957" val0=0.0 val1=vdd valx=vdd/2 rise=2p fall=2p
_ie99958 (\~W0_11 0) d2a src="99958" val0=0.0 val1=vdd valx=vdd/2 rise=2p fall=2p
_ie99959 (\~R1_14 0) a2d dest="99959" vl=0.3*vdd vh=0.7*vdd timex=20n
_ie99960 (\~W1_22 0) d2a src="99960" val0=0.0 val1=vdd valx=vdd/2 rise=2p fall=2p
_ie99961 (\~W1_23 0) d2a src="99961" val0=0.0 val1=vdd valx=vdd/2 rise=2p fall=2p
_ie99962 (\~W1_24 0) d2a src="99962" val0=0.0 val1=vdd valx=vdd/2 rise=2p fall=2p
_ie99963 (\~W1_25 0) d2a src="99963" val0=0.0 val1=vdd valx=vdd/2 rise=2p fall=2p
_ie99964 (\~R_Addr_6 0) d2a src="99964" val0=0.0 val1=vdd valx=vdd/2 rise=2p fall=2p
_ie99965 (\~R1_20 0) a2d dest="99965" vl=0.3*vdd vh=0.7*vdd timex=20n
_ie99966 (\~R0_23 0) a2d dest="99966" vl=0.3*vdd vh=0.7*vdd timex=20n
_ie99967 (\~W0_16 0) d2a src="99967" val0=0.0 val1=vdd valx=vdd/2 rise=2p fall=2p
_ie99968 (\~W0_17 0) d2a src="99968" val0=0.0 val1=vdd valx=vdd/2 rise=2p fall=2p
_ie99969 (\~R_Addr_0 0) d2a src="99969" val0=0.0 val1=vdd valx=vdd/2 rise=2p fall=2p
_ie99970 (\~W0_12 0) d2a src="99970" val0=0.0 val1=vdd valx=vdd/2 rise=2p fall=2p
_ie99971 (\~W1_7 0) d2a src="99971" val0=0.0 val1=vdd valx=vdd/2 rise=2p fall=2p
_ie99972 (\~W1_20 0) d2a src="99972" val0=0.0 val1=vdd valx=vdd/2 rise=2p fall=2p
_ie99973 (\~R1_11 0) a2d dest="99973" vl=0.3*vdd vh=0.7*vdd timex=20n
_ie99974 (\~W_Addr_5 0) d2a src="99974" val0=0.0 val1=vdd valx=vdd/2 rise=2p fall=2p
_ie99975 (\~W0_13 0) d2a src="99975" val0=0.0 val1=vdd valx=vdd/2 rise=2p fall=2p
_ie99976 (\~W1_21 0) d2a src="99976" val0=0.0 val1=vdd valx=vdd/2 rise=2p fall=2p
_ie99977 (\~W0_14 0) d2a src="99977" val0=0.0 val1=vdd valx=vdd/2 rise=2p fall=2p
_ie99978 (\~R1_21 0) a2d dest="99978" vl=0.3*vdd vh=0.7*vdd timex=20n
_ie99979 (\~R1_29 0) a2d dest="99979" vl=0.3*vdd vh=0.7*vdd timex=20n
_ie99980 (\~W0_22 0) d2a src="99980" val0=0.0 val1=vdd valx=vdd/2 rise=2p fall=2p
_ie99981 (\~W0_23 0) d2a src="99981" val0=0.0 val1=vdd valx=vdd/2 rise=2p fall=2p
_ie99982 (\~R1_23 0) a2d dest="99982" vl=0.3*vdd vh=0.7*vdd timex=20n
_ie99983 (\~R1_30 0) a2d dest="99983" vl=0.3*vdd vh=0.7*vdd timex=20n
_ie99984 (\~R1_24 0) a2d dest="99984" vl=0.3*vdd vh=0.7*vdd timex=20n
_ie99985 (\~R1_25 0) a2d dest="99985" vl=0.3*vdd vh=0.7*vdd timex=20n
_ie99986 (\~W1_28 0) d2a src="99986" val0=0.0 val1=vdd valx=vdd/2 rise=2p fall=2p
_ie99987 (\~R1_31 0) a2d dest="99987" vl=0.3*vdd vh=0.7*vdd timex=20n
_ie99988 (\~W0_3 0) d2a src="99988" val0=0.0 val1=vdd valx=vdd/2 rise=2p fall=2p
_ie99989 (\~W0_4 0) d2a src="99989" val0=0.0 val1=vdd valx=vdd/2 rise=2p fall=2p
_ie99990 (\~R1_26 0) a2d dest="99990" vl=0.3*vdd vh=0.7*vdd timex=20n
_ie99991 (\~R1_27 0) a2d dest="99991" vl=0.3*vdd vh=0.7*vdd timex=20n
_ie99992 (\~GoR 0) d2a src="99992" val0=0.0 val1=vdd valx=vdd/2 rise=2p fall=2p
_ie99993 (\~R0_0 0) a2d dest="99993" vl=0.3*vdd vh=0.7*vdd timex=20n
_ie99994 (\~W_ack 0) a2d dest="99994" vl=0.3*vdd vh=0.7*vdd timex=20n
_ie99995 (\~R0_1 0) a2d dest="99995" vl=0.3*vdd vh=0.7*vdd timex=20n
_ie99996 (\~W1_18 0) d2a src="99996" val0=0.0 val1=vdd valx=vdd/2 rise=2p fall=2p
_ie99997 (\~R1_6 0) a2d dest="99997" vl=0.3*vdd vh=0.7*vdd timex=20n
_ie99998 (\~R1_28 0) a2d dest="99998" vl=0.3*vdd vh=0.7*vdd timex=20n
_ie99999 (\~R_ack 0) a2d dest="99999" vl=0.3*vdd vh=0.7*vdd timex=20n
// END Hierarchical Interface Elements
ic I36.I0.I1.I7.I3.Q=vdd I36.I0.I1.I7.I3.Qb=0 R1T_31=0 R1T_30=0 R1T_29=0 R1T_28=0 R1T_27=0 R1T_26=0 R1T_25=0 R1T_24=0 R1T_23=0 R1T_22=0 R1T_21=0 R1T_20=0 R1T_19=0 R1T_18=0 R1T_17=0 R1T_16=0 R1T_15=0 R1T_14=0 R1T_13=0 R1T_12=0 R1T_11=0 R1T_10=0 R1T_9=0 R1T_8=0 R1T_7=0 R1T_6=0 R1T_5=0 R1T_4=0 R1T_3=0 R1T_2=0 R1T_1=0 R1T_0=0 R0T_31=0 R0T_30=0 R0T_29=0 R0T_28=0 R0T_27=0 R0T_26=0 R0T_25=0 R0T_24=0 R0T_23=0 R0T_22=0 R0T_21=0 R0T_20=0 R0T_19=0 R0T_18=0 R0T_17=0 R0T_16=0 R0T_15=0 R0T_14=0 R0T_13=0 R0T_12=0 R0T_11=0 R0T_10=0 R0T_9=0 R0T_8=0 R0T_7=0 R0T_6=0 R0T_5=0 R0T_4=0 R0T_3=0 R0T_2=0 R0T_1=0 R0T_0=0 KReT=0 KWeT=0 W0T_31=0 W0T_30=0 W0T_29=0 W0T_28=0 W0T_27=0 W0T_26=0 W0T_25=0 W0T_24=0 W0T_23=0 W0T_22=0 W0T_21=0 W0T_20=0 W0T_19=0 W0T_18=0 W0T_17=0 W0T_16=0 W0T_15=0 W0T_14=0 W0T_13=0 W0T_12=0 W0T_11=0 W0T_10=0 W0T_9=0 W0T_8=0 W0T_7=0 W0T_6=0 W0T_5=0 W0T_4=0 W0T_3=0 W0T_2=0 W0T_1=0 W0T_0=0 W1T_31=0 W1T_30=0 W1T_29=0 W1T_28=0 W1T_27=0 W1T_26=0 W1T_25=0 W1T_24=0 W1T_23=0 W1T_22=0 W1T_21=0 W1T_20=0 W1T_19=0 W1T_18=0 W1T_17=0 W1T_16=0 W1T_15=0 W1T_14=0 W1T_13=0 W1T_12=0 W1T_11=0 W1T_10=0 W1T_9=0 W1T_8=0 W1T_7=0 W1T_6=0 W1T_5=0 W1T_4=0 W1T_3=0 W1T_2=0 W1T_1=0 W1T_0=0 GoWT=0 W_AddrT_6=0 W_AddrT_5=0 W_AddrT_4=0 W_AddrT_3=0 W_AddrT_2=0 W_AddrT_1=0 W_AddrT_0=0 GoRT=0 R_AddrT_6=0 R_AddrT_5=0 R_AddrT_4=0 R_AddrT_3=0 R_AddrT_2=0 R_AddrT_1=0 R_AddrT_0=0 ResetT=0
simulatorOptions options temp=30.0
tran tran stop=50n errpreset=conservative
save V1:p V0:p V0:p V1:p
