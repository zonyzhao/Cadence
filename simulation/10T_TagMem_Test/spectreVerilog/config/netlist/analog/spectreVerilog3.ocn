simulator( 'spectreVerilog )
hostMode( 'distributed )
design(	 "/net/kafka/nfs/rstdenis/Cadence/simulation/10T_TagMem_Test/spectreVerilog/config/netlist/analog/netlist")
resultsDir( "/net/kafka/nfs/rstdenis/Cadence/simulation/10T_TagMem_Test/spectreVerilog/config/distributed/job" )
modelFile(
    '("/software/cadence/ncsu-FreePDK15/hspice_16nm_hp.include" "")
)
analysis('tran ?stop "50n"  ?errpreset "conservative"  )
desVar(	  "vcc" "vdd"	)
desVar(	  "vdd" 0.5	)
envOption(
	'mspSetupNetlistSimPrecisionUnit  "ps"
	'mspSetupNetlistSimTimeUnit  "ps"
	'mspSetupNetlistSwitchRC  t
	'analysisOrder  list("tran")
)
option(	'multithread  "on"
	'temp  "30.0"
)
saveOption( ?simOutputFormat "psfxl" )
save( 'i "/V0/MINUS" "/V0/PLUS" "/V1/MINUS" "/V1/PLUS" )
converge( 'ic "/ResetT" "0" )
converge( 'ic "/R_AddrT<0>" "0" )
converge( 'ic "/R_AddrT<1>" "0" )
converge( 'ic "/R_AddrT<2>" "0" )
converge( 'ic "/R_AddrT<3>" "0" )
converge( 'ic "/R_AddrT<4>" "0" )
converge( 'ic "/R_AddrT<5>" "0" )
converge( 'ic "/R_AddrT<6>" "0" )
converge( 'ic "/GoRT" "0" )
converge( 'ic "/GoWT" "0" )
converge( 'ic "/W_AddrT<0>" "0" )
converge( 'ic "/W_AddrT<1>" "0" )
converge( 'ic "/W_AddrT<2>" "0" )
converge( 'ic "/W_AddrT<3>" "0" )
converge( 'ic "/W_AddrT<4>" "0" )
converge( 'ic "/W_AddrT<5>" "0" )
converge( 'ic "/W_AddrT<6>" "0" )
converge( 'ic "/I36/I0/I1/I7/I3/Qb" "0" )
temp( 30.0 )
run( ?jobName "job" ?queue "c2107" )
selectResult( 'tran )
plot(getData("/GoR") getData("/GoRT") getData("/GoW") getData("/GoWT") getData("/I36/Rs<0>") getData("/I36/Rs<1>") getData("/I36/Rs<2>") getData("/I36/Rs<3>") getData("/I36/Ws<0>") getData("/I36/Ws<1>") getData("/I36/Ws<2>") getData("/I36/Ws<3>") getData("/KReT") getData("/KWeT") getData("/R0<31:0>") getData("/R0T<0>") getData("/R0T<10>") getData("/R0T<11>") getData("/R0T<12>") getData("/R0T<13>") getData("/R0T<14>") getData("/R0T<15>") getData("/R0T<16>") getData("/R0T<17>") getData("/R0T<18>") getData("/R0T<19>") getData("/R0T<1>") getData("/R0T<20>") getData("/R0T<21>") getData("/R0T<22>") getData("/R0T<23>") getData("/R0T<24>") getData("/R0T<25>") getData("/R0T<26>") getData("/R0T<27>") getData("/R0T<28>") getData("/R0T<29>") getData("/R0T<2>") getData("/R0T<30>") getData("/R0T<31>") getData("/R0T<3>") getData("/R0T<4>") getData("/R0T<5>") getData("/R0T<6>") getData("/R0T<7>") getData("/R0T<8>") getData("/R0T<9>") getData("/R1<31:0>") getData("/R1T<0>") getData("/R1T<10>") getData("/R1T<11>") getData("/R1T<12>") getData("/R1T<13>") getData("/R1T<14>") getData("/R1T<15>") getData("/R1T<16>") getData("/R1T<17>") getData("/R1T<18>") getData("/R1T<19>") getData("/R1T<1>") getData("/R1T<20>") getData("/R1T<21>") getData("/R1T<22>") getData("/R1T<23>") getData("/R1T<24>") getData("/R1T<25>") getData("/R1T<26>") getData("/R1T<27>") getData("/R1T<28>") getData("/R1T<29>") getData("/R1T<2>") getData("/R1T<30>") getData("/R1T<31>") getData("/R1T<3>") getData("/R1T<4>") getData("/R1T<5>") getData("/R1T<6>") getData("/R1T<7>") getData("/R1T<8>") getData("/R1T<9>") getData("/R_Ack") getData("/R_Addr<6:0>") getData("/R_AddrT<0>") getData("/R_AddrT<1>") getData("/R_AddrT<2>") getData("/R_AddrT<3>") getData("/R_AddrT<4>") getData("/R_AddrT<5>") getData("/R_AddrT<6>") getData("/Reset") getData("/ResetT") getData("/V0/MINUS") getData("/V0/PLUS") getData("/V1/MINUS") getData("/V1/PLUS") getData("/W0<31:0>") getData("/W0T<0>") getData("/W0T<10>") getData("/W0T<11>") getData("/W0T<12>") getData("/W0T<13>") getData("/W0T<14>") getData("/W0T<15>") getData("/W0T<16>") getData("/W0T<17>") getData("/W0T<18>") getData("/W0T<19>") getData("/W0T<1>") getData("/W0T<20>") getData("/W0T<21>") getData("/W0T<22>") getData("/W0T<23>") getData("/W0T<24>") getData("/W0T<25>") getData("/W0T<26>") getData("/W0T<27>") getData("/W0T<28>") getData("/W0T<29>") getData("/W0T<2>") getData("/W0T<30>") getData("/W0T<31>") getData("/W0T<3>") getData("/W0T<4>") getData("/W0T<5>") getData("/W0T<6>") getData("/W0T<7>") getData("/W0T<8>") getData("/W0T<9>") getData("/W1<31:0>") getData("/W1T<0>") getData("/W1T<10>") getData("/W1T<11>") getData("/W1T<12>") getData("/W1T<13>") getData("/W1T<14>") getData("/W1T<15>") getData("/W1T<16>") getData("/W1T<17>") getData("/W1T<18>") getData("/W1T<19>") getData("/W1T<1>") getData("/W1T<20>") getData("/W1T<21>") getData("/W1T<22>") getData("/W1T<23>") getData("/W1T<24>") getData("/W1T<25>") getData("/W1T<26>") getData("/W1T<27>") getData("/W1T<28>") getData("/W1T<29>") getData("/W1T<2>") getData("/W1T<30>") getData("/W1T<31>") getData("/W1T<3>") getData("/W1T<4>") getData("/W1T<5>") getData("/W1T<6>") getData("/W1T<7>") getData("/W1T<8>") getData("/W1T<9>") getData("/W_Ack") getData("/W_Addr<6:0>") getData("/W_AddrT<0>") getData("/W_AddrT<1>") getData("/W_AddrT<2>") getData("/W_AddrT<3>") getData("/W_AddrT<4>") getData("/W_AddrT<5>") getData("/W_AddrT<6>") getData("/vdd!") getData("/vcc!") getData("/I36/I0/I1/I7/I3/Qb") getData("/I36/I0/I1/I7/I3/Q") getData("/I36/I0/~W1<0>") getData("/I36/I0/~W0<0>") getData("/I36/I0/~R1<0>") getData("/I36/I0/~R0<0>") )
hostMode( 'local )
resultsDir( "/net/kafka/nfs/rstdenis/Cadence/simulation/10T_TagMem_Test/spectreVerilog/config" )
modelFile(
    '("/software/cadence/ncsu-FreePDK15/hspice_16nm_hp.include" "")
)
run()
selectResult( 'tran )
plot(getData("/GoR") getData("/GoRT") getData("/GoW") getData("/GoWT") getData("/I36/Rs<0>") getData("/I36/Rs<1>") getData("/I36/Rs<2>") getData("/I36/Rs<3>") getData("/I36/Ws<0>") getData("/I36/Ws<1>") getData("/I36/Ws<2>") getData("/I36/Ws<3>") getData("/KReT") getData("/KWeT") getData("/R0<31:0>") getData("/R0T<0>") getData("/R0T<10>") getData("/R0T<11>") getData("/R0T<12>") getData("/R0T<13>") getData("/R0T<14>") getData("/R0T<15>") getData("/R0T<16>") getData("/R0T<17>") getData("/R0T<18>") getData("/R0T<19>") getData("/R0T<1>") getData("/R0T<20>") getData("/R0T<21>") getData("/R0T<22>") getData("/R0T<23>") getData("/R0T<24>") getData("/R0T<25>") getData("/R0T<26>") getData("/R0T<27>") getData("/R0T<28>") getData("/R0T<29>") getData("/R0T<2>") getData("/R0T<30>") getData("/R0T<31>") getData("/R0T<3>") getData("/R0T<4>") getData("/R0T<5>") getData("/R0T<6>") getData("/R0T<7>") getData("/R0T<8>") getData("/R0T<9>") getData("/R1<31:0>") getData("/R1T<0>") getData("/R1T<10>") getData("/R1T<11>") getData("/R1T<12>") getData("/R1T<13>") getData("/R1T<14>") getData("/R1T<15>") getData("/R1T<16>") getData("/R1T<17>") getData("/R1T<18>") getData("/R1T<19>") getData("/R1T<1>") getData("/R1T<20>") getData("/R1T<21>") getData("/R1T<22>") getData("/R1T<23>") getData("/R1T<24>") getData("/R1T<25>") getData("/R1T<26>") getData("/R1T<27>") getData("/R1T<28>") getData("/R1T<29>") getData("/R1T<2>") getData("/R1T<30>") getData("/R1T<31>") getData("/R1T<3>") getData("/R1T<4>") getData("/R1T<5>") getData("/R1T<6>") getData("/R1T<7>") getData("/R1T<8>") getData("/R1T<9>") getData("/R_Ack") getData("/R_Addr<6:0>") getData("/R_AddrT<0>") getData("/R_AddrT<1>") getData("/R_AddrT<2>") getData("/R_AddrT<3>") getData("/R_AddrT<4>") getData("/R_AddrT<5>") getData("/R_AddrT<6>") getData("/Reset") getData("/ResetT") getData("/V0/MINUS") getData("/V0/PLUS") getData("/V1/MINUS") getData("/V1/PLUS") getData("/W0<31:0>") getData("/W0T<0>") getData("/W0T<10>") getData("/W0T<11>") getData("/W0T<12>") getData("/W0T<13>") getData("/W0T<14>") getData("/W0T<15>") getData("/W0T<16>") getData("/W0T<17>") getData("/W0T<18>") getData("/W0T<19>") getData("/W0T<1>") getData("/W0T<20>") getData("/W0T<21>") getData("/W0T<22>") getData("/W0T<23>") getData("/W0T<24>") getData("/W0T<25>") getData("/W0T<26>") getData("/W0T<27>") getData("/W0T<28>") getData("/W0T<29>") getData("/W0T<2>") getData("/W0T<30>") getData("/W0T<31>") getData("/W0T<3>") getData("/W0T<4>") getData("/W0T<5>") getData("/W0T<6>") getData("/W0T<7>") getData("/W0T<8>") getData("/W0T<9>") getData("/W1<31:0>") getData("/W1T<0>") getData("/W1T<10>") getData("/W1T<11>") getData("/W1T<12>") getData("/W1T<13>") getData("/W1T<14>") getData("/W1T<15>") getData("/W1T<16>") getData("/W1T<17>") getData("/W1T<18>") getData("/W1T<19>") getData("/W1T<1>") getData("/W1T<20>") getData("/W1T<21>") getData("/W1T<22>") getData("/W1T<23>") getData("/W1T<24>") getData("/W1T<25>") getData("/W1T<26>") getData("/W1T<27>") getData("/W1T<28>") getData("/W1T<29>") getData("/W1T<2>") getData("/W1T<30>") getData("/W1T<31>") getData("/W1T<3>") getData("/W1T<4>") getData("/W1T<5>") getData("/W1T<6>") getData("/W1T<7>") getData("/W1T<8>") getData("/W1T<9>") getData("/W_Ack") getData("/W_Addr<6:0>") getData("/W_AddrT<0>") getData("/W_AddrT<1>") getData("/W_AddrT<2>") getData("/W_AddrT<3>") getData("/W_AddrT<4>") getData("/W_AddrT<5>") getData("/W_AddrT<6>") getData("/vdd!") getData("/vcc!") getData("/I36/I0/I1/I7/I3/Qb") getData("/I36/I0/I1/I7/I3/Q") getData("/I36/I0/~W1<0>") getData("/I36/I0/~W0<0>") getData("/I36/I0/~R1<0>") getData("/I36/I0/~R0<0>") )
modelFile(
    '("/software/cadence/ncsu-FreePDK15/hspice_16nm_hp.include" "")
)
run()
selectResult( 'tran )
plot(getData("/GoR") getData("/GoRT") getData("/GoW") getData("/GoWT") getData("/I36/Rs<0>") getData("/I36/Rs<1>") getData("/I36/Rs<2>") getData("/I36/Rs<3>") getData("/I36/Ws<0>") getData("/I36/Ws<1>") getData("/I36/Ws<2>") getData("/I36/Ws<3>") getData("/KReT") getData("/KWeT") getData("/R0<31:0>") getData("/R0T<0>") getData("/R0T<10>") getData("/R0T<11>") getData("/R0T<12>") getData("/R0T<13>") getData("/R0T<14>") getData("/R0T<15>") getData("/R0T<16>") getData("/R0T<17>") getData("/R0T<18>") getData("/R0T<19>") getData("/R0T<1>") getData("/R0T<20>") getData("/R0T<21>") getData("/R0T<22>") getData("/R0T<23>") getData("/R0T<24>") getData("/R0T<25>") getData("/R0T<26>") getData("/R0T<27>") getData("/R0T<28>") getData("/R0T<29>") getData("/R0T<2>") getData("/R0T<30>") getData("/R0T<31>") getData("/R0T<3>") getData("/R0T<4>") getData("/R0T<5>") getData("/R0T<6>") getData("/R0T<7>") getData("/R0T<8>") getData("/R0T<9>") getData("/R1<31:0>") getData("/R1T<0>") getData("/R1T<10>") getData("/R1T<11>") getData("/R1T<12>") getData("/R1T<13>") getData("/R1T<14>") getData("/R1T<15>") getData("/R1T<16>") getData("/R1T<17>") getData("/R1T<18>") getData("/R1T<19>") getData("/R1T<1>") getData("/R1T<20>") getData("/R1T<21>") getData("/R1T<22>") getData("/R1T<23>") getData("/R1T<24>") getData("/R1T<25>") getData("/R1T<26>") getData("/R1T<27>") getData("/R1T<28>") getData("/R1T<29>") getData("/R1T<2>") getData("/R1T<30>") getData("/R1T<31>") getData("/R1T<3>") getData("/R1T<4>") getData("/R1T<5>") getData("/R1T<6>") getData("/R1T<7>") getData("/R1T<8>") getData("/R1T<9>") getData("/R_Ack") getData("/R_Addr<6:0>") getData("/R_AddrT<0>") getData("/R_AddrT<1>") getData("/R_AddrT<2>") getData("/R_AddrT<3>") getData("/R_AddrT<4>") getData("/R_AddrT<5>") getData("/R_AddrT<6>") getData("/Reset") getData("/ResetT") getData("/V0/MINUS") getData("/V0/PLUS") getData("/V1/MINUS") getData("/V1/PLUS") getData("/W0<31:0>") getData("/W0T<0>") getData("/W0T<10>") getData("/W0T<11>") getData("/W0T<12>") getData("/W0T<13>") getData("/W0T<14>") getData("/W0T<15>") getData("/W0T<16>") getData("/W0T<17>") getData("/W0T<18>") getData("/W0T<19>") getData("/W0T<1>") getData("/W0T<20>") getData("/W0T<21>") getData("/W0T<22>") getData("/W0T<23>") getData("/W0T<24>") getData("/W0T<25>") getData("/W0T<26>") getData("/W0T<27>") getData("/W0T<28>") getData("/W0T<29>") getData("/W0T<2>") getData("/W0T<30>") getData("/W0T<31>") getData("/W0T<3>") getData("/W0T<4>") getData("/W0T<5>") getData("/W0T<6>") getData("/W0T<7>") getData("/W0T<8>") getData("/W0T<9>") getData("/W1<31:0>") getData("/W1T<0>") getData("/W1T<10>") getData("/W1T<11>") getData("/W1T<12>") getData("/W1T<13>") getData("/W1T<14>") getData("/W1T<15>") getData("/W1T<16>") getData("/W1T<17>") getData("/W1T<18>") getData("/W1T<19>") getData("/W1T<1>") getData("/W1T<20>") getData("/W1T<21>") getData("/W1T<22>") getData("/W1T<23>") getData("/W1T<24>") getData("/W1T<25>") getData("/W1T<26>") getData("/W1T<27>") getData("/W1T<28>") getData("/W1T<29>") getData("/W1T<2>") getData("/W1T<30>") getData("/W1T<31>") getData("/W1T<3>") getData("/W1T<4>") getData("/W1T<5>") getData("/W1T<6>") getData("/W1T<7>") getData("/W1T<8>") getData("/W1T<9>") getData("/W_Ack") getData("/W_Addr<6:0>") getData("/W_AddrT<0>") getData("/W_AddrT<1>") getData("/W_AddrT<2>") getData("/W_AddrT<3>") getData("/W_AddrT<4>") getData("/W_AddrT<5>") getData("/W_AddrT<6>") getData("/vdd!") getData("/vcc!") getData("/I36/I0/I1/I7/I3/Qb") getData("/I36/I0/I1/I7/I3/Q") getData("/I36/I0/~W1<0>") getData("/I36/I0/~W0<0>") getData("/I36/I0/~R1<0>") getData("/I36/I0/~R0<0>") )
modelFile(
    '("/software/cadence/ncsu-FreePDK15/hspice_16nm_hp.include" "")
)
run()
selectResult( 'tran )
plot(getData("/GoR") getData("/GoRT") getData("/GoW") getData("/GoWT") getData("/I36/Rs<0>") getData("/I36/Rs<1>") getData("/I36/Rs<2>") getData("/I36/Rs<3>") getData("/I36/Ws<0>") getData("/I36/Ws<1>") getData("/I36/Ws<2>") getData("/I36/Ws<3>") getData("/KReT") getData("/KWeT") getData("/R0<31:0>") getData("/R0T<0>") getData("/R0T<10>") getData("/R0T<11>") getData("/R0T<12>") getData("/R0T<13>") getData("/R0T<14>") getData("/R0T<15>") getData("/R0T<16>") getData("/R0T<17>") getData("/R0T<18>") getData("/R0T<19>") getData("/R0T<1>") getData("/R0T<20>") getData("/R0T<21>") getData("/R0T<22>") getData("/R0T<23>") getData("/R0T<24>") getData("/R0T<25>") getData("/R0T<26>") getData("/R0T<27>") getData("/R0T<28>") getData("/R0T<29>") getData("/R0T<2>") getData("/R0T<30>") getData("/R0T<31>") getData("/R0T<3>") getData("/R0T<4>") getData("/R0T<5>") getData("/R0T<6>") getData("/R0T<7>") getData("/R0T<8>") getData("/R0T<9>") getData("/R1<31:0>") getData("/R1T<0>") getData("/R1T<10>") getData("/R1T<11>") getData("/R1T<12>") getData("/R1T<13>") getData("/R1T<14>") getData("/R1T<15>") getData("/R1T<16>") getData("/R1T<17>") getData("/R1T<18>") getData("/R1T<19>") getData("/R1T<1>") getData("/R1T<20>") getData("/R1T<21>") getData("/R1T<22>") getData("/R1T<23>") getData("/R1T<24>") getData("/R1T<25>") getData("/R1T<26>") getData("/R1T<27>") getData("/R1T<28>") getData("/R1T<29>") getData("/R1T<2>") getData("/R1T<30>") getData("/R1T<31>") getData("/R1T<3>") getData("/R1T<4>") getData("/R1T<5>") getData("/R1T<6>") getData("/R1T<7>") getData("/R1T<8>") getData("/R1T<9>") getData("/R_Ack") getData("/R_Addr<6:0>") getData("/R_AddrT<0>") getData("/R_AddrT<1>") getData("/R_AddrT<2>") getData("/R_AddrT<3>") getData("/R_AddrT<4>") getData("/R_AddrT<5>") getData("/R_AddrT<6>") getData("/Reset") getData("/ResetT") getData("/V0/MINUS") getData("/V0/PLUS") getData("/V1/MINUS") getData("/V1/PLUS") getData("/W0<31:0>") getData("/W0T<0>") getData("/W0T<10>") getData("/W0T<11>") getData("/W0T<12>") getData("/W0T<13>") getData("/W0T<14>") getData("/W0T<15>") getData("/W0T<16>") getData("/W0T<17>") getData("/W0T<18>") getData("/W0T<19>") getData("/W0T<1>") getData("/W0T<20>") getData("/W0T<21>") getData("/W0T<22>") getData("/W0T<23>") getData("/W0T<24>") getData("/W0T<25>") getData("/W0T<26>") getData("/W0T<27>") getData("/W0T<28>") getData("/W0T<29>") getData("/W0T<2>") getData("/W0T<30>") getData("/W0T<31>") getData("/W0T<3>") getData("/W0T<4>") getData("/W0T<5>") getData("/W0T<6>") getData("/W0T<7>") getData("/W0T<8>") getData("/W0T<9>") getData("/W1<31:0>") getData("/W1T<0>") getData("/W1T<10>") getData("/W1T<11>") getData("/W1T<12>") getData("/W1T<13>") getData("/W1T<14>") getData("/W1T<15>") getData("/W1T<16>") getData("/W1T<17>") getData("/W1T<18>") getData("/W1T<19>") getData("/W1T<1>") getData("/W1T<20>") getData("/W1T<21>") getData("/W1T<22>") getData("/W1T<23>") getData("/W1T<24>") getData("/W1T<25>") getData("/W1T<26>") getData("/W1T<27>") getData("/W1T<28>") getData("/W1T<29>") getData("/W1T<2>") getData("/W1T<30>") getData("/W1T<31>") getData("/W1T<3>") getData("/W1T<4>") getData("/W1T<5>") getData("/W1T<6>") getData("/W1T<7>") getData("/W1T<8>") getData("/W1T<9>") getData("/W_Ack") getData("/W_Addr<6:0>") getData("/W_AddrT<0>") getData("/W_AddrT<1>") getData("/W_AddrT<2>") getData("/W_AddrT<3>") getData("/W_AddrT<4>") getData("/W_AddrT<5>") getData("/W_AddrT<6>") getData("/vdd!") getData("/vcc!") getData("/I36/I0/I1/I7/I3/Qb") getData("/I36/I0/I1/I7/I3/Q") getData("/I36/I0/~W1<0>") getData("/I36/I0/~W0<0>") getData("/I36/I0/~R1<0>") getData("/I36/I0/~R0<0>") )
