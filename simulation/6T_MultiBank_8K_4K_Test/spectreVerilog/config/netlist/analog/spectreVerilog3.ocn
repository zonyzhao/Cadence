simulator( 'spectreVerilog )
hostMode( 'distributed )
design(	 "/net/bull/apps/Cadence/simulation/6T_MultiBank_8K_4K_Test/spectreVerilog/config/netlist/analog/netlist")
resultsDir( "/net/bull/apps/Cadence/simulation/6T_MultiBank_8K_4K_Test/spectreVerilog/config/distributed/MBank_8K_r4K_500mV_30C" )
modelFile(
    '("/software/cadence/ncsu-FreePDK15/hspice_16nm_hp.include" "")
)
analysis('tran ?stop "5n"  ?errpreset "conservative"  )
desVar(	  "vcc" "vdd"	)
desVar(	  "vdd" .500	)
envOption(
	'mspSetupNetlistSimPrecisionUnit  "ps"
	'mspSetupNetlistSimTimeUnit  "ps"
	'mspSetupNetlistSwitchRC  t
	'userCmdLineOption  "+multithread"
	'analysisOrder  list("tran")
)
option(	'temp  "30.0"
)
saveOption( ?simOutputFormat "psfxl" )
save( 'i "/V0/MINUS" )
converge( 'ic "/ReadEnT" "0" )
converge( 'ic "/R_AddressT<0>" "0" )
converge( 'ic "/R_AddressT<1>" "0" )
converge( 'ic "/R_AddressT<2>" "0" )
converge( 'ic "/R_AddressT<3>" "0" )
converge( 'ic "/R_AddressT<4>" "0" )
converge( 'ic "/R_AddressT<5>" "0" )
converge( 'ic "/R_AddressT<6>" "0" )
converge( 'ic "/R_AddressT<7>" "0" )
converge( 'ic "/R_AddressT<8>" "0" )
converge( 'ic "/R_AddressT<9>" "0" )
converge( 'ic "/R_AddressT<10>" "0" )
converge( 'ic "/R_AddressT<11>" "0" )
converge( 'ic "/W_AddressT<0>" "0" )
converge( 'ic "/W_AddressT<1>" "0" )
converge( 'ic "/W_AddressT<2>" "0" )
converge( 'ic "/W_AddressT<3>" "0" )
converge( 'ic "/W_AddressT<4>" "0" )
converge( 'ic "/W_AddressT<5>" "0" )
converge( 'ic "/W_AddressT<6>" "0" )
converge( 'ic "/W_AddressT<7>" "0" )
converge( 'ic "/W_AddressT<8>" "0" )
converge( 'ic "/W_AddressT<9>" "0" )
converge( 'ic "/W_AddressT<10>" "0" )
converge( 'ic "/W_AddressT<11>" "0" )
converge( 'ic "/WriteEnT" "0" )
converge( 'ic "/WDataT<0>" "0" )
converge( 'ic "/WDataT<1>" "0" )
converge( 'ic "/WDataT<2>" "0" )
converge( 'ic "/WDataT<3>" "0" )
converge( 'ic "/WDataT<4>" "0" )
converge( 'ic "/WDataT<5>" "0" )
converge( 'ic "/WDataT<6>" "0" )
converge( 'ic "/WDataT<7>" "0" )
converge( 'ic "/WDataT<8>" "0" )
converge( 'ic "/WDataT<9>" "0" )
converge( 'ic "/WDataT<10>" "0" )
converge( 'ic "/WDataT<11>" "0" )
converge( 'ic "/WDataT<12>" "0" )
converge( 'ic "/WDataT<13>" "0" )
converge( 'ic "/WDataT<14>" "0" )
converge( 'ic "/WDataT<15>" "0" )
converge( 'ic "/I21/I0/I0/I0/I0/I0/I7/I3/Q0" "0" )
converge( 'ic "/I21/I0/I0/I0/I0/I0/I7/I3/Q1" "vdd" )
temp( 30.0 )
run( ?jobName "job" ?queue "c2107" ?host "copper" )
selectResult( 'tran )
plot(getData("/ReadEn") getData("/R_Address<11:0>") getData("/W_Address<11:0>") getData("/WriteEn") getData("/WDataAck<7:0>") getData("/RData<15:0>") getData("/ReadAck") getData("/WriteAck") getData("/RAckT") getData("/RDataT<15>") getData("/RDataT<14>") getData("/RDataT<13>") getData("/RDataT<12>") getData("/RDataT<11>") getData("/RDataT<10>") getData("/RDataT<9>") getData("/RDataT<8>") getData("/RDataT<7>") getData("/RDataT<6>") getData("/RDataT<5>") getData("/RDataT<4>") getData("/RDataT<3>") getData("/RDataT<2>") getData("/RDataT<1>") getData("/RDataT<0>") getData("/WAckT") getData("/R_AddressT<11>") getData("/R_AddressT<10>") getData("/R_AddressT<9>") getData("/R_AddressT<8>") getData("/R_AddressT<7>") getData("/R_AddressT<6>") getData("/R_AddressT<5>") getData("/R_AddressT<4>") getData("/R_AddressT<3>") getData("/R_AddressT<2>") getData("/R_AddressT<1>") getData("/R_AddressT<0>") getData("/ReadEnT") getData("/W_AddressT<11>") getData("/W_AddressT<10>") getData("/W_AddressT<9>") getData("/W_AddressT<8>") getData("/W_AddressT<7>") getData("/W_AddressT<6>") getData("/W_AddressT<5>") getData("/W_AddressT<4>") getData("/W_AddressT<3>") getData("/W_AddressT<2>") getData("/W_AddressT<1>") getData("/W_AddressT<0>") getData("/WriteEnT") getData("/WDataT<15>") getData("/WDataT<14>") getData("/WDataT<13>") getData("/WDataT<12>") getData("/WDataT<11>") getData("/WDataT<10>") getData("/WDataT<9>") getData("/WDataT<8>") getData("/WDataT<7>") getData("/WDataT<6>") getData("/WDataT<5>") getData("/WDataT<4>") getData("/WDataT<3>") getData("/WDataT<2>") getData("/WDataT<1>") getData("/WDataT<0>") getData("/WDataAckT<7>") getData("/WDataAckT<6>") getData("/WDataAckT<5>") getData("/WDataAckT<4>") getData("/WDataAckT<3>") getData("/WDataAckT<2>") getData("/WDataAckT<1>") getData("/WDataAckT<0>") getData("/V0/MINUS") getData("/I21/Wd<31>") getData("/I21/Wd<30>") getData("/I21/Wd<29>") getData("/I21/Wd<28>") getData("/I21/Wd<19>") getData("/I21/Wd<18>") getData("/I21/Wd<17>") getData("/I21/Wd<16>") getData("/I21/Wd<23>") getData("/I21/Wd<22>") getData("/I21/Wd<21>") getData("/I21/Wd<20>") getData("/I21/Wd<27>") getData("/I21/Wd<26>") getData("/I21/Wd<25>") getData("/I21/Wd<24>") getData("/I21/WdAck<7>") getData("/I21/WdAck<6>") getData("/I21/WdAck<5>") getData("/I21/WdAck<4>") getData("/I21/WdAck<3>") getData("/I21/WdAck<2>") getData("/I21/WdAck<1>") getData("/I21/WdAck<0>") getData("/I21/Wd<11>") getData("/I21/Wd<10>") getData("/I21/Wd<9>") getData("/I21/Wd<8>") getData("/I21/Wd<15>") getData("/I21/Wd<14>") getData("/I21/Wd<13>") getData("/I21/Wd<12>") getData("/I21/Wd<7>") getData("/I21/Wd<6>") getData("/I21/Wd<5>") getData("/I21/Wd<4>") getData("/I21/Wd<3>") getData("/I21/Wd<2>") getData("/I21/Wd<1>") getData("/I21/Wd<0>") getData("/I21/Rd<11>") getData("/I21/Rd<10>") getData("/I21/Rd<9>") getData("/I21/Rd<8>") getData("/I21/RdAck<7>") getData("/I21/RdAck<6>") getData("/I21/RdAck<5>") getData("/I21/RdAck<4>") getData("/I21/RdAck<3>") getData("/I21/RdAck<2>") getData("/I21/RdAck<1>") getData("/I21/RdAck<0>") getData("/I21/Rd<23>") getData("/I21/Rd<22>") getData("/I21/Rd<21>") getData("/I21/Rd<20>") getData("/I21/Rd<27>") getData("/I21/Rd<26>") getData("/I21/Rd<25>") getData("/I21/Rd<24>") getData("/I21/Rd<31>") getData("/I21/Rd<30>") getData("/I21/Rd<29>") getData("/I21/Rd<28>") getData("/I21/Rd<19>") getData("/I21/Rd<18>") getData("/I21/Rd<17>") getData("/I21/Rd<16>") getData("/I21/Rd<7>") getData("/I21/Rd<6>") getData("/I21/Rd<5>") getData("/I21/Rd<4>") getData("/I21/Rd<3>") getData("/I21/Rd<2>") getData("/I21/Rd<1>") getData("/I21/Rd<0>") getData("/I21/Rd<15>") getData("/I21/Rd<14>") getData("/I21/Rd<13>") getData("/I21/Rd<12>") getData("/I21/WdBank0<31>") getData("/I21/WdBank0<30>") getData("/I21/WdBank0<29>") getData("/I21/WdBank0<28>") getData("/I21/WdBank0<27>") getData("/I21/WdBank0<26>") getData("/I21/WdBank0<25>") getData("/I21/WdBank0<24>") getData("/I21/WdBank0<23>") getData("/I21/WdBank0<22>") getData("/I21/WdBank0<21>") getData("/I21/WdBank0<20>") getData("/I21/WdBank0<19>") getData("/I21/WdBank0<18>") getData("/I21/WdBank0<17>") getData("/I21/WdBank0<16>") getData("/I21/WdBank0<15>") getData("/I21/WdBank0<14>") getData("/I21/WdBank0<13>") getData("/I21/WdBank0<12>") getData("/I21/WdBank0<11>") getData("/I21/WdBank0<10>") getData("/I21/WdBank0<9>") getData("/I21/WdBank0<8>") getData("/I21/WdBank0<7>") getData("/I21/WdBank0<6>") getData("/I21/WdBank0<5>") getData("/I21/WdBank0<4>") getData("/I21/WdBank0<3>") getData("/I21/WdBank0<2>") getData("/I21/WdBank0<1>") getData("/I21/WdBank0<0>") getData("/I21/Bank0WAck<7>") getData("/I21/Bank0WAck<6>") getData("/I21/Bank0WAck<5>") getData("/I21/Bank0WAck<4>") getData("/I21/Bank0WAck<3>") getData("/I21/Bank0WAck<2>") getData("/I21/Bank0WAck<1>") getData("/I21/Bank0WAck<0>") getData("/I21/WdBank1<31>") getData("/I21/WdBank1<30>") getData("/I21/WdBank1<29>") getData("/I21/WdBank1<28>") getData("/I21/WdBank1<27>") getData("/I21/WdBank1<26>") getData("/I21/WdBank1<25>") getData("/I21/WdBank1<24>") getData("/I21/WdBank1<23>") getData("/I21/WdBank1<22>") getData("/I21/WdBank1<21>") getData("/I21/WdBank1<20>") getData("/I21/WdBank1<19>") getData("/I21/WdBank1<18>") getData("/I21/WdBank1<17>") getData("/I21/WdBank1<16>") getData("/I21/WdBank1<15>") getData("/I21/WdBank1<14>") getData("/I21/WdBank1<13>") getData("/I21/WdBank1<12>") getData("/I21/WdBank1<11>") getData("/I21/WdBank1<10>") getData("/I21/WdBank1<9>") getData("/I21/WdBank1<8>") getData("/I21/WdBank1<7>") getData("/I21/WdBank1<6>") getData("/I21/WdBank1<5>") getData("/I21/WdBank1<4>") getData("/I21/WdBank1<3>") getData("/I21/WdBank1<2>") getData("/I21/WdBank1<1>") getData("/I21/WdBank1<0>") getData("/I21/Bank1WAck<7>") getData("/I21/Bank1WAck<6>") getData("/I21/Bank1WAck<5>") getData("/I21/Bank1WAck<4>") getData("/I21/Bank1WAck<3>") getData("/I21/Bank1WAck<2>") getData("/I21/Bank1WAck<1>") getData("/I21/Bank1WAck<0>") getData("/I21/net0201") getData("/I21/net0205") getData("/I21/net018") getData("/I21/net017") getData("/I21/net022") getData("/I21/net021") getData("/I21/net020") getData("/I21/net019") getData("/I21/RdBank0<31>") getData("/I21/RdBank0<30>") getData("/I21/RdBank0<29>") getData("/I21/RdBank0<28>") getData("/I21/RdBank0<27>") getData("/I21/RdBank0<26>") getData("/I21/RdBank0<25>") getData("/I21/RdBank0<24>") getData("/I21/RdBank0<23>") getData("/I21/RdBank0<22>") getData("/I21/RdBank0<21>") getData("/I21/RdBank0<20>") getData("/I21/RdBank0<19>") getData("/I21/RdBank0<18>") getData("/I21/RdBank0<17>") getData("/I21/RdBank0<16>") getData("/I21/RdBank0<15>") getData("/I21/RdBank0<14>") getData("/I21/RdBank0<13>") getData("/I21/RdBank0<12>") getData("/I21/RdBank0<11>") getData("/I21/RdBank0<10>") getData("/I21/RdBank0<9>") getData("/I21/RdBank0<8>") getData("/I21/RdBank0<7>") getData("/I21/RdBank0<6>") getData("/I21/RdBank0<5>") getData("/I21/RdBank0<4>") getData("/I21/RdBank0<3>") getData("/I21/RdBank0<2>") getData("/I21/RdBank0<1>") getData("/I21/RdBank0<0>") getData("/I21/RdBank0Ack<7>") getData("/I21/RdBank0Ack<6>") getData("/I21/RdBank0Ack<5>") getData("/I21/RdBank0Ack<4>") getData("/I21/RdBank0Ack<3>") getData("/I21/RdBank0Ack<2>") getData("/I21/RdBank0Ack<1>") getData("/I21/RdBank0Ack<0>") getData("/I21/RdBank1<31>") getData("/I21/RdBank1<30>") getData("/I21/RdBank1<29>") getData("/I21/RdBank1<28>") getData("/I21/RdBank1<27>") getData("/I21/RdBank1<26>") getData("/I21/RdBank1<25>") getData("/I21/RdBank1<24>") getData("/I21/RdBank1<23>") getData("/I21/RdBank1<22>") getData("/I21/RdBank1<21>") getData("/I21/RdBank1<20>") getData("/I21/RdBank1<19>") getData("/I21/RdBank1<18>") getData("/I21/RdBank1<17>") getData("/I21/RdBank1<16>") getData("/I21/RdBank1<15>") getData("/I21/RdBank1<14>") getData("/I21/RdBank1<13>") getData("/I21/RdBank1<12>") getData("/I21/RdBank1<11>") getData("/I21/RdBank1<10>") getData("/I21/RdBank1<9>") getData("/I21/RdBank1<8>") getData("/I21/RdBank1<7>") getData("/I21/RdBank1<6>") getData("/I21/RdBank1<5>") getData("/I21/RdBank1<4>") getData("/I21/RdBank1<3>") getData("/I21/RdBank1<2>") getData("/I21/RdBank1<1>") getData("/I21/RdBank1<0>") getData("/I21/RdBank1Ack<7>") getData("/I21/RdBank1Ack<6>") getData("/I21/RdBank1Ack<5>") getData("/I21/RdBank1Ack<4>") getData("/I21/RdBank1Ack<3>") getData("/I21/RdBank1Ack<2>") getData("/I21/RdBank1Ack<1>") getData("/I21/RdBank1Ack<0>") getData("/WData<15:0>") )
resultsDir( "/net/bull/apps/Cadence/simulation/6T_MultiBank_8K_4K_Test/spectreVerilog/config/distributed/MBank_8K_r4K_500mV_58C" )
modelFile(
    '("/software/cadence/ncsu-FreePDK15/hspice_16nm_hp.include" "")
)
option(	'temp  "57.5"
)
temp( 57.5 )
run( ?jobName "job" ?queue "c2107" ?host "krait" )
selectResult( 'tran )
plot(getData("/ReadEn") getData("/R_Address<11:0>") getData("/W_Address<11:0>") getData("/WriteEn") getData("/WDataAck<7:0>") getData("/RData<15:0>") getData("/ReadAck") getData("/WriteAck") getData("/RAckT") getData("/RDataT<15>") getData("/RDataT<14>") getData("/RDataT<13>") getData("/RDataT<12>") getData("/RDataT<11>") getData("/RDataT<10>") getData("/RDataT<9>") getData("/RDataT<8>") getData("/RDataT<7>") getData("/RDataT<6>") getData("/RDataT<5>") getData("/RDataT<4>") getData("/RDataT<3>") getData("/RDataT<2>") getData("/RDataT<1>") getData("/RDataT<0>") getData("/WAckT") getData("/R_AddressT<11>") getData("/R_AddressT<10>") getData("/R_AddressT<9>") getData("/R_AddressT<8>") getData("/R_AddressT<7>") getData("/R_AddressT<6>") getData("/R_AddressT<5>") getData("/R_AddressT<4>") getData("/R_AddressT<3>") getData("/R_AddressT<2>") getData("/R_AddressT<1>") getData("/R_AddressT<0>") getData("/ReadEnT") getData("/W_AddressT<11>") getData("/W_AddressT<10>") getData("/W_AddressT<9>") getData("/W_AddressT<8>") getData("/W_AddressT<7>") getData("/W_AddressT<6>") getData("/W_AddressT<5>") getData("/W_AddressT<4>") getData("/W_AddressT<3>") getData("/W_AddressT<2>") getData("/W_AddressT<1>") getData("/W_AddressT<0>") getData("/WriteEnT") getData("/WDataT<15>") getData("/WDataT<14>") getData("/WDataT<13>") getData("/WDataT<12>") getData("/WDataT<11>") getData("/WDataT<10>") getData("/WDataT<9>") getData("/WDataT<8>") getData("/WDataT<7>") getData("/WDataT<6>") getData("/WDataT<5>") getData("/WDataT<4>") getData("/WDataT<3>") getData("/WDataT<2>") getData("/WDataT<1>") getData("/WDataT<0>") getData("/WDataAckT<7>") getData("/WDataAckT<6>") getData("/WDataAckT<5>") getData("/WDataAckT<4>") getData("/WDataAckT<3>") getData("/WDataAckT<2>") getData("/WDataAckT<1>") getData("/WDataAckT<0>") getData("/V0/MINUS") getData("/I21/Wd<31>") getData("/I21/Wd<30>") getData("/I21/Wd<29>") getData("/I21/Wd<28>") getData("/I21/Wd<19>") getData("/I21/Wd<18>") getData("/I21/Wd<17>") getData("/I21/Wd<16>") getData("/I21/Wd<23>") getData("/I21/Wd<22>") getData("/I21/Wd<21>") getData("/I21/Wd<20>") getData("/I21/Wd<27>") getData("/I21/Wd<26>") getData("/I21/Wd<25>") getData("/I21/Wd<24>") getData("/I21/WdAck<7>") getData("/I21/WdAck<6>") getData("/I21/WdAck<5>") getData("/I21/WdAck<4>") getData("/I21/WdAck<3>") getData("/I21/WdAck<2>") getData("/I21/WdAck<1>") getData("/I21/WdAck<0>") getData("/I21/Wd<11>") getData("/I21/Wd<10>") getData("/I21/Wd<9>") getData("/I21/Wd<8>") getData("/I21/Wd<15>") getData("/I21/Wd<14>") getData("/I21/Wd<13>") getData("/I21/Wd<12>") getData("/I21/Wd<7>") getData("/I21/Wd<6>") getData("/I21/Wd<5>") getData("/I21/Wd<4>") getData("/I21/Wd<3>") getData("/I21/Wd<2>") getData("/I21/Wd<1>") getData("/I21/Wd<0>") getData("/I21/Rd<11>") getData("/I21/Rd<10>") getData("/I21/Rd<9>") getData("/I21/Rd<8>") getData("/I21/RdAck<7>") getData("/I21/RdAck<6>") getData("/I21/RdAck<5>") getData("/I21/RdAck<4>") getData("/I21/RdAck<3>") getData("/I21/RdAck<2>") getData("/I21/RdAck<1>") getData("/I21/RdAck<0>") getData("/I21/Rd<23>") getData("/I21/Rd<22>") getData("/I21/Rd<21>") getData("/I21/Rd<20>") getData("/I21/Rd<27>") getData("/I21/Rd<26>") getData("/I21/Rd<25>") getData("/I21/Rd<24>") getData("/I21/Rd<31>") getData("/I21/Rd<30>") getData("/I21/Rd<29>") getData("/I21/Rd<28>") getData("/I21/Rd<19>") getData("/I21/Rd<18>") getData("/I21/Rd<17>") getData("/I21/Rd<16>") getData("/I21/Rd<7>") getData("/I21/Rd<6>") getData("/I21/Rd<5>") getData("/I21/Rd<4>") getData("/I21/Rd<3>") getData("/I21/Rd<2>") getData("/I21/Rd<1>") getData("/I21/Rd<0>") getData("/I21/Rd<15>") getData("/I21/Rd<14>") getData("/I21/Rd<13>") getData("/I21/Rd<12>") getData("/I21/WdBank0<31>") getData("/I21/WdBank0<30>") getData("/I21/WdBank0<29>") getData("/I21/WdBank0<28>") getData("/I21/WdBank0<27>") getData("/I21/WdBank0<26>") getData("/I21/WdBank0<25>") getData("/I21/WdBank0<24>") getData("/I21/WdBank0<23>") getData("/I21/WdBank0<22>") getData("/I21/WdBank0<21>") getData("/I21/WdBank0<20>") getData("/I21/WdBank0<19>") getData("/I21/WdBank0<18>") getData("/I21/WdBank0<17>") getData("/I21/WdBank0<16>") getData("/I21/WdBank0<15>") getData("/I21/WdBank0<14>") getData("/I21/WdBank0<13>") getData("/I21/WdBank0<12>") getData("/I21/WdBank0<11>") getData("/I21/WdBank0<10>") getData("/I21/WdBank0<9>") getData("/I21/WdBank0<8>") getData("/I21/WdBank0<7>") getData("/I21/WdBank0<6>") getData("/I21/WdBank0<5>") getData("/I21/WdBank0<4>") getData("/I21/WdBank0<3>") getData("/I21/WdBank0<2>") getData("/I21/WdBank0<1>") getData("/I21/WdBank0<0>") getData("/I21/Bank0WAck<7>") getData("/I21/Bank0WAck<6>") getData("/I21/Bank0WAck<5>") getData("/I21/Bank0WAck<4>") getData("/I21/Bank0WAck<3>") getData("/I21/Bank0WAck<2>") getData("/I21/Bank0WAck<1>") getData("/I21/Bank0WAck<0>") getData("/I21/WdBank1<31>") getData("/I21/WdBank1<30>") getData("/I21/WdBank1<29>") getData("/I21/WdBank1<28>") getData("/I21/WdBank1<27>") getData("/I21/WdBank1<26>") getData("/I21/WdBank1<25>") getData("/I21/WdBank1<24>") getData("/I21/WdBank1<23>") getData("/I21/WdBank1<22>") getData("/I21/WdBank1<21>") getData("/I21/WdBank1<20>") getData("/I21/WdBank1<19>") getData("/I21/WdBank1<18>") getData("/I21/WdBank1<17>") getData("/I21/WdBank1<16>") getData("/I21/WdBank1<15>") getData("/I21/WdBank1<14>") getData("/I21/WdBank1<13>") getData("/I21/WdBank1<12>") getData("/I21/WdBank1<11>") getData("/I21/WdBank1<10>") getData("/I21/WdBank1<9>") getData("/I21/WdBank1<8>") getData("/I21/WdBank1<7>") getData("/I21/WdBank1<6>") getData("/I21/WdBank1<5>") getData("/I21/WdBank1<4>") getData("/I21/WdBank1<3>") getData("/I21/WdBank1<2>") getData("/I21/WdBank1<1>") getData("/I21/WdBank1<0>") getData("/I21/Bank1WAck<7>") getData("/I21/Bank1WAck<6>") getData("/I21/Bank1WAck<5>") getData("/I21/Bank1WAck<4>") getData("/I21/Bank1WAck<3>") getData("/I21/Bank1WAck<2>") getData("/I21/Bank1WAck<1>") getData("/I21/Bank1WAck<0>") getData("/I21/net0201") getData("/I21/net0205") getData("/I21/net018") getData("/I21/net017") getData("/I21/net022") getData("/I21/net021") getData("/I21/net020") getData("/I21/net019") getData("/I21/RdBank0<31>") getData("/I21/RdBank0<30>") getData("/I21/RdBank0<29>") getData("/I21/RdBank0<28>") getData("/I21/RdBank0<27>") getData("/I21/RdBank0<26>") getData("/I21/RdBank0<25>") getData("/I21/RdBank0<24>") getData("/I21/RdBank0<23>") getData("/I21/RdBank0<22>") getData("/I21/RdBank0<21>") getData("/I21/RdBank0<20>") getData("/I21/RdBank0<19>") getData("/I21/RdBank0<18>") getData("/I21/RdBank0<17>") getData("/I21/RdBank0<16>") getData("/I21/RdBank0<15>") getData("/I21/RdBank0<14>") getData("/I21/RdBank0<13>") getData("/I21/RdBank0<12>") getData("/I21/RdBank0<11>") getData("/I21/RdBank0<10>") getData("/I21/RdBank0<9>") getData("/I21/RdBank0<8>") getData("/I21/RdBank0<7>") getData("/I21/RdBank0<6>") getData("/I21/RdBank0<5>") getData("/I21/RdBank0<4>") getData("/I21/RdBank0<3>") getData("/I21/RdBank0<2>") getData("/I21/RdBank0<1>") getData("/I21/RdBank0<0>") getData("/I21/RdBank0Ack<7>") getData("/I21/RdBank0Ack<6>") getData("/I21/RdBank0Ack<5>") getData("/I21/RdBank0Ack<4>") getData("/I21/RdBank0Ack<3>") getData("/I21/RdBank0Ack<2>") getData("/I21/RdBank0Ack<1>") getData("/I21/RdBank0Ack<0>") getData("/I21/RdBank1<31>") getData("/I21/RdBank1<30>") getData("/I21/RdBank1<29>") getData("/I21/RdBank1<28>") getData("/I21/RdBank1<27>") getData("/I21/RdBank1<26>") getData("/I21/RdBank1<25>") getData("/I21/RdBank1<24>") getData("/I21/RdBank1<23>") getData("/I21/RdBank1<22>") getData("/I21/RdBank1<21>") getData("/I21/RdBank1<20>") getData("/I21/RdBank1<19>") getData("/I21/RdBank1<18>") getData("/I21/RdBank1<17>") getData("/I21/RdBank1<16>") getData("/I21/RdBank1<15>") getData("/I21/RdBank1<14>") getData("/I21/RdBank1<13>") getData("/I21/RdBank1<12>") getData("/I21/RdBank1<11>") getData("/I21/RdBank1<10>") getData("/I21/RdBank1<9>") getData("/I21/RdBank1<8>") getData("/I21/RdBank1<7>") getData("/I21/RdBank1<6>") getData("/I21/RdBank1<5>") getData("/I21/RdBank1<4>") getData("/I21/RdBank1<3>") getData("/I21/RdBank1<2>") getData("/I21/RdBank1<1>") getData("/I21/RdBank1<0>") getData("/I21/RdBank1Ack<7>") getData("/I21/RdBank1Ack<6>") getData("/I21/RdBank1Ack<5>") getData("/I21/RdBank1Ack<4>") getData("/I21/RdBank1Ack<3>") getData("/I21/RdBank1Ack<2>") getData("/I21/RdBank1Ack<1>") getData("/I21/RdBank1Ack<0>") getData("/WData<15:0>") )
resultsDir( "/net/bull/apps/Cadence/simulation/6T_MultiBank_8K_4K_Test/spectreVerilog/config/distributed/MBank_8K_r4K_500mV_85C" )
modelFile(
    '("/software/cadence/ncsu-FreePDK15/hspice_16nm_hp.include" "")
)
option(	'temp  "85.0"
)
temp( 85.0 )
run( ?jobName "job" ?queue "c2107" ?host "asp" )
selectResult( 'tran )
plot(getData("/ReadEn") getData("/R_Address<11:0>") getData("/W_Address<11:0>") getData("/WriteEn") getData("/WDataAck<7:0>") getData("/RData<15:0>") getData("/ReadAck") getData("/WriteAck") getData("/RAckT") getData("/RDataT<15>") getData("/RDataT<14>") getData("/RDataT<13>") getData("/RDataT<12>") getData("/RDataT<11>") getData("/RDataT<10>") getData("/RDataT<9>") getData("/RDataT<8>") getData("/RDataT<7>") getData("/RDataT<6>") getData("/RDataT<5>") getData("/RDataT<4>") getData("/RDataT<3>") getData("/RDataT<2>") getData("/RDataT<1>") getData("/RDataT<0>") getData("/WAckT") getData("/R_AddressT<11>") getData("/R_AddressT<10>") getData("/R_AddressT<9>") getData("/R_AddressT<8>") getData("/R_AddressT<7>") getData("/R_AddressT<6>") getData("/R_AddressT<5>") getData("/R_AddressT<4>") getData("/R_AddressT<3>") getData("/R_AddressT<2>") getData("/R_AddressT<1>") getData("/R_AddressT<0>") getData("/ReadEnT") getData("/W_AddressT<11>") getData("/W_AddressT<10>") getData("/W_AddressT<9>") getData("/W_AddressT<8>") getData("/W_AddressT<7>") getData("/W_AddressT<6>") getData("/W_AddressT<5>") getData("/W_AddressT<4>") getData("/W_AddressT<3>") getData("/W_AddressT<2>") getData("/W_AddressT<1>") getData("/W_AddressT<0>") getData("/WriteEnT") getData("/WDataT<15>") getData("/WDataT<14>") getData("/WDataT<13>") getData("/WDataT<12>") getData("/WDataT<11>") getData("/WDataT<10>") getData("/WDataT<9>") getData("/WDataT<8>") getData("/WDataT<7>") getData("/WDataT<6>") getData("/WDataT<5>") getData("/WDataT<4>") getData("/WDataT<3>") getData("/WDataT<2>") getData("/WDataT<1>") getData("/WDataT<0>") getData("/WDataAckT<7>") getData("/WDataAckT<6>") getData("/WDataAckT<5>") getData("/WDataAckT<4>") getData("/WDataAckT<3>") getData("/WDataAckT<2>") getData("/WDataAckT<1>") getData("/WDataAckT<0>") getData("/V0/MINUS") getData("/I21/Wd<31>") getData("/I21/Wd<30>") getData("/I21/Wd<29>") getData("/I21/Wd<28>") getData("/I21/Wd<19>") getData("/I21/Wd<18>") getData("/I21/Wd<17>") getData("/I21/Wd<16>") getData("/I21/Wd<23>") getData("/I21/Wd<22>") getData("/I21/Wd<21>") getData("/I21/Wd<20>") getData("/I21/Wd<27>") getData("/I21/Wd<26>") getData("/I21/Wd<25>") getData("/I21/Wd<24>") getData("/I21/WdAck<7>") getData("/I21/WdAck<6>") getData("/I21/WdAck<5>") getData("/I21/WdAck<4>") getData("/I21/WdAck<3>") getData("/I21/WdAck<2>") getData("/I21/WdAck<1>") getData("/I21/WdAck<0>") getData("/I21/Wd<11>") getData("/I21/Wd<10>") getData("/I21/Wd<9>") getData("/I21/Wd<8>") getData("/I21/Wd<15>") getData("/I21/Wd<14>") getData("/I21/Wd<13>") getData("/I21/Wd<12>") getData("/I21/Wd<7>") getData("/I21/Wd<6>") getData("/I21/Wd<5>") getData("/I21/Wd<4>") getData("/I21/Wd<3>") getData("/I21/Wd<2>") getData("/I21/Wd<1>") getData("/I21/Wd<0>") getData("/I21/Rd<11>") getData("/I21/Rd<10>") getData("/I21/Rd<9>") getData("/I21/Rd<8>") getData("/I21/RdAck<7>") getData("/I21/RdAck<6>") getData("/I21/RdAck<5>") getData("/I21/RdAck<4>") getData("/I21/RdAck<3>") getData("/I21/RdAck<2>") getData("/I21/RdAck<1>") getData("/I21/RdAck<0>") getData("/I21/Rd<23>") getData("/I21/Rd<22>") getData("/I21/Rd<21>") getData("/I21/Rd<20>") getData("/I21/Rd<27>") getData("/I21/Rd<26>") getData("/I21/Rd<25>") getData("/I21/Rd<24>") getData("/I21/Rd<31>") getData("/I21/Rd<30>") getData("/I21/Rd<29>") getData("/I21/Rd<28>") getData("/I21/Rd<19>") getData("/I21/Rd<18>") getData("/I21/Rd<17>") getData("/I21/Rd<16>") getData("/I21/Rd<7>") getData("/I21/Rd<6>") getData("/I21/Rd<5>") getData("/I21/Rd<4>") getData("/I21/Rd<3>") getData("/I21/Rd<2>") getData("/I21/Rd<1>") getData("/I21/Rd<0>") getData("/I21/Rd<15>") getData("/I21/Rd<14>") getData("/I21/Rd<13>") getData("/I21/Rd<12>") getData("/I21/WdBank0<31>") getData("/I21/WdBank0<30>") getData("/I21/WdBank0<29>") getData("/I21/WdBank0<28>") getData("/I21/WdBank0<27>") getData("/I21/WdBank0<26>") getData("/I21/WdBank0<25>") getData("/I21/WdBank0<24>") getData("/I21/WdBank0<23>") getData("/I21/WdBank0<22>") getData("/I21/WdBank0<21>") getData("/I21/WdBank0<20>") getData("/I21/WdBank0<19>") getData("/I21/WdBank0<18>") getData("/I21/WdBank0<17>") getData("/I21/WdBank0<16>") getData("/I21/WdBank0<15>") getData("/I21/WdBank0<14>") getData("/I21/WdBank0<13>") getData("/I21/WdBank0<12>") getData("/I21/WdBank0<11>") getData("/I21/WdBank0<10>") getData("/I21/WdBank0<9>") getData("/I21/WdBank0<8>") getData("/I21/WdBank0<7>") getData("/I21/WdBank0<6>") getData("/I21/WdBank0<5>") getData("/I21/WdBank0<4>") getData("/I21/WdBank0<3>") getData("/I21/WdBank0<2>") getData("/I21/WdBank0<1>") getData("/I21/WdBank0<0>") getData("/I21/Bank0WAck<7>") getData("/I21/Bank0WAck<6>") getData("/I21/Bank0WAck<5>") getData("/I21/Bank0WAck<4>") getData("/I21/Bank0WAck<3>") getData("/I21/Bank0WAck<2>") getData("/I21/Bank0WAck<1>") getData("/I21/Bank0WAck<0>") getData("/I21/WdBank1<31>") getData("/I21/WdBank1<30>") getData("/I21/WdBank1<29>") getData("/I21/WdBank1<28>") getData("/I21/WdBank1<27>") getData("/I21/WdBank1<26>") getData("/I21/WdBank1<25>") getData("/I21/WdBank1<24>") getData("/I21/WdBank1<23>") getData("/I21/WdBank1<22>") getData("/I21/WdBank1<21>") getData("/I21/WdBank1<20>") getData("/I21/WdBank1<19>") getData("/I21/WdBank1<18>") getData("/I21/WdBank1<17>") getData("/I21/WdBank1<16>") getData("/I21/WdBank1<15>") getData("/I21/WdBank1<14>") getData("/I21/WdBank1<13>") getData("/I21/WdBank1<12>") getData("/I21/WdBank1<11>") getData("/I21/WdBank1<10>") getData("/I21/WdBank1<9>") getData("/I21/WdBank1<8>") getData("/I21/WdBank1<7>") getData("/I21/WdBank1<6>") getData("/I21/WdBank1<5>") getData("/I21/WdBank1<4>") getData("/I21/WdBank1<3>") getData("/I21/WdBank1<2>") getData("/I21/WdBank1<1>") getData("/I21/WdBank1<0>") getData("/I21/Bank1WAck<7>") getData("/I21/Bank1WAck<6>") getData("/I21/Bank1WAck<5>") getData("/I21/Bank1WAck<4>") getData("/I21/Bank1WAck<3>") getData("/I21/Bank1WAck<2>") getData("/I21/Bank1WAck<1>") getData("/I21/Bank1WAck<0>") getData("/I21/net0201") getData("/I21/net0205") getData("/I21/net018") getData("/I21/net017") getData("/I21/net022") getData("/I21/net021") getData("/I21/net020") getData("/I21/net019") getData("/I21/RdBank0<31>") getData("/I21/RdBank0<30>") getData("/I21/RdBank0<29>") getData("/I21/RdBank0<28>") getData("/I21/RdBank0<27>") getData("/I21/RdBank0<26>") getData("/I21/RdBank0<25>") getData("/I21/RdBank0<24>") getData("/I21/RdBank0<23>") getData("/I21/RdBank0<22>") getData("/I21/RdBank0<21>") getData("/I21/RdBank0<20>") getData("/I21/RdBank0<19>") getData("/I21/RdBank0<18>") getData("/I21/RdBank0<17>") getData("/I21/RdBank0<16>") getData("/I21/RdBank0<15>") getData("/I21/RdBank0<14>") getData("/I21/RdBank0<13>") getData("/I21/RdBank0<12>") getData("/I21/RdBank0<11>") getData("/I21/RdBank0<10>") getData("/I21/RdBank0<9>") getData("/I21/RdBank0<8>") getData("/I21/RdBank0<7>") getData("/I21/RdBank0<6>") getData("/I21/RdBank0<5>") getData("/I21/RdBank0<4>") getData("/I21/RdBank0<3>") getData("/I21/RdBank0<2>") getData("/I21/RdBank0<1>") getData("/I21/RdBank0<0>") getData("/I21/RdBank0Ack<7>") getData("/I21/RdBank0Ack<6>") getData("/I21/RdBank0Ack<5>") getData("/I21/RdBank0Ack<4>") getData("/I21/RdBank0Ack<3>") getData("/I21/RdBank0Ack<2>") getData("/I21/RdBank0Ack<1>") getData("/I21/RdBank0Ack<0>") getData("/I21/RdBank1<31>") getData("/I21/RdBank1<30>") getData("/I21/RdBank1<29>") getData("/I21/RdBank1<28>") getData("/I21/RdBank1<27>") getData("/I21/RdBank1<26>") getData("/I21/RdBank1<25>") getData("/I21/RdBank1<24>") getData("/I21/RdBank1<23>") getData("/I21/RdBank1<22>") getData("/I21/RdBank1<21>") getData("/I21/RdBank1<20>") getData("/I21/RdBank1<19>") getData("/I21/RdBank1<18>") getData("/I21/RdBank1<17>") getData("/I21/RdBank1<16>") getData("/I21/RdBank1<15>") getData("/I21/RdBank1<14>") getData("/I21/RdBank1<13>") getData("/I21/RdBank1<12>") getData("/I21/RdBank1<11>") getData("/I21/RdBank1<10>") getData("/I21/RdBank1<9>") getData("/I21/RdBank1<8>") getData("/I21/RdBank1<7>") getData("/I21/RdBank1<6>") getData("/I21/RdBank1<5>") getData("/I21/RdBank1<4>") getData("/I21/RdBank1<3>") getData("/I21/RdBank1<2>") getData("/I21/RdBank1<1>") getData("/I21/RdBank1<0>") getData("/I21/RdBank1Ack<7>") getData("/I21/RdBank1Ack<6>") getData("/I21/RdBank1Ack<5>") getData("/I21/RdBank1Ack<4>") getData("/I21/RdBank1Ack<3>") getData("/I21/RdBank1Ack<2>") getData("/I21/RdBank1Ack<1>") getData("/I21/RdBank1Ack<0>") getData("/WData<15:0>") )
resultsDir( "/net/bull/apps/Cadence/simulation/6T_MultiBank_8K_4K_Test/spectreVerilog/config/distributed/MBank_8K_r4K_675mV_30C" )
modelFile(
    '("/software/cadence/ncsu-FreePDK15/hspice_16nm_hp.include" "")
)
desVar(	  "vdd" .675	)
option(	'temp  "30.0"
)
temp( 30.0 )
run( ?jobName "job" ?queue "c2107" ?host "rat" )
selectResult( 'tran )
plot(getData("/ReadEn") getData("/R_Address<11:0>") getData("/W_Address<11:0>") getData("/WriteEn") getData("/WDataAck<7:0>") getData("/RData<15:0>") getData("/ReadAck") getData("/WriteAck") getData("/RAckT") getData("/RDataT<15>") getData("/RDataT<14>") getData("/RDataT<13>") getData("/RDataT<12>") getData("/RDataT<11>") getData("/RDataT<10>") getData("/RDataT<9>") getData("/RDataT<8>") getData("/RDataT<7>") getData("/RDataT<6>") getData("/RDataT<5>") getData("/RDataT<4>") getData("/RDataT<3>") getData("/RDataT<2>") getData("/RDataT<1>") getData("/RDataT<0>") getData("/WAckT") getData("/R_AddressT<11>") getData("/R_AddressT<10>") getData("/R_AddressT<9>") getData("/R_AddressT<8>") getData("/R_AddressT<7>") getData("/R_AddressT<6>") getData("/R_AddressT<5>") getData("/R_AddressT<4>") getData("/R_AddressT<3>") getData("/R_AddressT<2>") getData("/R_AddressT<1>") getData("/R_AddressT<0>") getData("/ReadEnT") getData("/W_AddressT<11>") getData("/W_AddressT<10>") getData("/W_AddressT<9>") getData("/W_AddressT<8>") getData("/W_AddressT<7>") getData("/W_AddressT<6>") getData("/W_AddressT<5>") getData("/W_AddressT<4>") getData("/W_AddressT<3>") getData("/W_AddressT<2>") getData("/W_AddressT<1>") getData("/W_AddressT<0>") getData("/WriteEnT") getData("/WDataT<15>") getData("/WDataT<14>") getData("/WDataT<13>") getData("/WDataT<12>") getData("/WDataT<11>") getData("/WDataT<10>") getData("/WDataT<9>") getData("/WDataT<8>") getData("/WDataT<7>") getData("/WDataT<6>") getData("/WDataT<5>") getData("/WDataT<4>") getData("/WDataT<3>") getData("/WDataT<2>") getData("/WDataT<1>") getData("/WDataT<0>") getData("/WDataAckT<7>") getData("/WDataAckT<6>") getData("/WDataAckT<5>") getData("/WDataAckT<4>") getData("/WDataAckT<3>") getData("/WDataAckT<2>") getData("/WDataAckT<1>") getData("/WDataAckT<0>") getData("/V0/MINUS") getData("/I21/Wd<31>") getData("/I21/Wd<30>") getData("/I21/Wd<29>") getData("/I21/Wd<28>") getData("/I21/Wd<19>") getData("/I21/Wd<18>") getData("/I21/Wd<17>") getData("/I21/Wd<16>") getData("/I21/Wd<23>") getData("/I21/Wd<22>") getData("/I21/Wd<21>") getData("/I21/Wd<20>") getData("/I21/Wd<27>") getData("/I21/Wd<26>") getData("/I21/Wd<25>") getData("/I21/Wd<24>") getData("/I21/WdAck<7>") getData("/I21/WdAck<6>") getData("/I21/WdAck<5>") getData("/I21/WdAck<4>") getData("/I21/WdAck<3>") getData("/I21/WdAck<2>") getData("/I21/WdAck<1>") getData("/I21/WdAck<0>") getData("/I21/Wd<11>") getData("/I21/Wd<10>") getData("/I21/Wd<9>") getData("/I21/Wd<8>") getData("/I21/Wd<15>") getData("/I21/Wd<14>") getData("/I21/Wd<13>") getData("/I21/Wd<12>") getData("/I21/Wd<7>") getData("/I21/Wd<6>") getData("/I21/Wd<5>") getData("/I21/Wd<4>") getData("/I21/Wd<3>") getData("/I21/Wd<2>") getData("/I21/Wd<1>") getData("/I21/Wd<0>") getData("/I21/Rd<11>") getData("/I21/Rd<10>") getData("/I21/Rd<9>") getData("/I21/Rd<8>") getData("/I21/RdAck<7>") getData("/I21/RdAck<6>") getData("/I21/RdAck<5>") getData("/I21/RdAck<4>") getData("/I21/RdAck<3>") getData("/I21/RdAck<2>") getData("/I21/RdAck<1>") getData("/I21/RdAck<0>") getData("/I21/Rd<23>") getData("/I21/Rd<22>") getData("/I21/Rd<21>") getData("/I21/Rd<20>") getData("/I21/Rd<27>") getData("/I21/Rd<26>") getData("/I21/Rd<25>") getData("/I21/Rd<24>") getData("/I21/Rd<31>") getData("/I21/Rd<30>") getData("/I21/Rd<29>") getData("/I21/Rd<28>") getData("/I21/Rd<19>") getData("/I21/Rd<18>") getData("/I21/Rd<17>") getData("/I21/Rd<16>") getData("/I21/Rd<7>") getData("/I21/Rd<6>") getData("/I21/Rd<5>") getData("/I21/Rd<4>") getData("/I21/Rd<3>") getData("/I21/Rd<2>") getData("/I21/Rd<1>") getData("/I21/Rd<0>") getData("/I21/Rd<15>") getData("/I21/Rd<14>") getData("/I21/Rd<13>") getData("/I21/Rd<12>") getData("/I21/WdBank0<31>") getData("/I21/WdBank0<30>") getData("/I21/WdBank0<29>") getData("/I21/WdBank0<28>") getData("/I21/WdBank0<27>") getData("/I21/WdBank0<26>") getData("/I21/WdBank0<25>") getData("/I21/WdBank0<24>") getData("/I21/WdBank0<23>") getData("/I21/WdBank0<22>") getData("/I21/WdBank0<21>") getData("/I21/WdBank0<20>") getData("/I21/WdBank0<19>") getData("/I21/WdBank0<18>") getData("/I21/WdBank0<17>") getData("/I21/WdBank0<16>") getData("/I21/WdBank0<15>") getData("/I21/WdBank0<14>") getData("/I21/WdBank0<13>") getData("/I21/WdBank0<12>") getData("/I21/WdBank0<11>") getData("/I21/WdBank0<10>") getData("/I21/WdBank0<9>") getData("/I21/WdBank0<8>") getData("/I21/WdBank0<7>") getData("/I21/WdBank0<6>") getData("/I21/WdBank0<5>") getData("/I21/WdBank0<4>") getData("/I21/WdBank0<3>") getData("/I21/WdBank0<2>") getData("/I21/WdBank0<1>") getData("/I21/WdBank0<0>") getData("/I21/Bank0WAck<7>") getData("/I21/Bank0WAck<6>") getData("/I21/Bank0WAck<5>") getData("/I21/Bank0WAck<4>") getData("/I21/Bank0WAck<3>") getData("/I21/Bank0WAck<2>") getData("/I21/Bank0WAck<1>") getData("/I21/Bank0WAck<0>") getData("/I21/WdBank1<31>") getData("/I21/WdBank1<30>") getData("/I21/WdBank1<29>") getData("/I21/WdBank1<28>") getData("/I21/WdBank1<27>") getData("/I21/WdBank1<26>") getData("/I21/WdBank1<25>") getData("/I21/WdBank1<24>") getData("/I21/WdBank1<23>") getData("/I21/WdBank1<22>") getData("/I21/WdBank1<21>") getData("/I21/WdBank1<20>") getData("/I21/WdBank1<19>") getData("/I21/WdBank1<18>") getData("/I21/WdBank1<17>") getData("/I21/WdBank1<16>") getData("/I21/WdBank1<15>") getData("/I21/WdBank1<14>") getData("/I21/WdBank1<13>") getData("/I21/WdBank1<12>") getData("/I21/WdBank1<11>") getData("/I21/WdBank1<10>") getData("/I21/WdBank1<9>") getData("/I21/WdBank1<8>") getData("/I21/WdBank1<7>") getData("/I21/WdBank1<6>") getData("/I21/WdBank1<5>") getData("/I21/WdBank1<4>") getData("/I21/WdBank1<3>") getData("/I21/WdBank1<2>") getData("/I21/WdBank1<1>") getData("/I21/WdBank1<0>") getData("/I21/Bank1WAck<7>") getData("/I21/Bank1WAck<6>") getData("/I21/Bank1WAck<5>") getData("/I21/Bank1WAck<4>") getData("/I21/Bank1WAck<3>") getData("/I21/Bank1WAck<2>") getData("/I21/Bank1WAck<1>") getData("/I21/Bank1WAck<0>") getData("/I21/net0201") getData("/I21/net0205") getData("/I21/net018") getData("/I21/net017") getData("/I21/net022") getData("/I21/net021") getData("/I21/net020") getData("/I21/net019") getData("/I21/RdBank0<31>") getData("/I21/RdBank0<30>") getData("/I21/RdBank0<29>") getData("/I21/RdBank0<28>") getData("/I21/RdBank0<27>") getData("/I21/RdBank0<26>") getData("/I21/RdBank0<25>") getData("/I21/RdBank0<24>") getData("/I21/RdBank0<23>") getData("/I21/RdBank0<22>") getData("/I21/RdBank0<21>") getData("/I21/RdBank0<20>") getData("/I21/RdBank0<19>") getData("/I21/RdBank0<18>") getData("/I21/RdBank0<17>") getData("/I21/RdBank0<16>") getData("/I21/RdBank0<15>") getData("/I21/RdBank0<14>") getData("/I21/RdBank0<13>") getData("/I21/RdBank0<12>") getData("/I21/RdBank0<11>") getData("/I21/RdBank0<10>") getData("/I21/RdBank0<9>") getData("/I21/RdBank0<8>") getData("/I21/RdBank0<7>") getData("/I21/RdBank0<6>") getData("/I21/RdBank0<5>") getData("/I21/RdBank0<4>") getData("/I21/RdBank0<3>") getData("/I21/RdBank0<2>") getData("/I21/RdBank0<1>") getData("/I21/RdBank0<0>") getData("/I21/RdBank0Ack<7>") getData("/I21/RdBank0Ack<6>") getData("/I21/RdBank0Ack<5>") getData("/I21/RdBank0Ack<4>") getData("/I21/RdBank0Ack<3>") getData("/I21/RdBank0Ack<2>") getData("/I21/RdBank0Ack<1>") getData("/I21/RdBank0Ack<0>") getData("/I21/RdBank1<31>") getData("/I21/RdBank1<30>") getData("/I21/RdBank1<29>") getData("/I21/RdBank1<28>") getData("/I21/RdBank1<27>") getData("/I21/RdBank1<26>") getData("/I21/RdBank1<25>") getData("/I21/RdBank1<24>") getData("/I21/RdBank1<23>") getData("/I21/RdBank1<22>") getData("/I21/RdBank1<21>") getData("/I21/RdBank1<20>") getData("/I21/RdBank1<19>") getData("/I21/RdBank1<18>") getData("/I21/RdBank1<17>") getData("/I21/RdBank1<16>") getData("/I21/RdBank1<15>") getData("/I21/RdBank1<14>") getData("/I21/RdBank1<13>") getData("/I21/RdBank1<12>") getData("/I21/RdBank1<11>") getData("/I21/RdBank1<10>") getData("/I21/RdBank1<9>") getData("/I21/RdBank1<8>") getData("/I21/RdBank1<7>") getData("/I21/RdBank1<6>") getData("/I21/RdBank1<5>") getData("/I21/RdBank1<4>") getData("/I21/RdBank1<3>") getData("/I21/RdBank1<2>") getData("/I21/RdBank1<1>") getData("/I21/RdBank1<0>") getData("/I21/RdBank1Ack<7>") getData("/I21/RdBank1Ack<6>") getData("/I21/RdBank1Ack<5>") getData("/I21/RdBank1Ack<4>") getData("/I21/RdBank1Ack<3>") getData("/I21/RdBank1Ack<2>") getData("/I21/RdBank1Ack<1>") getData("/I21/RdBank1Ack<0>") getData("/WData<15:0>") )
resultsDir( "/net/bull/apps/Cadence/simulation/6T_MultiBank_8K_4K_Test/spectreVerilog/config/distributed/MBank_8K_r4K_675mV_58C" )
modelFile(
    '("/software/cadence/ncsu-FreePDK15/hspice_16nm_hp.include" "")
)
option(	'temp  "57.5"
)
temp( 57.5 )
run( ?jobName "job" ?queue "c2107" ?host "cobra" )
selectResult( 'tran )
plot(getData("/ReadEn") getData("/R_Address<11:0>") getData("/W_Address<11:0>") getData("/WriteEn") getData("/WDataAck<7:0>") getData("/RData<15:0>") getData("/ReadAck") getData("/WriteAck") getData("/RAckT") getData("/RDataT<15>") getData("/RDataT<14>") getData("/RDataT<13>") getData("/RDataT<12>") getData("/RDataT<11>") getData("/RDataT<10>") getData("/RDataT<9>") getData("/RDataT<8>") getData("/RDataT<7>") getData("/RDataT<6>") getData("/RDataT<5>") getData("/RDataT<4>") getData("/RDataT<3>") getData("/RDataT<2>") getData("/RDataT<1>") getData("/RDataT<0>") getData("/WAckT") getData("/R_AddressT<11>") getData("/R_AddressT<10>") getData("/R_AddressT<9>") getData("/R_AddressT<8>") getData("/R_AddressT<7>") getData("/R_AddressT<6>") getData("/R_AddressT<5>") getData("/R_AddressT<4>") getData("/R_AddressT<3>") getData("/R_AddressT<2>") getData("/R_AddressT<1>") getData("/R_AddressT<0>") getData("/ReadEnT") getData("/W_AddressT<11>") getData("/W_AddressT<10>") getData("/W_AddressT<9>") getData("/W_AddressT<8>") getData("/W_AddressT<7>") getData("/W_AddressT<6>") getData("/W_AddressT<5>") getData("/W_AddressT<4>") getData("/W_AddressT<3>") getData("/W_AddressT<2>") getData("/W_AddressT<1>") getData("/W_AddressT<0>") getData("/WriteEnT") getData("/WDataT<15>") getData("/WDataT<14>") getData("/WDataT<13>") getData("/WDataT<12>") getData("/WDataT<11>") getData("/WDataT<10>") getData("/WDataT<9>") getData("/WDataT<8>") getData("/WDataT<7>") getData("/WDataT<6>") getData("/WDataT<5>") getData("/WDataT<4>") getData("/WDataT<3>") getData("/WDataT<2>") getData("/WDataT<1>") getData("/WDataT<0>") getData("/WDataAckT<7>") getData("/WDataAckT<6>") getData("/WDataAckT<5>") getData("/WDataAckT<4>") getData("/WDataAckT<3>") getData("/WDataAckT<2>") getData("/WDataAckT<1>") getData("/WDataAckT<0>") getData("/V0/MINUS") getData("/I21/Wd<31>") getData("/I21/Wd<30>") getData("/I21/Wd<29>") getData("/I21/Wd<28>") getData("/I21/Wd<19>") getData("/I21/Wd<18>") getData("/I21/Wd<17>") getData("/I21/Wd<16>") getData("/I21/Wd<23>") getData("/I21/Wd<22>") getData("/I21/Wd<21>") getData("/I21/Wd<20>") getData("/I21/Wd<27>") getData("/I21/Wd<26>") getData("/I21/Wd<25>") getData("/I21/Wd<24>") getData("/I21/WdAck<7>") getData("/I21/WdAck<6>") getData("/I21/WdAck<5>") getData("/I21/WdAck<4>") getData("/I21/WdAck<3>") getData("/I21/WdAck<2>") getData("/I21/WdAck<1>") getData("/I21/WdAck<0>") getData("/I21/Wd<11>") getData("/I21/Wd<10>") getData("/I21/Wd<9>") getData("/I21/Wd<8>") getData("/I21/Wd<15>") getData("/I21/Wd<14>") getData("/I21/Wd<13>") getData("/I21/Wd<12>") getData("/I21/Wd<7>") getData("/I21/Wd<6>") getData("/I21/Wd<5>") getData("/I21/Wd<4>") getData("/I21/Wd<3>") getData("/I21/Wd<2>") getData("/I21/Wd<1>") getData("/I21/Wd<0>") getData("/I21/Rd<11>") getData("/I21/Rd<10>") getData("/I21/Rd<9>") getData("/I21/Rd<8>") getData("/I21/RdAck<7>") getData("/I21/RdAck<6>") getData("/I21/RdAck<5>") getData("/I21/RdAck<4>") getData("/I21/RdAck<3>") getData("/I21/RdAck<2>") getData("/I21/RdAck<1>") getData("/I21/RdAck<0>") getData("/I21/Rd<23>") getData("/I21/Rd<22>") getData("/I21/Rd<21>") getData("/I21/Rd<20>") getData("/I21/Rd<27>") getData("/I21/Rd<26>") getData("/I21/Rd<25>") getData("/I21/Rd<24>") getData("/I21/Rd<31>") getData("/I21/Rd<30>") getData("/I21/Rd<29>") getData("/I21/Rd<28>") getData("/I21/Rd<19>") getData("/I21/Rd<18>") getData("/I21/Rd<17>") getData("/I21/Rd<16>") getData("/I21/Rd<7>") getData("/I21/Rd<6>") getData("/I21/Rd<5>") getData("/I21/Rd<4>") getData("/I21/Rd<3>") getData("/I21/Rd<2>") getData("/I21/Rd<1>") getData("/I21/Rd<0>") getData("/I21/Rd<15>") getData("/I21/Rd<14>") getData("/I21/Rd<13>") getData("/I21/Rd<12>") getData("/I21/WdBank0<31>") getData("/I21/WdBank0<30>") getData("/I21/WdBank0<29>") getData("/I21/WdBank0<28>") getData("/I21/WdBank0<27>") getData("/I21/WdBank0<26>") getData("/I21/WdBank0<25>") getData("/I21/WdBank0<24>") getData("/I21/WdBank0<23>") getData("/I21/WdBank0<22>") getData("/I21/WdBank0<21>") getData("/I21/WdBank0<20>") getData("/I21/WdBank0<19>") getData("/I21/WdBank0<18>") getData("/I21/WdBank0<17>") getData("/I21/WdBank0<16>") getData("/I21/WdBank0<15>") getData("/I21/WdBank0<14>") getData("/I21/WdBank0<13>") getData("/I21/WdBank0<12>") getData("/I21/WdBank0<11>") getData("/I21/WdBank0<10>") getData("/I21/WdBank0<9>") getData("/I21/WdBank0<8>") getData("/I21/WdBank0<7>") getData("/I21/WdBank0<6>") getData("/I21/WdBank0<5>") getData("/I21/WdBank0<4>") getData("/I21/WdBank0<3>") getData("/I21/WdBank0<2>") getData("/I21/WdBank0<1>") getData("/I21/WdBank0<0>") getData("/I21/Bank0WAck<7>") getData("/I21/Bank0WAck<6>") getData("/I21/Bank0WAck<5>") getData("/I21/Bank0WAck<4>") getData("/I21/Bank0WAck<3>") getData("/I21/Bank0WAck<2>") getData("/I21/Bank0WAck<1>") getData("/I21/Bank0WAck<0>") getData("/I21/WdBank1<31>") getData("/I21/WdBank1<30>") getData("/I21/WdBank1<29>") getData("/I21/WdBank1<28>") getData("/I21/WdBank1<27>") getData("/I21/WdBank1<26>") getData("/I21/WdBank1<25>") getData("/I21/WdBank1<24>") getData("/I21/WdBank1<23>") getData("/I21/WdBank1<22>") getData("/I21/WdBank1<21>") getData("/I21/WdBank1<20>") getData("/I21/WdBank1<19>") getData("/I21/WdBank1<18>") getData("/I21/WdBank1<17>") getData("/I21/WdBank1<16>") getData("/I21/WdBank1<15>") getData("/I21/WdBank1<14>") getData("/I21/WdBank1<13>") getData("/I21/WdBank1<12>") getData("/I21/WdBank1<11>") getData("/I21/WdBank1<10>") getData("/I21/WdBank1<9>") getData("/I21/WdBank1<8>") getData("/I21/WdBank1<7>") getData("/I21/WdBank1<6>") getData("/I21/WdBank1<5>") getData("/I21/WdBank1<4>") getData("/I21/WdBank1<3>") getData("/I21/WdBank1<2>") getData("/I21/WdBank1<1>") getData("/I21/WdBank1<0>") getData("/I21/Bank1WAck<7>") getData("/I21/Bank1WAck<6>") getData("/I21/Bank1WAck<5>") getData("/I21/Bank1WAck<4>") getData("/I21/Bank1WAck<3>") getData("/I21/Bank1WAck<2>") getData("/I21/Bank1WAck<1>") getData("/I21/Bank1WAck<0>") getData("/I21/net0201") getData("/I21/net0205") getData("/I21/net018") getData("/I21/net017") getData("/I21/net022") getData("/I21/net021") getData("/I21/net020") getData("/I21/net019") getData("/I21/RdBank0<31>") getData("/I21/RdBank0<30>") getData("/I21/RdBank0<29>") getData("/I21/RdBank0<28>") getData("/I21/RdBank0<27>") getData("/I21/RdBank0<26>") getData("/I21/RdBank0<25>") getData("/I21/RdBank0<24>") getData("/I21/RdBank0<23>") getData("/I21/RdBank0<22>") getData("/I21/RdBank0<21>") getData("/I21/RdBank0<20>") getData("/I21/RdBank0<19>") getData("/I21/RdBank0<18>") getData("/I21/RdBank0<17>") getData("/I21/RdBank0<16>") getData("/I21/RdBank0<15>") getData("/I21/RdBank0<14>") getData("/I21/RdBank0<13>") getData("/I21/RdBank0<12>") getData("/I21/RdBank0<11>") getData("/I21/RdBank0<10>") getData("/I21/RdBank0<9>") getData("/I21/RdBank0<8>") getData("/I21/RdBank0<7>") getData("/I21/RdBank0<6>") getData("/I21/RdBank0<5>") getData("/I21/RdBank0<4>") getData("/I21/RdBank0<3>") getData("/I21/RdBank0<2>") getData("/I21/RdBank0<1>") getData("/I21/RdBank0<0>") getData("/I21/RdBank0Ack<7>") getData("/I21/RdBank0Ack<6>") getData("/I21/RdBank0Ack<5>") getData("/I21/RdBank0Ack<4>") getData("/I21/RdBank0Ack<3>") getData("/I21/RdBank0Ack<2>") getData("/I21/RdBank0Ack<1>") getData("/I21/RdBank0Ack<0>") getData("/I21/RdBank1<31>") getData("/I21/RdBank1<30>") getData("/I21/RdBank1<29>") getData("/I21/RdBank1<28>") getData("/I21/RdBank1<27>") getData("/I21/RdBank1<26>") getData("/I21/RdBank1<25>") getData("/I21/RdBank1<24>") getData("/I21/RdBank1<23>") getData("/I21/RdBank1<22>") getData("/I21/RdBank1<21>") getData("/I21/RdBank1<20>") getData("/I21/RdBank1<19>") getData("/I21/RdBank1<18>") getData("/I21/RdBank1<17>") getData("/I21/RdBank1<16>") getData("/I21/RdBank1<15>") getData("/I21/RdBank1<14>") getData("/I21/RdBank1<13>") getData("/I21/RdBank1<12>") getData("/I21/RdBank1<11>") getData("/I21/RdBank1<10>") getData("/I21/RdBank1<9>") getData("/I21/RdBank1<8>") getData("/I21/RdBank1<7>") getData("/I21/RdBank1<6>") getData("/I21/RdBank1<5>") getData("/I21/RdBank1<4>") getData("/I21/RdBank1<3>") getData("/I21/RdBank1<2>") getData("/I21/RdBank1<1>") getData("/I21/RdBank1<0>") getData("/I21/RdBank1Ack<7>") getData("/I21/RdBank1Ack<6>") getData("/I21/RdBank1Ack<5>") getData("/I21/RdBank1Ack<4>") getData("/I21/RdBank1Ack<3>") getData("/I21/RdBank1Ack<2>") getData("/I21/RdBank1Ack<1>") getData("/I21/RdBank1Ack<0>") getData("/WData<15:0>") )
resultsDir( "/net/bull/apps/Cadence/simulation/6T_MultiBank_8K_4K_Test/spectreVerilog/config/distributed/MBank_8K_r4K_675mV_85C" )
modelFile(
    '("/software/cadence/ncsu-FreePDK15/hspice_16nm_hp.include" "")
)
option(	'temp  "85.0"
)
temp( 85.0 )
run( ?jobName "job" ?queue "c2107" ?host "gopher" )
selectResult( 'tran )
plot(getData("/ReadEn") getData("/R_Address<11:0>") getData("/W_Address<11:0>") getData("/WriteEn") getData("/WDataAck<7:0>") getData("/RData<15:0>") getData("/ReadAck") getData("/WriteAck") getData("/RAckT") getData("/RDataT<15>") getData("/RDataT<14>") getData("/RDataT<13>") getData("/RDataT<12>") getData("/RDataT<11>") getData("/RDataT<10>") getData("/RDataT<9>") getData("/RDataT<8>") getData("/RDataT<7>") getData("/RDataT<6>") getData("/RDataT<5>") getData("/RDataT<4>") getData("/RDataT<3>") getData("/RDataT<2>") getData("/RDataT<1>") getData("/RDataT<0>") getData("/WAckT") getData("/R_AddressT<11>") getData("/R_AddressT<10>") getData("/R_AddressT<9>") getData("/R_AddressT<8>") getData("/R_AddressT<7>") getData("/R_AddressT<6>") getData("/R_AddressT<5>") getData("/R_AddressT<4>") getData("/R_AddressT<3>") getData("/R_AddressT<2>") getData("/R_AddressT<1>") getData("/R_AddressT<0>") getData("/ReadEnT") getData("/W_AddressT<11>") getData("/W_AddressT<10>") getData("/W_AddressT<9>") getData("/W_AddressT<8>") getData("/W_AddressT<7>") getData("/W_AddressT<6>") getData("/W_AddressT<5>") getData("/W_AddressT<4>") getData("/W_AddressT<3>") getData("/W_AddressT<2>") getData("/W_AddressT<1>") getData("/W_AddressT<0>") getData("/WriteEnT") getData("/WDataT<15>") getData("/WDataT<14>") getData("/WDataT<13>") getData("/WDataT<12>") getData("/WDataT<11>") getData("/WDataT<10>") getData("/WDataT<9>") getData("/WDataT<8>") getData("/WDataT<7>") getData("/WDataT<6>") getData("/WDataT<5>") getData("/WDataT<4>") getData("/WDataT<3>") getData("/WDataT<2>") getData("/WDataT<1>") getData("/WDataT<0>") getData("/WDataAckT<7>") getData("/WDataAckT<6>") getData("/WDataAckT<5>") getData("/WDataAckT<4>") getData("/WDataAckT<3>") getData("/WDataAckT<2>") getData("/WDataAckT<1>") getData("/WDataAckT<0>") getData("/V0/MINUS") getData("/I21/Wd<31>") getData("/I21/Wd<30>") getData("/I21/Wd<29>") getData("/I21/Wd<28>") getData("/I21/Wd<19>") getData("/I21/Wd<18>") getData("/I21/Wd<17>") getData("/I21/Wd<16>") getData("/I21/Wd<23>") getData("/I21/Wd<22>") getData("/I21/Wd<21>") getData("/I21/Wd<20>") getData("/I21/Wd<27>") getData("/I21/Wd<26>") getData("/I21/Wd<25>") getData("/I21/Wd<24>") getData("/I21/WdAck<7>") getData("/I21/WdAck<6>") getData("/I21/WdAck<5>") getData("/I21/WdAck<4>") getData("/I21/WdAck<3>") getData("/I21/WdAck<2>") getData("/I21/WdAck<1>") getData("/I21/WdAck<0>") getData("/I21/Wd<11>") getData("/I21/Wd<10>") getData("/I21/Wd<9>") getData("/I21/Wd<8>") getData("/I21/Wd<15>") getData("/I21/Wd<14>") getData("/I21/Wd<13>") getData("/I21/Wd<12>") getData("/I21/Wd<7>") getData("/I21/Wd<6>") getData("/I21/Wd<5>") getData("/I21/Wd<4>") getData("/I21/Wd<3>") getData("/I21/Wd<2>") getData("/I21/Wd<1>") getData("/I21/Wd<0>") getData("/I21/Rd<11>") getData("/I21/Rd<10>") getData("/I21/Rd<9>") getData("/I21/Rd<8>") getData("/I21/RdAck<7>") getData("/I21/RdAck<6>") getData("/I21/RdAck<5>") getData("/I21/RdAck<4>") getData("/I21/RdAck<3>") getData("/I21/RdAck<2>") getData("/I21/RdAck<1>") getData("/I21/RdAck<0>") getData("/I21/Rd<23>") getData("/I21/Rd<22>") getData("/I21/Rd<21>") getData("/I21/Rd<20>") getData("/I21/Rd<27>") getData("/I21/Rd<26>") getData("/I21/Rd<25>") getData("/I21/Rd<24>") getData("/I21/Rd<31>") getData("/I21/Rd<30>") getData("/I21/Rd<29>") getData("/I21/Rd<28>") getData("/I21/Rd<19>") getData("/I21/Rd<18>") getData("/I21/Rd<17>") getData("/I21/Rd<16>") getData("/I21/Rd<7>") getData("/I21/Rd<6>") getData("/I21/Rd<5>") getData("/I21/Rd<4>") getData("/I21/Rd<3>") getData("/I21/Rd<2>") getData("/I21/Rd<1>") getData("/I21/Rd<0>") getData("/I21/Rd<15>") getData("/I21/Rd<14>") getData("/I21/Rd<13>") getData("/I21/Rd<12>") getData("/I21/WdBank0<31>") getData("/I21/WdBank0<30>") getData("/I21/WdBank0<29>") getData("/I21/WdBank0<28>") getData("/I21/WdBank0<27>") getData("/I21/WdBank0<26>") getData("/I21/WdBank0<25>") getData("/I21/WdBank0<24>") getData("/I21/WdBank0<23>") getData("/I21/WdBank0<22>") getData("/I21/WdBank0<21>") getData("/I21/WdBank0<20>") getData("/I21/WdBank0<19>") getData("/I21/WdBank0<18>") getData("/I21/WdBank0<17>") getData("/I21/WdBank0<16>") getData("/I21/WdBank0<15>") getData("/I21/WdBank0<14>") getData("/I21/WdBank0<13>") getData("/I21/WdBank0<12>") getData("/I21/WdBank0<11>") getData("/I21/WdBank0<10>") getData("/I21/WdBank0<9>") getData("/I21/WdBank0<8>") getData("/I21/WdBank0<7>") getData("/I21/WdBank0<6>") getData("/I21/WdBank0<5>") getData("/I21/WdBank0<4>") getData("/I21/WdBank0<3>") getData("/I21/WdBank0<2>") getData("/I21/WdBank0<1>") getData("/I21/WdBank0<0>") getData("/I21/Bank0WAck<7>") getData("/I21/Bank0WAck<6>") getData("/I21/Bank0WAck<5>") getData("/I21/Bank0WAck<4>") getData("/I21/Bank0WAck<3>") getData("/I21/Bank0WAck<2>") getData("/I21/Bank0WAck<1>") getData("/I21/Bank0WAck<0>") getData("/I21/WdBank1<31>") getData("/I21/WdBank1<30>") getData("/I21/WdBank1<29>") getData("/I21/WdBank1<28>") getData("/I21/WdBank1<27>") getData("/I21/WdBank1<26>") getData("/I21/WdBank1<25>") getData("/I21/WdBank1<24>") getData("/I21/WdBank1<23>") getData("/I21/WdBank1<22>") getData("/I21/WdBank1<21>") getData("/I21/WdBank1<20>") getData("/I21/WdBank1<19>") getData("/I21/WdBank1<18>") getData("/I21/WdBank1<17>") getData("/I21/WdBank1<16>") getData("/I21/WdBank1<15>") getData("/I21/WdBank1<14>") getData("/I21/WdBank1<13>") getData("/I21/WdBank1<12>") getData("/I21/WdBank1<11>") getData("/I21/WdBank1<10>") getData("/I21/WdBank1<9>") getData("/I21/WdBank1<8>") getData("/I21/WdBank1<7>") getData("/I21/WdBank1<6>") getData("/I21/WdBank1<5>") getData("/I21/WdBank1<4>") getData("/I21/WdBank1<3>") getData("/I21/WdBank1<2>") getData("/I21/WdBank1<1>") getData("/I21/WdBank1<0>") getData("/I21/Bank1WAck<7>") getData("/I21/Bank1WAck<6>") getData("/I21/Bank1WAck<5>") getData("/I21/Bank1WAck<4>") getData("/I21/Bank1WAck<3>") getData("/I21/Bank1WAck<2>") getData("/I21/Bank1WAck<1>") getData("/I21/Bank1WAck<0>") getData("/I21/net0201") getData("/I21/net0205") getData("/I21/net018") getData("/I21/net017") getData("/I21/net022") getData("/I21/net021") getData("/I21/net020") getData("/I21/net019") getData("/I21/RdBank0<31>") getData("/I21/RdBank0<30>") getData("/I21/RdBank0<29>") getData("/I21/RdBank0<28>") getData("/I21/RdBank0<27>") getData("/I21/RdBank0<26>") getData("/I21/RdBank0<25>") getData("/I21/RdBank0<24>") getData("/I21/RdBank0<23>") getData("/I21/RdBank0<22>") getData("/I21/RdBank0<21>") getData("/I21/RdBank0<20>") getData("/I21/RdBank0<19>") getData("/I21/RdBank0<18>") getData("/I21/RdBank0<17>") getData("/I21/RdBank0<16>") getData("/I21/RdBank0<15>") getData("/I21/RdBank0<14>") getData("/I21/RdBank0<13>") getData("/I21/RdBank0<12>") getData("/I21/RdBank0<11>") getData("/I21/RdBank0<10>") getData("/I21/RdBank0<9>") getData("/I21/RdBank0<8>") getData("/I21/RdBank0<7>") getData("/I21/RdBank0<6>") getData("/I21/RdBank0<5>") getData("/I21/RdBank0<4>") getData("/I21/RdBank0<3>") getData("/I21/RdBank0<2>") getData("/I21/RdBank0<1>") getData("/I21/RdBank0<0>") getData("/I21/RdBank0Ack<7>") getData("/I21/RdBank0Ack<6>") getData("/I21/RdBank0Ack<5>") getData("/I21/RdBank0Ack<4>") getData("/I21/RdBank0Ack<3>") getData("/I21/RdBank0Ack<2>") getData("/I21/RdBank0Ack<1>") getData("/I21/RdBank0Ack<0>") getData("/I21/RdBank1<31>") getData("/I21/RdBank1<30>") getData("/I21/RdBank1<29>") getData("/I21/RdBank1<28>") getData("/I21/RdBank1<27>") getData("/I21/RdBank1<26>") getData("/I21/RdBank1<25>") getData("/I21/RdBank1<24>") getData("/I21/RdBank1<23>") getData("/I21/RdBank1<22>") getData("/I21/RdBank1<21>") getData("/I21/RdBank1<20>") getData("/I21/RdBank1<19>") getData("/I21/RdBank1<18>") getData("/I21/RdBank1<17>") getData("/I21/RdBank1<16>") getData("/I21/RdBank1<15>") getData("/I21/RdBank1<14>") getData("/I21/RdBank1<13>") getData("/I21/RdBank1<12>") getData("/I21/RdBank1<11>") getData("/I21/RdBank1<10>") getData("/I21/RdBank1<9>") getData("/I21/RdBank1<8>") getData("/I21/RdBank1<7>") getData("/I21/RdBank1<6>") getData("/I21/RdBank1<5>") getData("/I21/RdBank1<4>") getData("/I21/RdBank1<3>") getData("/I21/RdBank1<2>") getData("/I21/RdBank1<1>") getData("/I21/RdBank1<0>") getData("/I21/RdBank1Ack<7>") getData("/I21/RdBank1Ack<6>") getData("/I21/RdBank1Ack<5>") getData("/I21/RdBank1Ack<4>") getData("/I21/RdBank1Ack<3>") getData("/I21/RdBank1Ack<2>") getData("/I21/RdBank1Ack<1>") getData("/I21/RdBank1Ack<0>") getData("/WData<15:0>") )
resultsDir( "/net/bull/apps/Cadence/simulation/6T_MultiBank_8K_4K_Test/spectreVerilog/config/distributed/MBank_8K_r4K_850mV_30C" )
modelFile(
    '("/software/cadence/ncsu-FreePDK15/hspice_16nm_hp.include" "")
)
desVar(	  "vdd" .850	)
option(	'temp  "30.0"
)
temp( 30.0 )
run( ?jobName "job" ?queue "c2107" ?host "viper" )
selectResult( 'tran )
plot(getData("/ReadEn") getData("/R_Address<11:0>") getData("/W_Address<11:0>") getData("/WriteEn") getData("/WDataAck<7:0>") getData("/RData<15:0>") getData("/ReadAck") getData("/WriteAck") getData("/RAckT") getData("/RDataT<15>") getData("/RDataT<14>") getData("/RDataT<13>") getData("/RDataT<12>") getData("/RDataT<11>") getData("/RDataT<10>") getData("/RDataT<9>") getData("/RDataT<8>") getData("/RDataT<7>") getData("/RDataT<6>") getData("/RDataT<5>") getData("/RDataT<4>") getData("/RDataT<3>") getData("/RDataT<2>") getData("/RDataT<1>") getData("/RDataT<0>") getData("/WAckT") getData("/R_AddressT<11>") getData("/R_AddressT<10>") getData("/R_AddressT<9>") getData("/R_AddressT<8>") getData("/R_AddressT<7>") getData("/R_AddressT<6>") getData("/R_AddressT<5>") getData("/R_AddressT<4>") getData("/R_AddressT<3>") getData("/R_AddressT<2>") getData("/R_AddressT<1>") getData("/R_AddressT<0>") getData("/ReadEnT") getData("/W_AddressT<11>") getData("/W_AddressT<10>") getData("/W_AddressT<9>") getData("/W_AddressT<8>") getData("/W_AddressT<7>") getData("/W_AddressT<6>") getData("/W_AddressT<5>") getData("/W_AddressT<4>") getData("/W_AddressT<3>") getData("/W_AddressT<2>") getData("/W_AddressT<1>") getData("/W_AddressT<0>") getData("/WriteEnT") getData("/WDataT<15>") getData("/WDataT<14>") getData("/WDataT<13>") getData("/WDataT<12>") getData("/WDataT<11>") getData("/WDataT<10>") getData("/WDataT<9>") getData("/WDataT<8>") getData("/WDataT<7>") getData("/WDataT<6>") getData("/WDataT<5>") getData("/WDataT<4>") getData("/WDataT<3>") getData("/WDataT<2>") getData("/WDataT<1>") getData("/WDataT<0>") getData("/WDataAckT<7>") getData("/WDataAckT<6>") getData("/WDataAckT<5>") getData("/WDataAckT<4>") getData("/WDataAckT<3>") getData("/WDataAckT<2>") getData("/WDataAckT<1>") getData("/WDataAckT<0>") getData("/V0/MINUS") getData("/I21/Wd<31>") getData("/I21/Wd<30>") getData("/I21/Wd<29>") getData("/I21/Wd<28>") getData("/I21/Wd<19>") getData("/I21/Wd<18>") getData("/I21/Wd<17>") getData("/I21/Wd<16>") getData("/I21/Wd<23>") getData("/I21/Wd<22>") getData("/I21/Wd<21>") getData("/I21/Wd<20>") getData("/I21/Wd<27>") getData("/I21/Wd<26>") getData("/I21/Wd<25>") getData("/I21/Wd<24>") getData("/I21/WdAck<7>") getData("/I21/WdAck<6>") getData("/I21/WdAck<5>") getData("/I21/WdAck<4>") getData("/I21/WdAck<3>") getData("/I21/WdAck<2>") getData("/I21/WdAck<1>") getData("/I21/WdAck<0>") getData("/I21/Wd<11>") getData("/I21/Wd<10>") getData("/I21/Wd<9>") getData("/I21/Wd<8>") getData("/I21/Wd<15>") getData("/I21/Wd<14>") getData("/I21/Wd<13>") getData("/I21/Wd<12>") getData("/I21/Wd<7>") getData("/I21/Wd<6>") getData("/I21/Wd<5>") getData("/I21/Wd<4>") getData("/I21/Wd<3>") getData("/I21/Wd<2>") getData("/I21/Wd<1>") getData("/I21/Wd<0>") getData("/I21/Rd<11>") getData("/I21/Rd<10>") getData("/I21/Rd<9>") getData("/I21/Rd<8>") getData("/I21/RdAck<7>") getData("/I21/RdAck<6>") getData("/I21/RdAck<5>") getData("/I21/RdAck<4>") getData("/I21/RdAck<3>") getData("/I21/RdAck<2>") getData("/I21/RdAck<1>") getData("/I21/RdAck<0>") getData("/I21/Rd<23>") getData("/I21/Rd<22>") getData("/I21/Rd<21>") getData("/I21/Rd<20>") getData("/I21/Rd<27>") getData("/I21/Rd<26>") getData("/I21/Rd<25>") getData("/I21/Rd<24>") getData("/I21/Rd<31>") getData("/I21/Rd<30>") getData("/I21/Rd<29>") getData("/I21/Rd<28>") getData("/I21/Rd<19>") getData("/I21/Rd<18>") getData("/I21/Rd<17>") getData("/I21/Rd<16>") getData("/I21/Rd<7>") getData("/I21/Rd<6>") getData("/I21/Rd<5>") getData("/I21/Rd<4>") getData("/I21/Rd<3>") getData("/I21/Rd<2>") getData("/I21/Rd<1>") getData("/I21/Rd<0>") getData("/I21/Rd<15>") getData("/I21/Rd<14>") getData("/I21/Rd<13>") getData("/I21/Rd<12>") getData("/I21/WdBank0<31>") getData("/I21/WdBank0<30>") getData("/I21/WdBank0<29>") getData("/I21/WdBank0<28>") getData("/I21/WdBank0<27>") getData("/I21/WdBank0<26>") getData("/I21/WdBank0<25>") getData("/I21/WdBank0<24>") getData("/I21/WdBank0<23>") getData("/I21/WdBank0<22>") getData("/I21/WdBank0<21>") getData("/I21/WdBank0<20>") getData("/I21/WdBank0<19>") getData("/I21/WdBank0<18>") getData("/I21/WdBank0<17>") getData("/I21/WdBank0<16>") getData("/I21/WdBank0<15>") getData("/I21/WdBank0<14>") getData("/I21/WdBank0<13>") getData("/I21/WdBank0<12>") getData("/I21/WdBank0<11>") getData("/I21/WdBank0<10>") getData("/I21/WdBank0<9>") getData("/I21/WdBank0<8>") getData("/I21/WdBank0<7>") getData("/I21/WdBank0<6>") getData("/I21/WdBank0<5>") getData("/I21/WdBank0<4>") getData("/I21/WdBank0<3>") getData("/I21/WdBank0<2>") getData("/I21/WdBank0<1>") getData("/I21/WdBank0<0>") getData("/I21/Bank0WAck<7>") getData("/I21/Bank0WAck<6>") getData("/I21/Bank0WAck<5>") getData("/I21/Bank0WAck<4>") getData("/I21/Bank0WAck<3>") getData("/I21/Bank0WAck<2>") getData("/I21/Bank0WAck<1>") getData("/I21/Bank0WAck<0>") getData("/I21/WdBank1<31>") getData("/I21/WdBank1<30>") getData("/I21/WdBank1<29>") getData("/I21/WdBank1<28>") getData("/I21/WdBank1<27>") getData("/I21/WdBank1<26>") getData("/I21/WdBank1<25>") getData("/I21/WdBank1<24>") getData("/I21/WdBank1<23>") getData("/I21/WdBank1<22>") getData("/I21/WdBank1<21>") getData("/I21/WdBank1<20>") getData("/I21/WdBank1<19>") getData("/I21/WdBank1<18>") getData("/I21/WdBank1<17>") getData("/I21/WdBank1<16>") getData("/I21/WdBank1<15>") getData("/I21/WdBank1<14>") getData("/I21/WdBank1<13>") getData("/I21/WdBank1<12>") getData("/I21/WdBank1<11>") getData("/I21/WdBank1<10>") getData("/I21/WdBank1<9>") getData("/I21/WdBank1<8>") getData("/I21/WdBank1<7>") getData("/I21/WdBank1<6>") getData("/I21/WdBank1<5>") getData("/I21/WdBank1<4>") getData("/I21/WdBank1<3>") getData("/I21/WdBank1<2>") getData("/I21/WdBank1<1>") getData("/I21/WdBank1<0>") getData("/I21/Bank1WAck<7>") getData("/I21/Bank1WAck<6>") getData("/I21/Bank1WAck<5>") getData("/I21/Bank1WAck<4>") getData("/I21/Bank1WAck<3>") getData("/I21/Bank1WAck<2>") getData("/I21/Bank1WAck<1>") getData("/I21/Bank1WAck<0>") getData("/I21/net0201") getData("/I21/net0205") getData("/I21/net018") getData("/I21/net017") getData("/I21/net022") getData("/I21/net021") getData("/I21/net020") getData("/I21/net019") getData("/I21/RdBank0<31>") getData("/I21/RdBank0<30>") getData("/I21/RdBank0<29>") getData("/I21/RdBank0<28>") getData("/I21/RdBank0<27>") getData("/I21/RdBank0<26>") getData("/I21/RdBank0<25>") getData("/I21/RdBank0<24>") getData("/I21/RdBank0<23>") getData("/I21/RdBank0<22>") getData("/I21/RdBank0<21>") getData("/I21/RdBank0<20>") getData("/I21/RdBank0<19>") getData("/I21/RdBank0<18>") getData("/I21/RdBank0<17>") getData("/I21/RdBank0<16>") getData("/I21/RdBank0<15>") getData("/I21/RdBank0<14>") getData("/I21/RdBank0<13>") getData("/I21/RdBank0<12>") getData("/I21/RdBank0<11>") getData("/I21/RdBank0<10>") getData("/I21/RdBank0<9>") getData("/I21/RdBank0<8>") getData("/I21/RdBank0<7>") getData("/I21/RdBank0<6>") getData("/I21/RdBank0<5>") getData("/I21/RdBank0<4>") getData("/I21/RdBank0<3>") getData("/I21/RdBank0<2>") getData("/I21/RdBank0<1>") getData("/I21/RdBank0<0>") getData("/I21/RdBank0Ack<7>") getData("/I21/RdBank0Ack<6>") getData("/I21/RdBank0Ack<5>") getData("/I21/RdBank0Ack<4>") getData("/I21/RdBank0Ack<3>") getData("/I21/RdBank0Ack<2>") getData("/I21/RdBank0Ack<1>") getData("/I21/RdBank0Ack<0>") getData("/I21/RdBank1<31>") getData("/I21/RdBank1<30>") getData("/I21/RdBank1<29>") getData("/I21/RdBank1<28>") getData("/I21/RdBank1<27>") getData("/I21/RdBank1<26>") getData("/I21/RdBank1<25>") getData("/I21/RdBank1<24>") getData("/I21/RdBank1<23>") getData("/I21/RdBank1<22>") getData("/I21/RdBank1<21>") getData("/I21/RdBank1<20>") getData("/I21/RdBank1<19>") getData("/I21/RdBank1<18>") getData("/I21/RdBank1<17>") getData("/I21/RdBank1<16>") getData("/I21/RdBank1<15>") getData("/I21/RdBank1<14>") getData("/I21/RdBank1<13>") getData("/I21/RdBank1<12>") getData("/I21/RdBank1<11>") getData("/I21/RdBank1<10>") getData("/I21/RdBank1<9>") getData("/I21/RdBank1<8>") getData("/I21/RdBank1<7>") getData("/I21/RdBank1<6>") getData("/I21/RdBank1<5>") getData("/I21/RdBank1<4>") getData("/I21/RdBank1<3>") getData("/I21/RdBank1<2>") getData("/I21/RdBank1<1>") getData("/I21/RdBank1<0>") getData("/I21/RdBank1Ack<7>") getData("/I21/RdBank1Ack<6>") getData("/I21/RdBank1Ack<5>") getData("/I21/RdBank1Ack<4>") getData("/I21/RdBank1Ack<3>") getData("/I21/RdBank1Ack<2>") getData("/I21/RdBank1Ack<1>") getData("/I21/RdBank1Ack<0>") getData("/WData<15:0>") )
resultsDir( "/net/bull/apps/Cadence/simulation/6T_MultiBank_8K_4K_Test/spectreVerilog/config/distributed/MBank_8K_r4K_850mV_58C" )
modelFile(
    '("/software/cadence/ncsu-FreePDK15/hspice_16nm_hp.include" "")
)
option(	'temp  "57.5"
)
temp( 57.5 )
run( ?jobName "job" ?queue "c2107" ?host "boa" )
selectResult( 'tran )
plot(getData("/ReadEn") getData("/R_Address<11:0>") getData("/W_Address<11:0>") getData("/WriteEn") getData("/WDataAck<7:0>") getData("/RData<15:0>") getData("/ReadAck") getData("/WriteAck") getData("/RAckT") getData("/RDataT<15>") getData("/RDataT<14>") getData("/RDataT<13>") getData("/RDataT<12>") getData("/RDataT<11>") getData("/RDataT<10>") getData("/RDataT<9>") getData("/RDataT<8>") getData("/RDataT<7>") getData("/RDataT<6>") getData("/RDataT<5>") getData("/RDataT<4>") getData("/RDataT<3>") getData("/RDataT<2>") getData("/RDataT<1>") getData("/RDataT<0>") getData("/WAckT") getData("/R_AddressT<11>") getData("/R_AddressT<10>") getData("/R_AddressT<9>") getData("/R_AddressT<8>") getData("/R_AddressT<7>") getData("/R_AddressT<6>") getData("/R_AddressT<5>") getData("/R_AddressT<4>") getData("/R_AddressT<3>") getData("/R_AddressT<2>") getData("/R_AddressT<1>") getData("/R_AddressT<0>") getData("/ReadEnT") getData("/W_AddressT<11>") getData("/W_AddressT<10>") getData("/W_AddressT<9>") getData("/W_AddressT<8>") getData("/W_AddressT<7>") getData("/W_AddressT<6>") getData("/W_AddressT<5>") getData("/W_AddressT<4>") getData("/W_AddressT<3>") getData("/W_AddressT<2>") getData("/W_AddressT<1>") getData("/W_AddressT<0>") getData("/WriteEnT") getData("/WDataT<15>") getData("/WDataT<14>") getData("/WDataT<13>") getData("/WDataT<12>") getData("/WDataT<11>") getData("/WDataT<10>") getData("/WDataT<9>") getData("/WDataT<8>") getData("/WDataT<7>") getData("/WDataT<6>") getData("/WDataT<5>") getData("/WDataT<4>") getData("/WDataT<3>") getData("/WDataT<2>") getData("/WDataT<1>") getData("/WDataT<0>") getData("/WDataAckT<7>") getData("/WDataAckT<6>") getData("/WDataAckT<5>") getData("/WDataAckT<4>") getData("/WDataAckT<3>") getData("/WDataAckT<2>") getData("/WDataAckT<1>") getData("/WDataAckT<0>") getData("/V0/MINUS") getData("/I21/Wd<31>") getData("/I21/Wd<30>") getData("/I21/Wd<29>") getData("/I21/Wd<28>") getData("/I21/Wd<19>") getData("/I21/Wd<18>") getData("/I21/Wd<17>") getData("/I21/Wd<16>") getData("/I21/Wd<23>") getData("/I21/Wd<22>") getData("/I21/Wd<21>") getData("/I21/Wd<20>") getData("/I21/Wd<27>") getData("/I21/Wd<26>") getData("/I21/Wd<25>") getData("/I21/Wd<24>") getData("/I21/WdAck<7>") getData("/I21/WdAck<6>") getData("/I21/WdAck<5>") getData("/I21/WdAck<4>") getData("/I21/WdAck<3>") getData("/I21/WdAck<2>") getData("/I21/WdAck<1>") getData("/I21/WdAck<0>") getData("/I21/Wd<11>") getData("/I21/Wd<10>") getData("/I21/Wd<9>") getData("/I21/Wd<8>") getData("/I21/Wd<15>") getData("/I21/Wd<14>") getData("/I21/Wd<13>") getData("/I21/Wd<12>") getData("/I21/Wd<7>") getData("/I21/Wd<6>") getData("/I21/Wd<5>") getData("/I21/Wd<4>") getData("/I21/Wd<3>") getData("/I21/Wd<2>") getData("/I21/Wd<1>") getData("/I21/Wd<0>") getData("/I21/Rd<11>") getData("/I21/Rd<10>") getData("/I21/Rd<9>") getData("/I21/Rd<8>") getData("/I21/RdAck<7>") getData("/I21/RdAck<6>") getData("/I21/RdAck<5>") getData("/I21/RdAck<4>") getData("/I21/RdAck<3>") getData("/I21/RdAck<2>") getData("/I21/RdAck<1>") getData("/I21/RdAck<0>") getData("/I21/Rd<23>") getData("/I21/Rd<22>") getData("/I21/Rd<21>") getData("/I21/Rd<20>") getData("/I21/Rd<27>") getData("/I21/Rd<26>") getData("/I21/Rd<25>") getData("/I21/Rd<24>") getData("/I21/Rd<31>") getData("/I21/Rd<30>") getData("/I21/Rd<29>") getData("/I21/Rd<28>") getData("/I21/Rd<19>") getData("/I21/Rd<18>") getData("/I21/Rd<17>") getData("/I21/Rd<16>") getData("/I21/Rd<7>") getData("/I21/Rd<6>") getData("/I21/Rd<5>") getData("/I21/Rd<4>") getData("/I21/Rd<3>") getData("/I21/Rd<2>") getData("/I21/Rd<1>") getData("/I21/Rd<0>") getData("/I21/Rd<15>") getData("/I21/Rd<14>") getData("/I21/Rd<13>") getData("/I21/Rd<12>") getData("/I21/WdBank0<31>") getData("/I21/WdBank0<30>") getData("/I21/WdBank0<29>") getData("/I21/WdBank0<28>") getData("/I21/WdBank0<27>") getData("/I21/WdBank0<26>") getData("/I21/WdBank0<25>") getData("/I21/WdBank0<24>") getData("/I21/WdBank0<23>") getData("/I21/WdBank0<22>") getData("/I21/WdBank0<21>") getData("/I21/WdBank0<20>") getData("/I21/WdBank0<19>") getData("/I21/WdBank0<18>") getData("/I21/WdBank0<17>") getData("/I21/WdBank0<16>") getData("/I21/WdBank0<15>") getData("/I21/WdBank0<14>") getData("/I21/WdBank0<13>") getData("/I21/WdBank0<12>") getData("/I21/WdBank0<11>") getData("/I21/WdBank0<10>") getData("/I21/WdBank0<9>") getData("/I21/WdBank0<8>") getData("/I21/WdBank0<7>") getData("/I21/WdBank0<6>") getData("/I21/WdBank0<5>") getData("/I21/WdBank0<4>") getData("/I21/WdBank0<3>") getData("/I21/WdBank0<2>") getData("/I21/WdBank0<1>") getData("/I21/WdBank0<0>") getData("/I21/Bank0WAck<7>") getData("/I21/Bank0WAck<6>") getData("/I21/Bank0WAck<5>") getData("/I21/Bank0WAck<4>") getData("/I21/Bank0WAck<3>") getData("/I21/Bank0WAck<2>") getData("/I21/Bank0WAck<1>") getData("/I21/Bank0WAck<0>") getData("/I21/WdBank1<31>") getData("/I21/WdBank1<30>") getData("/I21/WdBank1<29>") getData("/I21/WdBank1<28>") getData("/I21/WdBank1<27>") getData("/I21/WdBank1<26>") getData("/I21/WdBank1<25>") getData("/I21/WdBank1<24>") getData("/I21/WdBank1<23>") getData("/I21/WdBank1<22>") getData("/I21/WdBank1<21>") getData("/I21/WdBank1<20>") getData("/I21/WdBank1<19>") getData("/I21/WdBank1<18>") getData("/I21/WdBank1<17>") getData("/I21/WdBank1<16>") getData("/I21/WdBank1<15>") getData("/I21/WdBank1<14>") getData("/I21/WdBank1<13>") getData("/I21/WdBank1<12>") getData("/I21/WdBank1<11>") getData("/I21/WdBank1<10>") getData("/I21/WdBank1<9>") getData("/I21/WdBank1<8>") getData("/I21/WdBank1<7>") getData("/I21/WdBank1<6>") getData("/I21/WdBank1<5>") getData("/I21/WdBank1<4>") getData("/I21/WdBank1<3>") getData("/I21/WdBank1<2>") getData("/I21/WdBank1<1>") getData("/I21/WdBank1<0>") getData("/I21/Bank1WAck<7>") getData("/I21/Bank1WAck<6>") getData("/I21/Bank1WAck<5>") getData("/I21/Bank1WAck<4>") getData("/I21/Bank1WAck<3>") getData("/I21/Bank1WAck<2>") getData("/I21/Bank1WAck<1>") getData("/I21/Bank1WAck<0>") getData("/I21/net0201") getData("/I21/net0205") getData("/I21/net018") getData("/I21/net017") getData("/I21/net022") getData("/I21/net021") getData("/I21/net020") getData("/I21/net019") getData("/I21/RdBank0<31>") getData("/I21/RdBank0<30>") getData("/I21/RdBank0<29>") getData("/I21/RdBank0<28>") getData("/I21/RdBank0<27>") getData("/I21/RdBank0<26>") getData("/I21/RdBank0<25>") getData("/I21/RdBank0<24>") getData("/I21/RdBank0<23>") getData("/I21/RdBank0<22>") getData("/I21/RdBank0<21>") getData("/I21/RdBank0<20>") getData("/I21/RdBank0<19>") getData("/I21/RdBank0<18>") getData("/I21/RdBank0<17>") getData("/I21/RdBank0<16>") getData("/I21/RdBank0<15>") getData("/I21/RdBank0<14>") getData("/I21/RdBank0<13>") getData("/I21/RdBank0<12>") getData("/I21/RdBank0<11>") getData("/I21/RdBank0<10>") getData("/I21/RdBank0<9>") getData("/I21/RdBank0<8>") getData("/I21/RdBank0<7>") getData("/I21/RdBank0<6>") getData("/I21/RdBank0<5>") getData("/I21/RdBank0<4>") getData("/I21/RdBank0<3>") getData("/I21/RdBank0<2>") getData("/I21/RdBank0<1>") getData("/I21/RdBank0<0>") getData("/I21/RdBank0Ack<7>") getData("/I21/RdBank0Ack<6>") getData("/I21/RdBank0Ack<5>") getData("/I21/RdBank0Ack<4>") getData("/I21/RdBank0Ack<3>") getData("/I21/RdBank0Ack<2>") getData("/I21/RdBank0Ack<1>") getData("/I21/RdBank0Ack<0>") getData("/I21/RdBank1<31>") getData("/I21/RdBank1<30>") getData("/I21/RdBank1<29>") getData("/I21/RdBank1<28>") getData("/I21/RdBank1<27>") getData("/I21/RdBank1<26>") getData("/I21/RdBank1<25>") getData("/I21/RdBank1<24>") getData("/I21/RdBank1<23>") getData("/I21/RdBank1<22>") getData("/I21/RdBank1<21>") getData("/I21/RdBank1<20>") getData("/I21/RdBank1<19>") getData("/I21/RdBank1<18>") getData("/I21/RdBank1<17>") getData("/I21/RdBank1<16>") getData("/I21/RdBank1<15>") getData("/I21/RdBank1<14>") getData("/I21/RdBank1<13>") getData("/I21/RdBank1<12>") getData("/I21/RdBank1<11>") getData("/I21/RdBank1<10>") getData("/I21/RdBank1<9>") getData("/I21/RdBank1<8>") getData("/I21/RdBank1<7>") getData("/I21/RdBank1<6>") getData("/I21/RdBank1<5>") getData("/I21/RdBank1<4>") getData("/I21/RdBank1<3>") getData("/I21/RdBank1<2>") getData("/I21/RdBank1<1>") getData("/I21/RdBank1<0>") getData("/I21/RdBank1Ack<7>") getData("/I21/RdBank1Ack<6>") getData("/I21/RdBank1Ack<5>") getData("/I21/RdBank1Ack<4>") getData("/I21/RdBank1Ack<3>") getData("/I21/RdBank1Ack<2>") getData("/I21/RdBank1Ack<1>") getData("/I21/RdBank1Ack<0>") getData("/WData<15:0>") )
resultsDir( "/net/bull/apps/Cadence/simulation/6T_MultiBank_8K_4K_Test/spectreVerilog/config/distributed/MBank_8K_r4K_850mV_85C" )
modelFile(
    '("/software/cadence/ncsu-FreePDK15/hspice_16nm_hp.include" "")
)
option(	'temp  "85.0"
)
temp( 85.0 )
run( ?jobName "job" ?queue "c2107" ?host "redbelly" )
selectResult( 'tran )
plot(getData("/ReadEn") getData("/R_Address<11:0>") getData("/W_Address<11:0>") getData("/WriteEn") getData("/WDataAck<7:0>") getData("/RData<15:0>") getData("/ReadAck") getData("/WriteAck") getData("/RAckT") getData("/RDataT<15>") getData("/RDataT<14>") getData("/RDataT<13>") getData("/RDataT<12>") getData("/RDataT<11>") getData("/RDataT<10>") getData("/RDataT<9>") getData("/RDataT<8>") getData("/RDataT<7>") getData("/RDataT<6>") getData("/RDataT<5>") getData("/RDataT<4>") getData("/RDataT<3>") getData("/RDataT<2>") getData("/RDataT<1>") getData("/RDataT<0>") getData("/WAckT") getData("/R_AddressT<11>") getData("/R_AddressT<10>") getData("/R_AddressT<9>") getData("/R_AddressT<8>") getData("/R_AddressT<7>") getData("/R_AddressT<6>") getData("/R_AddressT<5>") getData("/R_AddressT<4>") getData("/R_AddressT<3>") getData("/R_AddressT<2>") getData("/R_AddressT<1>") getData("/R_AddressT<0>") getData("/ReadEnT") getData("/W_AddressT<11>") getData("/W_AddressT<10>") getData("/W_AddressT<9>") getData("/W_AddressT<8>") getData("/W_AddressT<7>") getData("/W_AddressT<6>") getData("/W_AddressT<5>") getData("/W_AddressT<4>") getData("/W_AddressT<3>") getData("/W_AddressT<2>") getData("/W_AddressT<1>") getData("/W_AddressT<0>") getData("/WriteEnT") getData("/WDataT<15>") getData("/WDataT<14>") getData("/WDataT<13>") getData("/WDataT<12>") getData("/WDataT<11>") getData("/WDataT<10>") getData("/WDataT<9>") getData("/WDataT<8>") getData("/WDataT<7>") getData("/WDataT<6>") getData("/WDataT<5>") getData("/WDataT<4>") getData("/WDataT<3>") getData("/WDataT<2>") getData("/WDataT<1>") getData("/WDataT<0>") getData("/WDataAckT<7>") getData("/WDataAckT<6>") getData("/WDataAckT<5>") getData("/WDataAckT<4>") getData("/WDataAckT<3>") getData("/WDataAckT<2>") getData("/WDataAckT<1>") getData("/WDataAckT<0>") getData("/V0/MINUS") getData("/I21/Wd<31>") getData("/I21/Wd<30>") getData("/I21/Wd<29>") getData("/I21/Wd<28>") getData("/I21/Wd<19>") getData("/I21/Wd<18>") getData("/I21/Wd<17>") getData("/I21/Wd<16>") getData("/I21/Wd<23>") getData("/I21/Wd<22>") getData("/I21/Wd<21>") getData("/I21/Wd<20>") getData("/I21/Wd<27>") getData("/I21/Wd<26>") getData("/I21/Wd<25>") getData("/I21/Wd<24>") getData("/I21/WdAck<7>") getData("/I21/WdAck<6>") getData("/I21/WdAck<5>") getData("/I21/WdAck<4>") getData("/I21/WdAck<3>") getData("/I21/WdAck<2>") getData("/I21/WdAck<1>") getData("/I21/WdAck<0>") getData("/I21/Wd<11>") getData("/I21/Wd<10>") getData("/I21/Wd<9>") getData("/I21/Wd<8>") getData("/I21/Wd<15>") getData("/I21/Wd<14>") getData("/I21/Wd<13>") getData("/I21/Wd<12>") getData("/I21/Wd<7>") getData("/I21/Wd<6>") getData("/I21/Wd<5>") getData("/I21/Wd<4>") getData("/I21/Wd<3>") getData("/I21/Wd<2>") getData("/I21/Wd<1>") getData("/I21/Wd<0>") getData("/I21/Rd<11>") getData("/I21/Rd<10>") getData("/I21/Rd<9>") getData("/I21/Rd<8>") getData("/I21/RdAck<7>") getData("/I21/RdAck<6>") getData("/I21/RdAck<5>") getData("/I21/RdAck<4>") getData("/I21/RdAck<3>") getData("/I21/RdAck<2>") getData("/I21/RdAck<1>") getData("/I21/RdAck<0>") getData("/I21/Rd<23>") getData("/I21/Rd<22>") getData("/I21/Rd<21>") getData("/I21/Rd<20>") getData("/I21/Rd<27>") getData("/I21/Rd<26>") getData("/I21/Rd<25>") getData("/I21/Rd<24>") getData("/I21/Rd<31>") getData("/I21/Rd<30>") getData("/I21/Rd<29>") getData("/I21/Rd<28>") getData("/I21/Rd<19>") getData("/I21/Rd<18>") getData("/I21/Rd<17>") getData("/I21/Rd<16>") getData("/I21/Rd<7>") getData("/I21/Rd<6>") getData("/I21/Rd<5>") getData("/I21/Rd<4>") getData("/I21/Rd<3>") getData("/I21/Rd<2>") getData("/I21/Rd<1>") getData("/I21/Rd<0>") getData("/I21/Rd<15>") getData("/I21/Rd<14>") getData("/I21/Rd<13>") getData("/I21/Rd<12>") getData("/I21/WdBank0<31>") getData("/I21/WdBank0<30>") getData("/I21/WdBank0<29>") getData("/I21/WdBank0<28>") getData("/I21/WdBank0<27>") getData("/I21/WdBank0<26>") getData("/I21/WdBank0<25>") getData("/I21/WdBank0<24>") getData("/I21/WdBank0<23>") getData("/I21/WdBank0<22>") getData("/I21/WdBank0<21>") getData("/I21/WdBank0<20>") getData("/I21/WdBank0<19>") getData("/I21/WdBank0<18>") getData("/I21/WdBank0<17>") getData("/I21/WdBank0<16>") getData("/I21/WdBank0<15>") getData("/I21/WdBank0<14>") getData("/I21/WdBank0<13>") getData("/I21/WdBank0<12>") getData("/I21/WdBank0<11>") getData("/I21/WdBank0<10>") getData("/I21/WdBank0<9>") getData("/I21/WdBank0<8>") getData("/I21/WdBank0<7>") getData("/I21/WdBank0<6>") getData("/I21/WdBank0<5>") getData("/I21/WdBank0<4>") getData("/I21/WdBank0<3>") getData("/I21/WdBank0<2>") getData("/I21/WdBank0<1>") getData("/I21/WdBank0<0>") getData("/I21/Bank0WAck<7>") getData("/I21/Bank0WAck<6>") getData("/I21/Bank0WAck<5>") getData("/I21/Bank0WAck<4>") getData("/I21/Bank0WAck<3>") getData("/I21/Bank0WAck<2>") getData("/I21/Bank0WAck<1>") getData("/I21/Bank0WAck<0>") getData("/I21/WdBank1<31>") getData("/I21/WdBank1<30>") getData("/I21/WdBank1<29>") getData("/I21/WdBank1<28>") getData("/I21/WdBank1<27>") getData("/I21/WdBank1<26>") getData("/I21/WdBank1<25>") getData("/I21/WdBank1<24>") getData("/I21/WdBank1<23>") getData("/I21/WdBank1<22>") getData("/I21/WdBank1<21>") getData("/I21/WdBank1<20>") getData("/I21/WdBank1<19>") getData("/I21/WdBank1<18>") getData("/I21/WdBank1<17>") getData("/I21/WdBank1<16>") getData("/I21/WdBank1<15>") getData("/I21/WdBank1<14>") getData("/I21/WdBank1<13>") getData("/I21/WdBank1<12>") getData("/I21/WdBank1<11>") getData("/I21/WdBank1<10>") getData("/I21/WdBank1<9>") getData("/I21/WdBank1<8>") getData("/I21/WdBank1<7>") getData("/I21/WdBank1<6>") getData("/I21/WdBank1<5>") getData("/I21/WdBank1<4>") getData("/I21/WdBank1<3>") getData("/I21/WdBank1<2>") getData("/I21/WdBank1<1>") getData("/I21/WdBank1<0>") getData("/I21/Bank1WAck<7>") getData("/I21/Bank1WAck<6>") getData("/I21/Bank1WAck<5>") getData("/I21/Bank1WAck<4>") getData("/I21/Bank1WAck<3>") getData("/I21/Bank1WAck<2>") getData("/I21/Bank1WAck<1>") getData("/I21/Bank1WAck<0>") getData("/I21/net0201") getData("/I21/net0205") getData("/I21/net018") getData("/I21/net017") getData("/I21/net022") getData("/I21/net021") getData("/I21/net020") getData("/I21/net019") getData("/I21/RdBank0<31>") getData("/I21/RdBank0<30>") getData("/I21/RdBank0<29>") getData("/I21/RdBank0<28>") getData("/I21/RdBank0<27>") getData("/I21/RdBank0<26>") getData("/I21/RdBank0<25>") getData("/I21/RdBank0<24>") getData("/I21/RdBank0<23>") getData("/I21/RdBank0<22>") getData("/I21/RdBank0<21>") getData("/I21/RdBank0<20>") getData("/I21/RdBank0<19>") getData("/I21/RdBank0<18>") getData("/I21/RdBank0<17>") getData("/I21/RdBank0<16>") getData("/I21/RdBank0<15>") getData("/I21/RdBank0<14>") getData("/I21/RdBank0<13>") getData("/I21/RdBank0<12>") getData("/I21/RdBank0<11>") getData("/I21/RdBank0<10>") getData("/I21/RdBank0<9>") getData("/I21/RdBank0<8>") getData("/I21/RdBank0<7>") getData("/I21/RdBank0<6>") getData("/I21/RdBank0<5>") getData("/I21/RdBank0<4>") getData("/I21/RdBank0<3>") getData("/I21/RdBank0<2>") getData("/I21/RdBank0<1>") getData("/I21/RdBank0<0>") getData("/I21/RdBank0Ack<7>") getData("/I21/RdBank0Ack<6>") getData("/I21/RdBank0Ack<5>") getData("/I21/RdBank0Ack<4>") getData("/I21/RdBank0Ack<3>") getData("/I21/RdBank0Ack<2>") getData("/I21/RdBank0Ack<1>") getData("/I21/RdBank0Ack<0>") getData("/I21/RdBank1<31>") getData("/I21/RdBank1<30>") getData("/I21/RdBank1<29>") getData("/I21/RdBank1<28>") getData("/I21/RdBank1<27>") getData("/I21/RdBank1<26>") getData("/I21/RdBank1<25>") getData("/I21/RdBank1<24>") getData("/I21/RdBank1<23>") getData("/I21/RdBank1<22>") getData("/I21/RdBank1<21>") getData("/I21/RdBank1<20>") getData("/I21/RdBank1<19>") getData("/I21/RdBank1<18>") getData("/I21/RdBank1<17>") getData("/I21/RdBank1<16>") getData("/I21/RdBank1<15>") getData("/I21/RdBank1<14>") getData("/I21/RdBank1<13>") getData("/I21/RdBank1<12>") getData("/I21/RdBank1<11>") getData("/I21/RdBank1<10>") getData("/I21/RdBank1<9>") getData("/I21/RdBank1<8>") getData("/I21/RdBank1<7>") getData("/I21/RdBank1<6>") getData("/I21/RdBank1<5>") getData("/I21/RdBank1<4>") getData("/I21/RdBank1<3>") getData("/I21/RdBank1<2>") getData("/I21/RdBank1<1>") getData("/I21/RdBank1<0>") getData("/I21/RdBank1Ack<7>") getData("/I21/RdBank1Ack<6>") getData("/I21/RdBank1Ack<5>") getData("/I21/RdBank1Ack<4>") getData("/I21/RdBank1Ack<3>") getData("/I21/RdBank1Ack<2>") getData("/I21/RdBank1Ack<1>") getData("/I21/RdBank1Ack<0>") getData("/WData<15:0>") )
