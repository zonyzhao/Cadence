simulator( 'spectreVerilog )
design(	 "/net/kafka/nfs/rstdenis/Cadence/simulation/Compare24_Test/spectreVerilog/config/netlist/analog/netlist")
resultsDir( "/net/kafka/nfs/rstdenis/Cadence/simulation/Compare24_Test/spectreVerilog/config" )
modelFile(
    '("/software/cadence/ncsu-FreePDK15/hspice_16nm_hp.include" "")
)
analysis('tran ?stop "12n"  ?errpreset "conservative"  )
desVar(	  "vdd" .500	)
envOption(
	'analysisOrder  list("tran")
)
option(	'multithread  "on"
	'temp  "30.0"
)
saveOption( ?simOutputFormat "psfxl" )
save( 'v "/vcc!" "/vdd!" )
save( 'i "/V0/MINUS" "/V1/MINUS" "/V1/PLUS" "/V0/PLUS" )
converge( 'ic "/b1T<0>" "0" )
converge( 'ic "/b1T<1>" "0" )
converge( 'ic "/b1T<2>" "0" )
converge( 'ic "/b1T<3>" "0" )
converge( 'ic "/b1T<4>" "0" )
converge( 'ic "/b1T<5>" "0" )
converge( 'ic "/b1T<6>" "0" )
converge( 'ic "/b1T<7>" "0" )
converge( 'ic "/b1T<8>" "0" )
converge( 'ic "/b1T<9>" "0" )
converge( 'ic "/b1T<10>" "0" )
converge( 'ic "/b1T<11>" "0" )
converge( 'ic "/b1T<12>" "0" )
converge( 'ic "/b1T<13>" "0" )
converge( 'ic "/b1T<14>" "0" )
converge( 'ic "/b1T<15>" "0" )
converge( 'ic "/b1T<16>" "0" )
converge( 'ic "/b1T<17>" "0" )
converge( 'ic "/b1T<18>" "0" )
converge( 'ic "/b1T<19>" "0" )
converge( 'ic "/b1T<20>" "0" )
converge( 'ic "/b1T<21>" "0" )
converge( 'ic "/b1T<22>" "0" )
converge( 'ic "/b1T<23>" "0" )
converge( 'ic "/b0T<0>" "0" )
converge( 'ic "/b0T<1>" "0" )
converge( 'ic "/b0T<2>" "0" )
converge( 'ic "/b0T<3>" "0" )
converge( 'ic "/b0T<4>" "0" )
converge( 'ic "/b0T<5>" "0" )
converge( 'ic "/b0T<6>" "0" )
converge( 'ic "/b0T<7>" "0" )
converge( 'ic "/b0T<8>" "0" )
converge( 'ic "/b0T<9>" "0" )
converge( 'ic "/b0T<10>" "0" )
converge( 'ic "/b0T<11>" "0" )
converge( 'ic "/b0T<12>" "0" )
converge( 'ic "/b0T<13>" "0" )
converge( 'ic "/b0T<14>" "0" )
converge( 'ic "/b0T<15>" "0" )
converge( 'ic "/b0T<16>" "0" )
converge( 'ic "/b0T<17>" "0" )
converge( 'ic "/b0T<18>" "0" )
converge( 'ic "/b0T<19>" "0" )
converge( 'ic "/b0T<20>" "0" )
converge( 'ic "/b0T<21>" "0" )
converge( 'ic "/b0T<22>" "0" )
converge( 'ic "/b0T<23>" "0" )
converge( 'ic "/a0T<0>" "0" )
converge( 'ic "/a0T<1>" "0" )
converge( 'ic "/a0T<2>" "0" )
converge( 'ic "/a0T<3>" "0" )
converge( 'ic "/a0T<4>" "0" )
converge( 'ic "/a0T<5>" "0" )
converge( 'ic "/a0T<6>" "0" )
converge( 'ic "/a0T<7>" "0" )
converge( 'ic "/a0T<8>" "0" )
converge( 'ic "/a0T<9>" "0" )
converge( 'ic "/a0T<10>" "0" )
converge( 'ic "/a0T<11>" "0" )
converge( 'ic "/a0T<12>" "0" )
converge( 'ic "/a0T<13>" "0" )
converge( 'ic "/a0T<14>" "0" )
converge( 'ic "/a0T<15>" "0" )
converge( 'ic "/a0T<16>" "0" )
converge( 'ic "/a0T<17>" "0" )
converge( 'ic "/a0T<18>" "0" )
converge( 'ic "/a0T<19>" "0" )
converge( 'ic "/a0T<20>" "0" )
converge( 'ic "/a0T<21>" "0" )
converge( 'ic "/a0T<22>" "0" )
converge( 'ic "/a0T<23>" "0" )
converge( 'ic "/a1T<0>" "0" )
converge( 'ic "/a1T<1>" "0" )
converge( 'ic "/a1T<2>" "0" )
converge( 'ic "/a1T<3>" "0" )
converge( 'ic "/a1T<4>" "0" )
converge( 'ic "/a1T<5>" "0" )
converge( 'ic "/a1T<6>" "0" )
converge( 'ic "/a1T<7>" "0" )
converge( 'ic "/a1T<8>" "0" )
converge( 'ic "/a1T<9>" "0" )
converge( 'ic "/a1T<10>" "0" )
converge( 'ic "/a1T<11>" "0" )
converge( 'ic "/a1T<12>" "0" )
converge( 'ic "/a1T<13>" "0" )
converge( 'ic "/a1T<14>" "0" )
converge( 'ic "/a1T<15>" "0" )
converge( 'ic "/a1T<16>" "0" )
converge( 'ic "/a1T<17>" "0" )
converge( 'ic "/a1T<18>" "0" )
converge( 'ic "/a1T<19>" "0" )
converge( 'ic "/a1T<20>" "0" )
converge( 'ic "/a1T<21>" "0" )
converge( 'ic "/a1T<22>" "0" )
converge( 'ic "/a1T<23>" "0" )
temp( 30.0 )
run()
selectResult( 'tran )
plot(getData("/a1<23:0>") getData("/a0<23:0>") getData("/b1<23:0>") getData("/b0<23:0>") getData("/Hit") getData("/Valid") getData("/Miss") getData("/a1T<3>") getData("/a1T<2>") getData("/a1T<1>") getData("/a1T<0>") getData("/a0T<3>") getData("/a0T<2>") getData("/a0T<1>") getData("/a0T<0>") getData("/b0T<3>") getData("/b0T<2>") getData("/b0T<1>") getData("/b0T<0>") getData("/b1T<3>") getData("/b1T<2>") getData("/b1T<1>") getData("/b1T<0>") getData("/HitT") getData("/ValidT") getData("/MissT") getData("/I4/1y0<3>") getData("/I4/1y0<2>") getData("/I4/1y0<1>") getData("/I4/1y0<0>") getData("/I4/1y1<3>") getData("/I4/1y1<2>") getData("/I4/1y1<1>") getData("/I4/1y1<0>") getData("/I4/2y0<3>") getData("/I4/2y0<2>") getData("/I4/2y0<1>") getData("/I4/2y0<0>") getData("/I4/2y1<3>") getData("/I4/2y1<2>") getData("/I4/2y1<1>") getData("/I4/2y1<0>") getData("/I4/s2_n1_y0<3>") getData("/I4/s2_n1_y0<2>") getData("/I4/s2_n1_y0<1>") getData("/I4/s2_n1_y0<0>") getData("/I4/s2_n1_y1<3>") getData("/I4/s2_n1_y1<2>") getData("/I4/s2_n1_y1<1>") getData("/I4/s2_n1_y1<0>") getData("/I4/net47<0>") getData("/I4/net47<1>") getData("/I4/net47<2>") getData("/I4/net47<3>") getData("/I4/net46<0>") getData("/I4/net46<1>") getData("/I4/net46<2>") getData("/I4/net46<3>") getData("/I4/s3_y0<3>") getData("/I4/s3_y0<2>") getData("/I4/s3_y0<1>") getData("/I4/s3_y0<0>") getData("/I4/s3_y1<3>") getData("/I4/s3_y1<2>") getData("/I4/s3_y1<1>") getData("/I4/s3_y1<0>") getData("/I4/sfy0<1>") getData("/I4/sfy0<0>") getData("/I4/sfy1<1>") getData("/I4/sfy1<0>") getData("/V0/MINUS") getData("/V1/MINUS") getData("/vcc!") getData("/V1/PLUS") getData("/V0/PLUS") getData("/vdd!") getData("/gnd!") )
modelFile(
    '("/software/cadence/ncsu-FreePDK15/hspice_16nm_hp.include" "")
)
run()
selectResult( 'tran )
plot(getData("/a1<23:0>") getData("/a0<23:0>") getData("/b1<23:0>") getData("/b0<23:0>") getData("/Hit") getData("/Valid") getData("/Miss") getData("/a1T<3>") getData("/a1T<2>") getData("/a1T<1>") getData("/a1T<0>") getData("/a0T<3>") getData("/a0T<2>") getData("/a0T<1>") getData("/a0T<0>") getData("/b0T<3>") getData("/b0T<2>") getData("/b0T<1>") getData("/b0T<0>") getData("/b1T<3>") getData("/b1T<2>") getData("/b1T<1>") getData("/b1T<0>") getData("/HitT") getData("/ValidT") getData("/MissT") getData("/I4/1y0<3>") getData("/I4/1y0<2>") getData("/I4/1y0<1>") getData("/I4/1y0<0>") getData("/I4/1y1<3>") getData("/I4/1y1<2>") getData("/I4/1y1<1>") getData("/I4/1y1<0>") getData("/I4/2y0<3>") getData("/I4/2y0<2>") getData("/I4/2y0<1>") getData("/I4/2y0<0>") getData("/I4/2y1<3>") getData("/I4/2y1<2>") getData("/I4/2y1<1>") getData("/I4/2y1<0>") getData("/I4/s2_n1_y0<3>") getData("/I4/s2_n1_y0<2>") getData("/I4/s2_n1_y0<1>") getData("/I4/s2_n1_y0<0>") getData("/I4/s2_n1_y1<3>") getData("/I4/s2_n1_y1<2>") getData("/I4/s2_n1_y1<1>") getData("/I4/s2_n1_y1<0>") getData("/I4/net47<0>") getData("/I4/net47<1>") getData("/I4/net47<2>") getData("/I4/net47<3>") getData("/I4/net46<0>") getData("/I4/net46<1>") getData("/I4/net46<2>") getData("/I4/net46<3>") getData("/I4/s3_y0<3>") getData("/I4/s3_y0<2>") getData("/I4/s3_y0<1>") getData("/I4/s3_y0<0>") getData("/I4/s3_y1<3>") getData("/I4/s3_y1<2>") getData("/I4/s3_y1<1>") getData("/I4/s3_y1<0>") getData("/I4/sfy0<1>") getData("/I4/sfy0<0>") getData("/I4/sfy1<1>") getData("/I4/sfy1<0>") getData("/V0/MINUS") getData("/V1/MINUS") getData("/vcc!") getData("/V1/PLUS") getData("/V0/PLUS") getData("/vdd!") getData("/gnd!") )
modelFile(
    '("/software/cadence/ncsu-FreePDK15/hspice_16nm_hp.include" "")
)
run()
selectResult( 'tran )
plot(getData("/a1<23:0>") getData("/a0<23:0>") getData("/b1<23:0>") getData("/b0<23:0>") getData("/Hit") getData("/Valid") getData("/Miss") getData("/a1T<3>") getData("/a1T<2>") getData("/a1T<1>") getData("/a1T<0>") getData("/a0T<3>") getData("/a0T<2>") getData("/a0T<1>") getData("/a0T<0>") getData("/b0T<3>") getData("/b0T<2>") getData("/b0T<1>") getData("/b0T<0>") getData("/b1T<3>") getData("/b1T<2>") getData("/b1T<1>") getData("/b1T<0>") getData("/HitT") getData("/ValidT") getData("/MissT") getData("/I4/1y0<3>") getData("/I4/1y0<2>") getData("/I4/1y0<1>") getData("/I4/1y0<0>") getData("/I4/1y1<3>") getData("/I4/1y1<2>") getData("/I4/1y1<1>") getData("/I4/1y1<0>") getData("/I4/2y0<3>") getData("/I4/2y0<2>") getData("/I4/2y0<1>") getData("/I4/2y0<0>") getData("/I4/2y1<3>") getData("/I4/2y1<2>") getData("/I4/2y1<1>") getData("/I4/2y1<0>") getData("/I4/s2_n1_y0<3>") getData("/I4/s2_n1_y0<2>") getData("/I4/s2_n1_y0<1>") getData("/I4/s2_n1_y0<0>") getData("/I4/s2_n1_y1<3>") getData("/I4/s2_n1_y1<2>") getData("/I4/s2_n1_y1<1>") getData("/I4/s2_n1_y1<0>") getData("/I4/net47<0>") getData("/I4/net47<1>") getData("/I4/net47<2>") getData("/I4/net47<3>") getData("/I4/net46<0>") getData("/I4/net46<1>") getData("/I4/net46<2>") getData("/I4/net46<3>") getData("/I4/s3_y0<3>") getData("/I4/s3_y0<2>") getData("/I4/s3_y0<1>") getData("/I4/s3_y0<0>") getData("/I4/s3_y1<3>") getData("/I4/s3_y1<2>") getData("/I4/s3_y1<1>") getData("/I4/s3_y1<0>") getData("/I4/sfy0<1>") getData("/I4/sfy0<0>") getData("/I4/sfy1<1>") getData("/I4/sfy1<0>") getData("/V0/MINUS") getData("/V1/MINUS") getData("/vcc!") getData("/V1/PLUS") getData("/V0/PLUS") getData("/vdd!") getData("/gnd!") )
modelFile(
    '("/software/cadence/ncsu-FreePDK15/hspice_16nm_hp.include" "")
)
run()
selectResult( 'tran )
plot(getData("/a1<23:0>") getData("/a0<23:0>") getData("/b1<23:0>") getData("/b0<23:0>") getData("/Hit") getData("/Valid") getData("/Miss") getData("/a1T<3>") getData("/a1T<2>") getData("/a1T<1>") getData("/a1T<0>") getData("/a0T<3>") getData("/a0T<2>") getData("/a0T<1>") getData("/a0T<0>") getData("/b0T<3>") getData("/b0T<2>") getData("/b0T<1>") getData("/b0T<0>") getData("/b1T<3>") getData("/b1T<2>") getData("/b1T<1>") getData("/b1T<0>") getData("/HitT") getData("/ValidT") getData("/MissT") getData("/I4/1y0<3>") getData("/I4/1y0<2>") getData("/I4/1y0<1>") getData("/I4/1y0<0>") getData("/I4/1y1<3>") getData("/I4/1y1<2>") getData("/I4/1y1<1>") getData("/I4/1y1<0>") getData("/I4/2y0<3>") getData("/I4/2y0<2>") getData("/I4/2y0<1>") getData("/I4/2y0<0>") getData("/I4/2y1<3>") getData("/I4/2y1<2>") getData("/I4/2y1<1>") getData("/I4/2y1<0>") getData("/I4/s2_n1_y0<3>") getData("/I4/s2_n1_y0<2>") getData("/I4/s2_n1_y0<1>") getData("/I4/s2_n1_y0<0>") getData("/I4/s2_n1_y1<3>") getData("/I4/s2_n1_y1<2>") getData("/I4/s2_n1_y1<1>") getData("/I4/s2_n1_y1<0>") getData("/I4/net47<0>") getData("/I4/net47<1>") getData("/I4/net47<2>") getData("/I4/net47<3>") getData("/I4/net46<0>") getData("/I4/net46<1>") getData("/I4/net46<2>") getData("/I4/net46<3>") getData("/I4/s3_y0<3>") getData("/I4/s3_y0<2>") getData("/I4/s3_y0<1>") getData("/I4/s3_y0<0>") getData("/I4/s3_y1<3>") getData("/I4/s3_y1<2>") getData("/I4/s3_y1<1>") getData("/I4/s3_y1<0>") getData("/I4/sfy0<1>") getData("/I4/sfy0<0>") getData("/I4/sfy1<1>") getData("/I4/sfy1<0>") getData("/V0/MINUS") getData("/V1/MINUS") getData("/vcc!") getData("/V1/PLUS") getData("/V0/PLUS") getData("/vdd!") getData("/gnd!") )
