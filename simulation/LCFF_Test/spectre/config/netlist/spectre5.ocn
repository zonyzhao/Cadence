simulator( 'spectre )
design(	 "/net/kafka/nfs/rstdenis/Cadence/simulation/LCFF_Test/spectre/config/netlist/netlist")
resultsDir( "/net/kafka/nfs/rstdenis/Cadence/simulation/LCFF_Test/spectre/config" )
analysis('tran ?stop "10n"  ?errpreset "conservative"  )
desVar(	  "vddH" .850	)
desVar(	  "vddL" .500	)
desVar(	  "vdd" .500	)
desVar(	  "vcc" .500	)
temp( 27 )
run()
selectResult( 'tran )
plot(getData("/tCLK") getData("/tD") getData("/tCLK~") getData("/Q") )
desVar(	  "pClk" 1n	)
desVar(	  "time3" 5.01n	)
desVar(	  "time2" 5n	)
run()
selectResult( 'tran )
plot(getData("/tCLK") getData("/tD") getData("/tCLK~") getData("/Q") )
save( 'v "/tD" )
run()
selectResult( 'tran )
plot(getData("/tCLK") getData("/tD") getData("/tCLK~") getData("/Q") )
delete( 'save 'v /tD )
run()
selectResult( 'tran )
plot(getData("/tCLK") getData("/tD") getData("/tCLK~") getData("/Q") )
modelFile(
    '("/home/cadence/ncsu-FreePDK15/hspice_16nm_hp.include" "")
)
run()
selectResult( 'tran )
plot(getData("/tCLK") getData("/tD") getData("/tCLK~") getData("/Q") )
modelFile(
    '("/home/cadence/ncsu-FreePDK15/hspice_16nm_hp.include" "")
)
run()
selectResult( 'tran )
plot(getData("/tCLK") getData("/tD") getData("/tCLK~") getData("/Q") )
modelFile(
    '("/home/cadence/ncsu-FreePDK15/hspice_16nm_hp.include" "")
)
desVar(	  "time3" 5.3n	)
desVar(	  "time2" 5.25n	)
run()
selectResult( 'tran )
plot(getData("/tCLK") getData("/tD") getData("/tCLK~") getData("/Q") )
modelFile(
    '("/home/cadence/ncsu-FreePDK15/hspice_16nm_hp.include" "")
)
run()
selectResult( 'tran )
plot(getData("/tCLK") getData("/tD") getData("/tCLK~") getData("/Q") )
modelFile(
    '("/home/cadence/ncsu-FreePDK15/hspice_16nm_hp.include" "")
)
delete( 'desVar "vcc" )
run()
selectResult( 'tran )
plot(getData("/I0/PG1") getData("/I0/PG2") getData("/I0/mf") getData("/tCLK") getData("/tD") getData("/tCLK~") getData("/Q") )
modelFile(
    '("/home/cadence/ncsu-FreePDK15/hspice_16nm_hp.include" "")
)
delete( 'desVar "vcc" )
run()
selectResult( 'tran )
plot(getData("/tCLK") getData("/tD") getData("/tCLK~") getData("/Q") getData("/I0/mf") getData("/I0/PG2") getData("/I0/PG1") )
modelFile(
    '("/home/cadence/ncsu-FreePDK15/hspice_16nm_hp.include" "")
)
desVar(	  "pClk" 2.5n	)
run()
selectResult( 'tran )
plot(getData("/tCLK") getData("/tD") getData("/tCLK~") getData("/Q") getData("/I0/mf") getData("/I0/PG2") getData("/I0/PG1") )
modelFile(
    '("/home/cadence/ncsu-FreePDK15/hspice_16nm_hp.include" "")
)
run()
selectResult( 'tran )
plot(getData("/tCLK") getData("/tD") getData("/tCLK~") getData("/Q") getData("/I0/mf") getData("/I0/PG2") getData("/I0/PG1") )
modelFile(
    '("/home/cadence/ncsu-FreePDK15/hspice_16nm_hp.include" "")
)
run()
selectResult( 'tran )
plot(getData("/tCLK") getData("/tD") getData("/tCLK~") getData("/Q") getData("/I0/mf") getData("/I0/PG2") getData("/I0/PG1") )
modelFile(
    '("/home/cadence/ncsu-FreePDK15/hspice_16nm_hp.include" "")
)
run()
selectResult( 'tran )
plot(getData("/tCLK") getData("/tD") getData("/tCLK~") getData("/Q") getData("/I0/mf") getData("/I0/PG2") getData("/I0/PG1") )
modelFile(
    '("/home/cadence/ncsu-FreePDK15/hspice_16nm_hp.include" "")
)
run()
selectResult( 'tran )
plot(getData("/tCLK") getData("/tD") getData("/tCLK~") getData("/Q") getData("/I0/mf") getData("/I0/PG2") getData("/I0/PG1") )
modelFile(
    '("/home/cadence/ncsu-FreePDK15/hspice_16nm_hp.include" "")
)
desVar(	  "vddH" .800	)
desVar(	  "vddL" .400	)
desVar(	  "vdd" .400	)
run()
selectResult( 'tran )
plot(getData("/tCLK") getData("/tD") getData("/tCLK~") getData("/Q") getData("/I0/mf") getData("/I0/PG2") getData("/I0/PG1") )
modelFile(
    '("/home/cadence/ncsu-FreePDK15/hspice_16nm_hp.include" "")
)
run()
selectResult( 'tran )
plot(getData("/tCLK") getData("/tD") getData("/tCLK~") getData("/Q") getData("/I0/mf") getData("/I0/PG2") getData("/I0/PG1") )
modelFile(
    '("/home/cadence/ncsu-FreePDK15/hspice_16nm_hp.include" "")
)
desVar(	  "time3" 5.15n	)
desVar(	  "time2" 5.1n	)
run()
selectResult( 'tran )
plot(getData("/tCLK") getData("/tD") getData("/tCLK~") getData("/Q") getData("/I0/mf") getData("/I0/PG2") getData("/I0/PG1") )
