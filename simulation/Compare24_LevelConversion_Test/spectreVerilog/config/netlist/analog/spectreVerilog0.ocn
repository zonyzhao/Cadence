simulator( 'spectreVerilog )
design(	 "/net/kafka/nfs/rstdenis/Cadence/simulation/Compare24_LevelConversion_Test/spectreVerilog/config/netlist/analog/netlist")
resultsDir( "/net/kafka/nfs/rstdenis/Cadence/simulation/Compare24_LevelConversion_Test/spectreVerilog/config" )
modelFile(
    '("/software/cadence/ncsu-FreePDK15/hspice_16nm_hp.include" "")
)
analysis('tran ?stop "12n"  ?errpreset "conservative"  )
desVar(	  "vdd" .500	)
desVar(	  "vddH" .850	)
envOption(
	'analysisOrder  list("tran")
)
option(	'multithread  "on"
)
saveOption( ?simOutputFormat "psfxl" )
temp( 27 )
run()
selectResult( 'tran )
plot(getData("/a1<23:0>") getData("/a0<23:0>") getData("/b1<23:0>") getData("/b0<23:0>") getData("/Hit") getData("/Valid") getData("/Miss") getData("/a1T<23>") getData("/a1T<22>") getData("/a1T<21>") getData("/a1T<20>") getData("/a1T<19>") getData("/a1T<18>") getData("/a1T<17>") getData("/a1T<16>") getData("/a1T<15>") getData("/a1T<14>") getData("/a1T<13>") getData("/a1T<12>") getData("/a1T<11>") getData("/a1T<10>") getData("/a1T<9>") getData("/a1T<8>") getData("/a1T<7>") getData("/a1T<6>") getData("/a1T<5>") getData("/a1T<4>") getData("/a1T<3>") getData("/a1T<2>") getData("/a1T<1>") getData("/a1T<0>") getData("/a0T<23>") getData("/a0T<22>") getData("/a0T<21>") getData("/a0T<20>") getData("/a0T<19>") getData("/a0T<18>") getData("/a0T<17>") getData("/a0T<16>") getData("/a0T<15>") getData("/a0T<14>") getData("/a0T<13>") getData("/a0T<12>") getData("/a0T<11>") getData("/a0T<10>") getData("/a0T<9>") getData("/a0T<8>") getData("/a0T<7>") getData("/a0T<6>") getData("/a0T<5>") getData("/a0T<4>") getData("/a0T<3>") getData("/a0T<2>") getData("/a0T<1>") getData("/a0T<0>") getData("/b0T<23>") getData("/b0T<22>") getData("/b0T<21>") getData("/b0T<20>") getData("/b0T<19>") getData("/b0T<18>") getData("/b0T<17>") getData("/b0T<16>") getData("/b0T<15>") getData("/b0T<14>") getData("/b0T<13>") getData("/b0T<12>") getData("/b0T<11>") getData("/b0T<10>") getData("/b0T<9>") getData("/b0T<8>") getData("/b0T<7>") getData("/b0T<6>") getData("/b0T<5>") getData("/b0T<4>") getData("/b0T<3>") getData("/b0T<2>") getData("/b0T<1>") getData("/b0T<0>") getData("/b1T<23>") getData("/b1T<22>") getData("/b1T<21>") getData("/b1T<20>") getData("/b1T<19>") getData("/b1T<18>") getData("/b1T<17>") getData("/b1T<16>") getData("/b1T<15>") getData("/b1T<14>") getData("/b1T<13>") getData("/b1T<12>") getData("/b1T<11>") getData("/b1T<10>") getData("/b1T<9>") getData("/b1T<8>") getData("/b1T<7>") getData("/b1T<6>") getData("/b1T<5>") getData("/b1T<4>") getData("/b1T<3>") getData("/b1T<2>") getData("/b1T<1>") getData("/b1T<0>") getData("/HitT") getData("/ValidT") getData("/MissT") )
modelFile(
    '("/software/cadence/ncsu-FreePDK15/hspice_16nm_hp.include" "")
)
run()
selectResult( 'tran )
plot(getData("/a1<23:0>") getData("/a0<23:0>") getData("/b1<23:0>") getData("/b0<23:0>") getData("/Hit") getData("/Valid") getData("/Miss") getData("/a1T<23>") getData("/a1T<22>") getData("/a1T<21>") getData("/a1T<20>") getData("/a1T<19>") getData("/a1T<18>") getData("/a1T<17>") getData("/a1T<16>") getData("/a1T<15>") getData("/a1T<14>") getData("/a1T<13>") getData("/a1T<12>") getData("/a1T<11>") getData("/a1T<10>") getData("/a1T<9>") getData("/a1T<8>") getData("/a1T<7>") getData("/a1T<6>") getData("/a1T<5>") getData("/a1T<4>") getData("/a1T<3>") getData("/a1T<2>") getData("/a1T<1>") getData("/a1T<0>") getData("/a0T<23>") getData("/a0T<22>") getData("/a0T<21>") getData("/a0T<20>") getData("/a0T<19>") getData("/a0T<18>") getData("/a0T<17>") getData("/a0T<16>") getData("/a0T<15>") getData("/a0T<14>") getData("/a0T<13>") getData("/a0T<12>") getData("/a0T<11>") getData("/a0T<10>") getData("/a0T<9>") getData("/a0T<8>") getData("/a0T<7>") getData("/a0T<6>") getData("/a0T<5>") getData("/a0T<4>") getData("/a0T<3>") getData("/a0T<2>") getData("/a0T<1>") getData("/a0T<0>") getData("/b0T<23>") getData("/b0T<22>") getData("/b0T<21>") getData("/b0T<20>") getData("/b0T<19>") getData("/b0T<18>") getData("/b0T<17>") getData("/b0T<16>") getData("/b0T<15>") getData("/b0T<14>") getData("/b0T<13>") getData("/b0T<12>") getData("/b0T<11>") getData("/b0T<10>") getData("/b0T<9>") getData("/b0T<8>") getData("/b0T<7>") getData("/b0T<6>") getData("/b0T<5>") getData("/b0T<4>") getData("/b0T<3>") getData("/b0T<2>") getData("/b0T<1>") getData("/b0T<0>") getData("/b1T<23>") getData("/b1T<22>") getData("/b1T<21>") getData("/b1T<20>") getData("/b1T<19>") getData("/b1T<18>") getData("/b1T<17>") getData("/b1T<16>") getData("/b1T<15>") getData("/b1T<14>") getData("/b1T<13>") getData("/b1T<12>") getData("/b1T<11>") getData("/b1T<10>") getData("/b1T<9>") getData("/b1T<8>") getData("/b1T<7>") getData("/b1T<6>") getData("/b1T<5>") getData("/b1T<4>") getData("/b1T<3>") getData("/b1T<2>") getData("/b1T<1>") getData("/b1T<0>") getData("/HitT") getData("/ValidT") getData("/MissT") )
modelFile(
    '("/software/cadence/ncsu-FreePDK15/hspice_16nm_hp.include" "")
)
converge( 'ic "/b1T<0>" "0" )
converge( 'ic "/b1T<1>" "0" )
converge( 'ic "/b1T<2>" "0" )
converge( 'ic "/b1T<3>" "0" )
converge( 'ic "/b1T<4>" "0" )
converge( 'ic "/b1T<5>" "0" )
converge( 'ic "/b1T<6>" "0" )
converge( 'ic "/b1T<7>" "0" )
converge( 'ic "/b1T<8>" "0" )
converge( 'ic "/b1T<9>" "0" )
converge( 'ic "/b1T<10>" "0" )
converge( 'ic "/b1T<11>" "0" )
converge( 'ic "/b1T<12>" "0" )
converge( 'ic "/b1T<13>" "0" )
converge( 'ic "/b1T<14>" "0" )
converge( 'ic "/b1T<15>" "0" )
converge( 'ic "/b1T<16>" "0" )
converge( 'ic "/b1T<17>" "0" )
converge( 'ic "/b1T<18>" "0" )
converge( 'ic "/b1T<19>" "0" )
converge( 'ic "/b1T<20>" "0" )
converge( 'ic "/b1T<21>" "0" )
converge( 'ic "/b1T<22>" "0" )
converge( 'ic "/b1T<23>" "0" )
converge( 'ic "/b0T<0>" "0" )
converge( 'ic "/b0T<1>" "0" )
converge( 'ic "/b0T<2>" "0" )
converge( 'ic "/b0T<3>" "0" )
converge( 'ic "/b0T<4>" "0" )
converge( 'ic "/b0T<5>" "0" )
converge( 'ic "/b0T<6>" "0" )
converge( 'ic "/b0T<7>" "0" )
converge( 'ic "/b0T<8>" "0" )
converge( 'ic "/b0T<9>" "0" )
converge( 'ic "/b0T<10>" "0" )
converge( 'ic "/b0T<11>" "0" )
converge( 'ic "/b0T<12>" "0" )
converge( 'ic "/b0T<13>" "0" )
converge( 'ic "/b0T<14>" "0" )
converge( 'ic "/b0T<15>" "0" )
converge( 'ic "/b0T<16>" "0" )
converge( 'ic "/b0T<17>" "0" )
converge( 'ic "/b0T<18>" "0" )
converge( 'ic "/b0T<19>" "0" )
converge( 'ic "/b0T<20>" "0" )
converge( 'ic "/b0T<21>" "0" )
converge( 'ic "/b0T<22>" "0" )
converge( 'ic "/b0T<23>" "0" )
converge( 'ic "/a0T<0>" "0" )
converge( 'ic "/a0T<1>" "0" )
converge( 'ic "/a0T<2>" "0" )
converge( 'ic "/a0T<3>" "0" )
converge( 'ic "/a0T<4>" "0" )
converge( 'ic "/a0T<5>" "0" )
converge( 'ic "/a0T<6>" "0" )
converge( 'ic "/a0T<7>" "0" )
converge( 'ic "/a0T<8>" "0" )
converge( 'ic "/a0T<9>" "0" )
converge( 'ic "/a0T<10>" "0" )
converge( 'ic "/a0T<11>" "0" )
converge( 'ic "/a0T<12>" "0" )
converge( 'ic "/a0T<13>" "0" )
converge( 'ic "/a0T<14>" "0" )
converge( 'ic "/a0T<15>" "0" )
converge( 'ic "/a0T<16>" "0" )
converge( 'ic "/a0T<17>" "0" )
converge( 'ic "/a0T<18>" "0" )
converge( 'ic "/a0T<19>" "0" )
converge( 'ic "/a0T<20>" "0" )
converge( 'ic "/a0T<21>" "0" )
converge( 'ic "/a0T<22>" "0" )
converge( 'ic "/a0T<23>" "0" )
converge( 'ic "/a1T<0>" "0" )
converge( 'ic "/a1T<1>" "0" )
converge( 'ic "/a1T<2>" "0" )
converge( 'ic "/a1T<3>" "0" )
converge( 'ic "/a1T<4>" "0" )
converge( 'ic "/a1T<5>" "0" )
converge( 'ic "/a1T<6>" "0" )
converge( 'ic "/a1T<7>" "0" )
converge( 'ic "/a1T<8>" "0" )
converge( 'ic "/a1T<9>" "0" )
converge( 'ic "/a1T<10>" "0" )
converge( 'ic "/a1T<11>" "0" )
converge( 'ic "/a1T<12>" "0" )
converge( 'ic "/a1T<13>" "0" )
converge( 'ic "/a1T<14>" "0" )
converge( 'ic "/a1T<15>" "0" )
converge( 'ic "/a1T<16>" "0" )
converge( 'ic "/a1T<17>" "0" )
converge( 'ic "/a1T<18>" "0" )
converge( 'ic "/a1T<19>" "0" )
converge( 'ic "/a1T<20>" "0" )
converge( 'ic "/a1T<21>" "0" )
converge( 'ic "/a1T<22>" "0" )
converge( 'ic "/a1T<23>" "0" )
run()
selectResult( 'tran )
plot(getData("/a1<23:0>") getData("/a0<23:0>") getData("/b1<23:0>") getData("/b0<23:0>") getData("/Hit") getData("/Valid") getData("/Miss") getData("/a1T<23>") getData("/a1T<22>") getData("/a1T<21>") getData("/a1T<20>") getData("/a1T<19>") getData("/a1T<18>") getData("/a1T<17>") getData("/a1T<16>") getData("/a1T<15>") getData("/a1T<14>") getData("/a1T<13>") getData("/a1T<12>") getData("/a1T<11>") getData("/a1T<10>") getData("/a1T<9>") getData("/a1T<8>") getData("/a1T<7>") getData("/a1T<6>") getData("/a1T<5>") getData("/a1T<4>") getData("/a1T<3>") getData("/a1T<2>") getData("/a1T<1>") getData("/a1T<0>") getData("/a0T<23>") getData("/a0T<22>") getData("/a0T<21>") getData("/a0T<20>") getData("/a0T<19>") getData("/a0T<18>") getData("/a0T<17>") getData("/a0T<16>") getData("/a0T<15>") getData("/a0T<14>") getData("/a0T<13>") getData("/a0T<12>") getData("/a0T<11>") getData("/a0T<10>") getData("/a0T<9>") getData("/a0T<8>") getData("/a0T<7>") getData("/a0T<6>") getData("/a0T<5>") getData("/a0T<4>") getData("/a0T<3>") getData("/a0T<2>") getData("/a0T<1>") getData("/a0T<0>") getData("/b0T<23>") getData("/b0T<22>") getData("/b0T<21>") getData("/b0T<20>") getData("/b0T<19>") getData("/b0T<18>") getData("/b0T<17>") getData("/b0T<16>") getData("/b0T<15>") getData("/b0T<14>") getData("/b0T<13>") getData("/b0T<12>") getData("/b0T<11>") getData("/b0T<10>") getData("/b0T<9>") getData("/b0T<8>") getData("/b0T<7>") getData("/b0T<6>") getData("/b0T<5>") getData("/b0T<4>") getData("/b0T<3>") getData("/b0T<2>") getData("/b0T<1>") getData("/b0T<0>") getData("/b1T<23>") getData("/b1T<22>") getData("/b1T<21>") getData("/b1T<20>") getData("/b1T<19>") getData("/b1T<18>") getData("/b1T<17>") getData("/b1T<16>") getData("/b1T<15>") getData("/b1T<14>") getData("/b1T<13>") getData("/b1T<12>") getData("/b1T<11>") getData("/b1T<10>") getData("/b1T<9>") getData("/b1T<8>") getData("/b1T<7>") getData("/b1T<6>") getData("/b1T<5>") getData("/b1T<4>") getData("/b1T<3>") getData("/b1T<2>") getData("/b1T<1>") getData("/b1T<0>") getData("/HitT") getData("/ValidT") getData("/MissT") )
