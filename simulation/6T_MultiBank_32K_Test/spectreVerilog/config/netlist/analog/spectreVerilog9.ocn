simulator( 'spectreVerilog )
hostMode( 'distributed )
design(	 "/net/bull/apps/Cadence/simulation/6T_MultiBank_32K_Test/spectreVerilog/config/netlist/analog/netlist")
resultsDir( "/net/bull/apps/Cadence/simulation/6T_MultiBank_32K_Test/spectreVerilog/config/distributed/job018" )
modelFile(
    '("/software/cadence/ncsu-FreePDK15/hspice_16nm_hp.include" "")
)
analysis('tran ?stop "10n"  ?errpreset "conservative"  )
desVar(	  "vcc" "vdd"	)
desVar(	  "vdd" .500	)
envOption(
	'mspSetupNetlistSimPrecisionUnit  "ps"
	'mspSetupNetlistSimTimeUnit  "ps"
	'mspSetupNetlistSwitchRC  t
	'userCmdLineOption  "+multithread"
	'analysisOrder  list("tran")
)
option(	'temp  "30.0"
)
saveOption( ?simOutputFormat "psfxl" )
save( 'i "/V0/MINUS" )
converge( 'ic "/I21/I0/I0/I0/I0/I0/I7/I3/Q0" "0" )
converge( 'ic "/I21/I1/I0/I0/I0/I0/I7/I3/Q0" "0" )
converge( 'ic "/I21/I1/I0/I0/I0/I0/I7/I3/Q1" "vdd" )
converge( 'ic "/I21/I0/I0/I0/I0/I0/I7/I3/Q1" "vdd" )
converge( 'ic "/ReadEnT" "0" )
converge( 'ic "/R_AddressT<0>" "0" )
converge( 'ic "/R_AddressT<1>" "0" )
converge( 'ic "/R_AddressT<2>" "0" )
converge( 'ic "/R_AddressT<3>" "0" )
converge( 'ic "/R_AddressT<4>" "0" )
converge( 'ic "/R_AddressT<5>" "0" )
converge( 'ic "/R_AddressT<6>" "0" )
converge( 'ic "/R_AddressT<7>" "0" )
converge( 'ic "/R_AddressT<8>" "0" )
converge( 'ic "/R_AddressT<9>" "0" )
converge( 'ic "/R_AddressT<10>" "0" )
converge( 'ic "/R_AddressT<11>" "0" )
converge( 'ic "/W_AddressT<0>" "0" )
converge( 'ic "/W_AddressT<1>" "0" )
converge( 'ic "/W_AddressT<2>" "0" )
converge( 'ic "/W_AddressT<3>" "0" )
converge( 'ic "/W_AddressT<4>" "0" )
converge( 'ic "/W_AddressT<5>" "0" )
converge( 'ic "/W_AddressT<6>" "0" )
converge( 'ic "/W_AddressT<7>" "0" )
converge( 'ic "/W_AddressT<8>" "0" )
converge( 'ic "/W_AddressT<9>" "0" )
converge( 'ic "/W_AddressT<10>" "0" )
converge( 'ic "/W_AddressT<11>" "0" )
converge( 'ic "/WriteEnT" "0" )
converge( 'ic "/WDataT<0>" "0" )
converge( 'ic "/WDataT<1>" "0" )
converge( 'ic "/WDataT<2>" "0" )
converge( 'ic "/WDataT<3>" "0" )
converge( 'ic "/WDataT<4>" "0" )
converge( 'ic "/WDataT<5>" "0" )
converge( 'ic "/WDataT<6>" "0" )
converge( 'ic "/WDataT<7>" "0" )
converge( 'ic "/WDataT<8>" "0" )
converge( 'ic "/WDataT<9>" "0" )
converge( 'ic "/WDataT<10>" "0" )
converge( 'ic "/WDataT<11>" "0" )
converge( 'ic "/WDataT<12>" "0" )
converge( 'ic "/WDataT<13>" "0" )
converge( 'ic "/WDataT<14>" "0" )
converge( 'ic "/WDataT<15>" "0" )
converge( 'ic "/WDataT<16>" "0" )
converge( 'ic "/WDataT<17>" "0" )
converge( 'ic "/WDataT<18>" "0" )
converge( 'ic "/WDataT<19>" "0" )
converge( 'ic "/WDataT<20>" "0" )
converge( 'ic "/WDataT<21>" "0" )
converge( 'ic "/WDataT<22>" "0" )
converge( 'ic "/WDataT<23>" "0" )
converge( 'ic "/WDataT<24>" "0" )
converge( 'ic "/WDataT<25>" "0" )
converge( 'ic "/WDataT<26>" "0" )
converge( 'ic "/WDataT<27>" "0" )
converge( 'ic "/WDataT<28>" "0" )
converge( 'ic "/WDataT<29>" "0" )
converge( 'ic "/WDataT<30>" "0" )
converge( 'ic "/WDataT<31>" "0" )
converge( 'ic "/WDataT<32>" "0" )
converge( 'ic "/WDataT<33>" "0" )
converge( 'ic "/WDataT<34>" "0" )
converge( 'ic "/WDataT<35>" "0" )
converge( 'ic "/WDataT<36>" "0" )
converge( 'ic "/WDataT<37>" "0" )
converge( 'ic "/WDataT<38>" "0" )
converge( 'ic "/WDataT<39>" "0" )
converge( 'ic "/WDataT<40>" "0" )
converge( 'ic "/WDataT<41>" "0" )
converge( 'ic "/WDataT<42>" "0" )
converge( 'ic "/WDataT<43>" "0" )
converge( 'ic "/WDataT<44>" "0" )
converge( 'ic "/WDataT<45>" "0" )
converge( 'ic "/WDataT<46>" "0" )
converge( 'ic "/WDataT<47>" "0" )
converge( 'ic "/WDataT<48>" "0" )
converge( 'ic "/WDataT<49>" "0" )
converge( 'ic "/WDataT<50>" "0" )
converge( 'ic "/WDataT<51>" "0" )
converge( 'ic "/WDataT<52>" "0" )
converge( 'ic "/WDataT<53>" "0" )
converge( 'ic "/WDataT<54>" "0" )
converge( 'ic "/WDataT<55>" "0" )
converge( 'ic "/WDataT<56>" "0" )
converge( 'ic "/WDataT<57>" "0" )
converge( 'ic "/WDataT<58>" "0" )
converge( 'ic "/WDataT<59>" "0" )
converge( 'ic "/WDataT<60>" "0" )
converge( 'ic "/WDataT<61>" "0" )
converge( 'ic "/WDataT<62>" "0" )
converge( 'ic "/WDataT<63>" "0" )
converge( 'ic "/~ReadEn" "vdd" )
converge( 'ic "/~R_Address<11:0>" "vdd" )
converge( 'ic "/~WriteEn" "vdd" )
converge( 'ic "/~W_Address<11:0>" "vdd" )
converge( 'ic "/~WData<63:0>" "vdd" )
temp( 30.0 )
run( ?jobName "job" ?mail "rstdenis@ucdavis.edu" )
selectResult( 'tran )
plot(getData("/ReadEn") getData("/R_Address<11:0>") getData("/W_Address<11:0>") getData("/WriteEn") getData("/ReadAck") getData("/WriteAck") getData("/RAckT") getData("/WAckT") getData("/R_AddressT<11>") getData("/R_AddressT<10>") getData("/R_AddressT<9>") getData("/R_AddressT<8>") getData("/R_AddressT<7>") getData("/R_AddressT<6>") getData("/R_AddressT<5>") getData("/R_AddressT<4>") getData("/R_AddressT<3>") getData("/R_AddressT<2>") getData("/R_AddressT<1>") getData("/R_AddressT<0>") getData("/ReadEnT") getData("/W_AddressT<11>") getData("/W_AddressT<10>") getData("/W_AddressT<9>") getData("/W_AddressT<8>") getData("/W_AddressT<7>") getData("/W_AddressT<6>") getData("/W_AddressT<5>") getData("/W_AddressT<4>") getData("/W_AddressT<3>") getData("/W_AddressT<2>") getData("/W_AddressT<1>") getData("/W_AddressT<0>") getData("/WriteEnT") getData("/WDataAckT<7>") getData("/WDataAckT<6>") getData("/WDataAckT<5>") getData("/WDataAckT<4>") getData("/WDataAckT<3>") getData("/WDataAckT<2>") getData("/WDataAckT<1>") getData("/WDataAckT<0>") getData("/V0/MINUS") getData("/I21/WdBank0<31>") getData("/I21/WdBank0<30>") getData("/I21/WdBank0<29>") getData("/I21/WdBank0<28>") getData("/I21/WdBank0<27>") getData("/I21/WdBank0<26>") getData("/I21/WdBank0<25>") getData("/I21/WdBank0<24>") getData("/I21/WdBank0<23>") getData("/I21/WdBank0<22>") getData("/I21/WdBank0<21>") getData("/I21/WdBank0<20>") getData("/I21/WdBank0<19>") getData("/I21/WdBank0<18>") getData("/I21/WdBank0<17>") getData("/I21/WdBank0<16>") getData("/I21/WdBank0<15>") getData("/I21/WdBank0<14>") getData("/I21/WdBank0<13>") getData("/I21/WdBank0<12>") getData("/I21/WdBank0<11>") getData("/I21/WdBank0<10>") getData("/I21/WdBank0<9>") getData("/I21/WdBank0<8>") getData("/I21/WdBank0<7>") getData("/I21/WdBank0<6>") getData("/I21/WdBank0<5>") getData("/I21/WdBank0<4>") getData("/I21/WdBank0<3>") getData("/I21/WdBank0<2>") getData("/I21/WdBank0<1>") getData("/I21/WdBank0<0>") getData("/I21/Bank0WAck<7>") getData("/I21/Bank0WAck<6>") getData("/I21/Bank0WAck<5>") getData("/I21/Bank0WAck<4>") getData("/I21/Bank0WAck<3>") getData("/I21/Bank0WAck<2>") getData("/I21/Bank0WAck<1>") getData("/I21/Bank0WAck<0>") getData("/I21/WdBank1<31>") getData("/I21/WdBank1<30>") getData("/I21/WdBank1<29>") getData("/I21/WdBank1<28>") getData("/I21/WdBank1<27>") getData("/I21/WdBank1<26>") getData("/I21/WdBank1<25>") getData("/I21/WdBank1<24>") getData("/I21/WdBank1<23>") getData("/I21/WdBank1<22>") getData("/I21/WdBank1<21>") getData("/I21/WdBank1<20>") getData("/I21/WdBank1<19>") getData("/I21/WdBank1<18>") getData("/I21/WdBank1<17>") getData("/I21/WdBank1<16>") getData("/I21/WdBank1<15>") getData("/I21/WdBank1<14>") getData("/I21/WdBank1<13>") getData("/I21/WdBank1<12>") getData("/I21/WdBank1<11>") getData("/I21/WdBank1<10>") getData("/I21/WdBank1<9>") getData("/I21/WdBank1<8>") getData("/I21/WdBank1<7>") getData("/I21/WdBank1<6>") getData("/I21/WdBank1<5>") getData("/I21/WdBank1<4>") getData("/I21/WdBank1<3>") getData("/I21/WdBank1<2>") getData("/I21/WdBank1<1>") getData("/I21/WdBank1<0>") getData("/I21/Bank1WAck<7>") getData("/I21/Bank1WAck<6>") getData("/I21/Bank1WAck<5>") getData("/I21/Bank1WAck<4>") getData("/I21/Bank1WAck<3>") getData("/I21/Bank1WAck<2>") getData("/I21/Bank1WAck<1>") getData("/I21/Bank1WAck<0>") getData("/I21/WdBank2<31>") getData("/I21/WdBank2<30>") getData("/I21/WdBank2<29>") getData("/I21/WdBank2<28>") getData("/I21/WdBank2<27>") getData("/I21/WdBank2<26>") getData("/I21/WdBank2<25>") getData("/I21/WdBank2<24>") getData("/I21/WdBank2<23>") getData("/I21/WdBank2<22>") getData("/I21/WdBank2<21>") getData("/I21/WdBank2<20>") getData("/I21/WdBank2<19>") getData("/I21/WdBank2<18>") getData("/I21/WdBank2<17>") getData("/I21/WdBank2<16>") getData("/I21/WdBank2<15>") getData("/I21/WdBank2<14>") getData("/I21/WdBank2<13>") getData("/I21/WdBank2<12>") getData("/I21/WdBank2<11>") getData("/I21/WdBank2<10>") getData("/I21/WdBank2<9>") getData("/I21/WdBank2<8>") getData("/I21/WdBank2<7>") getData("/I21/WdBank2<6>") getData("/I21/WdBank2<5>") getData("/I21/WdBank2<4>") getData("/I21/WdBank2<3>") getData("/I21/WdBank2<2>") getData("/I21/WdBank2<1>") getData("/I21/WdBank2<0>") getData("/I21/Bank2WAck<7>") getData("/I21/Bank2WAck<6>") getData("/I21/Bank2WAck<5>") getData("/I21/Bank2WAck<4>") getData("/I21/Bank2WAck<3>") getData("/I21/Bank2WAck<2>") getData("/I21/Bank2WAck<1>") getData("/I21/Bank2WAck<0>") getData("/I21/WdBank3<31>") getData("/I21/WdBank3<30>") getData("/I21/WdBank3<29>") getData("/I21/WdBank3<28>") getData("/I21/WdBank3<27>") getData("/I21/WdBank3<26>") getData("/I21/WdBank3<25>") getData("/I21/WdBank3<24>") getData("/I21/WdBank3<23>") getData("/I21/WdBank3<22>") getData("/I21/WdBank3<21>") getData("/I21/WdBank3<20>") getData("/I21/WdBank3<19>") getData("/I21/WdBank3<18>") getData("/I21/WdBank3<17>") getData("/I21/WdBank3<16>") getData("/I21/WdBank3<15>") getData("/I21/WdBank3<14>") getData("/I21/WdBank3<13>") getData("/I21/WdBank3<12>") getData("/I21/WdBank3<11>") getData("/I21/WdBank3<10>") getData("/I21/WdBank3<9>") getData("/I21/WdBank3<8>") getData("/I21/WdBank3<7>") getData("/I21/WdBank3<6>") getData("/I21/WdBank3<5>") getData("/I21/WdBank3<4>") getData("/I21/WdBank3<3>") getData("/I21/WdBank3<2>") getData("/I21/WdBank3<1>") getData("/I21/WdBank3<0>") getData("/I21/Bank3WAck<7>") getData("/I21/Bank3WAck<6>") getData("/I21/Bank3WAck<5>") getData("/I21/Bank3WAck<4>") getData("/I21/Bank3WAck<3>") getData("/I21/Bank3WAck<2>") getData("/I21/Bank3WAck<1>") getData("/I21/Bank3WAck<0>") getData("/I21/net0201") getData("/I21/net0205") getData("/I21/net018") getData("/I21/net017") getData("/I21/net022") getData("/I21/net021") getData("/I21/net020") getData("/I21/net019") getData("/I21/RdBank0<31>") getData("/I21/RdBank0<30>") getData("/I21/RdBank0<29>") getData("/I21/RdBank0<28>") getData("/I21/RdBank0<27>") getData("/I21/RdBank0<26>") getData("/I21/RdBank0<25>") getData("/I21/RdBank0<24>") getData("/I21/RdBank0<23>") getData("/I21/RdBank0<22>") getData("/I21/RdBank0<21>") getData("/I21/RdBank0<20>") getData("/I21/RdBank0<19>") getData("/I21/RdBank0<18>") getData("/I21/RdBank0<17>") getData("/I21/RdBank0<16>") getData("/I21/RdBank0<15>") getData("/I21/RdBank0<14>") getData("/I21/RdBank0<13>") getData("/I21/RdBank0<12>") getData("/I21/RdBank0<11>") getData("/I21/RdBank0<10>") getData("/I21/RdBank0<9>") getData("/I21/RdBank0<8>") getData("/I21/RdBank0<7>") getData("/I21/RdBank0<6>") getData("/I21/RdBank0<5>") getData("/I21/RdBank0<4>") getData("/I21/RdBank0<3>") getData("/I21/RdBank0<2>") getData("/I21/RdBank0<1>") getData("/I21/RdBank0<0>") getData("/I21/RdBank0Ack<7>") getData("/I21/RdBank0Ack<6>") getData("/I21/RdBank0Ack<5>") getData("/I21/RdBank0Ack<4>") getData("/I21/RdBank0Ack<3>") getData("/I21/RdBank0Ack<2>") getData("/I21/RdBank0Ack<1>") getData("/I21/RdBank0Ack<0>") getData("/I21/RdBank1<31>") getData("/I21/RdBank1<30>") getData("/I21/RdBank1<29>") getData("/I21/RdBank1<28>") getData("/I21/RdBank1<27>") getData("/I21/RdBank1<26>") getData("/I21/RdBank1<25>") getData("/I21/RdBank1<24>") getData("/I21/RdBank1<23>") getData("/I21/RdBank1<22>") getData("/I21/RdBank1<21>") getData("/I21/RdBank1<20>") getData("/I21/RdBank1<19>") getData("/I21/RdBank1<18>") getData("/I21/RdBank1<17>") getData("/I21/RdBank1<16>") getData("/I21/RdBank1<15>") getData("/I21/RdBank1<14>") getData("/I21/RdBank1<13>") getData("/I21/RdBank1<12>") getData("/I21/RdBank1<11>") getData("/I21/RdBank1<10>") getData("/I21/RdBank1<9>") getData("/I21/RdBank1<8>") getData("/I21/RdBank1<7>") getData("/I21/RdBank1<6>") getData("/I21/RdBank1<5>") getData("/I21/RdBank1<4>") getData("/I21/RdBank1<3>") getData("/I21/RdBank1<2>") getData("/I21/RdBank1<1>") getData("/I21/RdBank1<0>") getData("/I21/RdBank1Ack<7>") getData("/I21/RdBank1Ack<6>") getData("/I21/RdBank1Ack<5>") getData("/I21/RdBank1Ack<4>") getData("/I21/RdBank1Ack<3>") getData("/I21/RdBank1Ack<2>") getData("/I21/RdBank1Ack<1>") getData("/I21/RdBank1Ack<0>") getData("/Data1<63:0>") getData("/WDataAck<31:0>") getData("/RData<63:0>") getData("/RDataT<63>") getData("/RDataT<62>") getData("/RDataT<61>") getData("/RDataT<60>") getData("/RDataT<59>") getData("/RDataT<58>") getData("/RDataT<57>") getData("/RDataT<56>") getData("/RDataT<55>") getData("/RDataT<54>") getData("/RDataT<53>") getData("/RDataT<52>") getData("/RDataT<51>") getData("/RDataT<50>") getData("/RDataT<49>") getData("/RDataT<48>") getData("/RDataT<47>") getData("/RDataT<46>") getData("/RDataT<45>") getData("/RDataT<44>") getData("/RDataT<43>") getData("/RDataT<42>") getData("/RDataT<41>") getData("/RDataT<40>") getData("/RDataT<39>") getData("/RDataT<38>") getData("/RDataT<37>") getData("/RDataT<36>") getData("/RDataT<35>") getData("/RDataT<34>") getData("/RDataT<33>") getData("/RDataT<32>") getData("/RDataT<31>") getData("/RDataT<30>") getData("/RDataT<29>") getData("/RDataT<28>") getData("/RDataT<27>") getData("/RDataT<26>") getData("/RDataT<25>") getData("/RDataT<24>") getData("/RDataT<23>") getData("/RDataT<22>") getData("/RDataT<21>") getData("/RDataT<20>") getData("/RDataT<19>") getData("/RDataT<18>") getData("/RDataT<17>") getData("/RDataT<16>") getData("/WDataT<63>") getData("/WDataT<62>") getData("/WDataT<61>") getData("/WDataT<60>") getData("/WDataT<59>") getData("/WDataT<58>") getData("/WDataT<57>") getData("/WDataT<56>") getData("/WDataT<55>") getData("/WDataT<54>") getData("/WDataT<53>") getData("/WDataT<52>") getData("/WDataT<51>") getData("/WDataT<50>") getData("/WDataT<49>") getData("/WDataT<48>") getData("/WDataT<47>") getData("/WDataT<46>") getData("/WDataT<45>") getData("/WDataT<44>") getData("/WDataT<43>") getData("/WDataT<42>") getData("/WDataT<41>") getData("/WDataT<40>") getData("/WDataT<39>") getData("/WDataT<38>") getData("/WDataT<37>") getData("/WDataT<36>") getData("/WDataT<35>") getData("/WDataT<34>") getData("/WDataT<33>") getData("/WDataT<32>") getData("/WDataT<31>") getData("/WDataT<30>") getData("/WDataT<29>") getData("/WDataT<28>") getData("/WDataT<27>") getData("/WDataT<26>") getData("/WDataT<25>") getData("/WDataT<24>") getData("/WDataT<23>") getData("/WDataT<22>") getData("/WDataT<21>") getData("/WDataT<20>") getData("/WDataT<19>") getData("/WDataT<18>") getData("/WDataT<17>") getData("/WDataT<16>") )
resultsDir( "/net/bull/apps/Cadence/simulation/6T_MultiBank_32K_Test/spectreVerilog/config/distributed/job019" )
modelFile(
    '("/software/cadence/ncsu-FreePDK15/hspice_16nm_hp.include" "")
)
desVar(	  "vdd" .675	)
run( ?jobName "job" ?mail "rstdenis@ucdavis.edu" )
selectResult( 'tran )
plot(getData("/ReadEn") getData("/R_Address<11:0>") getData("/W_Address<11:0>") getData("/WriteEn") getData("/ReadAck") getData("/WriteAck") getData("/RAckT") getData("/WAckT") getData("/R_AddressT<11>") getData("/R_AddressT<10>") getData("/R_AddressT<9>") getData("/R_AddressT<8>") getData("/R_AddressT<7>") getData("/R_AddressT<6>") getData("/R_AddressT<5>") getData("/R_AddressT<4>") getData("/R_AddressT<3>") getData("/R_AddressT<2>") getData("/R_AddressT<1>") getData("/R_AddressT<0>") getData("/ReadEnT") getData("/W_AddressT<11>") getData("/W_AddressT<10>") getData("/W_AddressT<9>") getData("/W_AddressT<8>") getData("/W_AddressT<7>") getData("/W_AddressT<6>") getData("/W_AddressT<5>") getData("/W_AddressT<4>") getData("/W_AddressT<3>") getData("/W_AddressT<2>") getData("/W_AddressT<1>") getData("/W_AddressT<0>") getData("/WriteEnT") getData("/WDataAckT<7>") getData("/WDataAckT<6>") getData("/WDataAckT<5>") getData("/WDataAckT<4>") getData("/WDataAckT<3>") getData("/WDataAckT<2>") getData("/WDataAckT<1>") getData("/WDataAckT<0>") getData("/V0/MINUS") getData("/I21/WdBank0<31>") getData("/I21/WdBank0<30>") getData("/I21/WdBank0<29>") getData("/I21/WdBank0<28>") getData("/I21/WdBank0<27>") getData("/I21/WdBank0<26>") getData("/I21/WdBank0<25>") getData("/I21/WdBank0<24>") getData("/I21/WdBank0<23>") getData("/I21/WdBank0<22>") getData("/I21/WdBank0<21>") getData("/I21/WdBank0<20>") getData("/I21/WdBank0<19>") getData("/I21/WdBank0<18>") getData("/I21/WdBank0<17>") getData("/I21/WdBank0<16>") getData("/I21/WdBank0<15>") getData("/I21/WdBank0<14>") getData("/I21/WdBank0<13>") getData("/I21/WdBank0<12>") getData("/I21/WdBank0<11>") getData("/I21/WdBank0<10>") getData("/I21/WdBank0<9>") getData("/I21/WdBank0<8>") getData("/I21/WdBank0<7>") getData("/I21/WdBank0<6>") getData("/I21/WdBank0<5>") getData("/I21/WdBank0<4>") getData("/I21/WdBank0<3>") getData("/I21/WdBank0<2>") getData("/I21/WdBank0<1>") getData("/I21/WdBank0<0>") getData("/I21/Bank0WAck<7>") getData("/I21/Bank0WAck<6>") getData("/I21/Bank0WAck<5>") getData("/I21/Bank0WAck<4>") getData("/I21/Bank0WAck<3>") getData("/I21/Bank0WAck<2>") getData("/I21/Bank0WAck<1>") getData("/I21/Bank0WAck<0>") getData("/I21/WdBank1<31>") getData("/I21/WdBank1<30>") getData("/I21/WdBank1<29>") getData("/I21/WdBank1<28>") getData("/I21/WdBank1<27>") getData("/I21/WdBank1<26>") getData("/I21/WdBank1<25>") getData("/I21/WdBank1<24>") getData("/I21/WdBank1<23>") getData("/I21/WdBank1<22>") getData("/I21/WdBank1<21>") getData("/I21/WdBank1<20>") getData("/I21/WdBank1<19>") getData("/I21/WdBank1<18>") getData("/I21/WdBank1<17>") getData("/I21/WdBank1<16>") getData("/I21/WdBank1<15>") getData("/I21/WdBank1<14>") getData("/I21/WdBank1<13>") getData("/I21/WdBank1<12>") getData("/I21/WdBank1<11>") getData("/I21/WdBank1<10>") getData("/I21/WdBank1<9>") getData("/I21/WdBank1<8>") getData("/I21/WdBank1<7>") getData("/I21/WdBank1<6>") getData("/I21/WdBank1<5>") getData("/I21/WdBank1<4>") getData("/I21/WdBank1<3>") getData("/I21/WdBank1<2>") getData("/I21/WdBank1<1>") getData("/I21/WdBank1<0>") getData("/I21/Bank1WAck<7>") getData("/I21/Bank1WAck<6>") getData("/I21/Bank1WAck<5>") getData("/I21/Bank1WAck<4>") getData("/I21/Bank1WAck<3>") getData("/I21/Bank1WAck<2>") getData("/I21/Bank1WAck<1>") getData("/I21/Bank1WAck<0>") getData("/I21/WdBank2<31>") getData("/I21/WdBank2<30>") getData("/I21/WdBank2<29>") getData("/I21/WdBank2<28>") getData("/I21/WdBank2<27>") getData("/I21/WdBank2<26>") getData("/I21/WdBank2<25>") getData("/I21/WdBank2<24>") getData("/I21/WdBank2<23>") getData("/I21/WdBank2<22>") getData("/I21/WdBank2<21>") getData("/I21/WdBank2<20>") getData("/I21/WdBank2<19>") getData("/I21/WdBank2<18>") getData("/I21/WdBank2<17>") getData("/I21/WdBank2<16>") getData("/I21/WdBank2<15>") getData("/I21/WdBank2<14>") getData("/I21/WdBank2<13>") getData("/I21/WdBank2<12>") getData("/I21/WdBank2<11>") getData("/I21/WdBank2<10>") getData("/I21/WdBank2<9>") getData("/I21/WdBank2<8>") getData("/I21/WdBank2<7>") getData("/I21/WdBank2<6>") getData("/I21/WdBank2<5>") getData("/I21/WdBank2<4>") getData("/I21/WdBank2<3>") getData("/I21/WdBank2<2>") getData("/I21/WdBank2<1>") getData("/I21/WdBank2<0>") getData("/I21/Bank2WAck<7>") getData("/I21/Bank2WAck<6>") getData("/I21/Bank2WAck<5>") getData("/I21/Bank2WAck<4>") getData("/I21/Bank2WAck<3>") getData("/I21/Bank2WAck<2>") getData("/I21/Bank2WAck<1>") getData("/I21/Bank2WAck<0>") getData("/I21/WdBank3<31>") getData("/I21/WdBank3<30>") getData("/I21/WdBank3<29>") getData("/I21/WdBank3<28>") getData("/I21/WdBank3<27>") getData("/I21/WdBank3<26>") getData("/I21/WdBank3<25>") getData("/I21/WdBank3<24>") getData("/I21/WdBank3<23>") getData("/I21/WdBank3<22>") getData("/I21/WdBank3<21>") getData("/I21/WdBank3<20>") getData("/I21/WdBank3<19>") getData("/I21/WdBank3<18>") getData("/I21/WdBank3<17>") getData("/I21/WdBank3<16>") getData("/I21/WdBank3<15>") getData("/I21/WdBank3<14>") getData("/I21/WdBank3<13>") getData("/I21/WdBank3<12>") getData("/I21/WdBank3<11>") getData("/I21/WdBank3<10>") getData("/I21/WdBank3<9>") getData("/I21/WdBank3<8>") getData("/I21/WdBank3<7>") getData("/I21/WdBank3<6>") getData("/I21/WdBank3<5>") getData("/I21/WdBank3<4>") getData("/I21/WdBank3<3>") getData("/I21/WdBank3<2>") getData("/I21/WdBank3<1>") getData("/I21/WdBank3<0>") getData("/I21/Bank3WAck<7>") getData("/I21/Bank3WAck<6>") getData("/I21/Bank3WAck<5>") getData("/I21/Bank3WAck<4>") getData("/I21/Bank3WAck<3>") getData("/I21/Bank3WAck<2>") getData("/I21/Bank3WAck<1>") getData("/I21/Bank3WAck<0>") getData("/I21/net0201") getData("/I21/net0205") getData("/I21/net018") getData("/I21/net017") getData("/I21/net022") getData("/I21/net021") getData("/I21/net020") getData("/I21/net019") getData("/I21/RdBank0<31>") getData("/I21/RdBank0<30>") getData("/I21/RdBank0<29>") getData("/I21/RdBank0<28>") getData("/I21/RdBank0<27>") getData("/I21/RdBank0<26>") getData("/I21/RdBank0<25>") getData("/I21/RdBank0<24>") getData("/I21/RdBank0<23>") getData("/I21/RdBank0<22>") getData("/I21/RdBank0<21>") getData("/I21/RdBank0<20>") getData("/I21/RdBank0<19>") getData("/I21/RdBank0<18>") getData("/I21/RdBank0<17>") getData("/I21/RdBank0<16>") getData("/I21/RdBank0<15>") getData("/I21/RdBank0<14>") getData("/I21/RdBank0<13>") getData("/I21/RdBank0<12>") getData("/I21/RdBank0<11>") getData("/I21/RdBank0<10>") getData("/I21/RdBank0<9>") getData("/I21/RdBank0<8>") getData("/I21/RdBank0<7>") getData("/I21/RdBank0<6>") getData("/I21/RdBank0<5>") getData("/I21/RdBank0<4>") getData("/I21/RdBank0<3>") getData("/I21/RdBank0<2>") getData("/I21/RdBank0<1>") getData("/I21/RdBank0<0>") getData("/I21/RdBank0Ack<7>") getData("/I21/RdBank0Ack<6>") getData("/I21/RdBank0Ack<5>") getData("/I21/RdBank0Ack<4>") getData("/I21/RdBank0Ack<3>") getData("/I21/RdBank0Ack<2>") getData("/I21/RdBank0Ack<1>") getData("/I21/RdBank0Ack<0>") getData("/I21/RdBank1<31>") getData("/I21/RdBank1<30>") getData("/I21/RdBank1<29>") getData("/I21/RdBank1<28>") getData("/I21/RdBank1<27>") getData("/I21/RdBank1<26>") getData("/I21/RdBank1<25>") getData("/I21/RdBank1<24>") getData("/I21/RdBank1<23>") getData("/I21/RdBank1<22>") getData("/I21/RdBank1<21>") getData("/I21/RdBank1<20>") getData("/I21/RdBank1<19>") getData("/I21/RdBank1<18>") getData("/I21/RdBank1<17>") getData("/I21/RdBank1<16>") getData("/I21/RdBank1<15>") getData("/I21/RdBank1<14>") getData("/I21/RdBank1<13>") getData("/I21/RdBank1<12>") getData("/I21/RdBank1<11>") getData("/I21/RdBank1<10>") getData("/I21/RdBank1<9>") getData("/I21/RdBank1<8>") getData("/I21/RdBank1<7>") getData("/I21/RdBank1<6>") getData("/I21/RdBank1<5>") getData("/I21/RdBank1<4>") getData("/I21/RdBank1<3>") getData("/I21/RdBank1<2>") getData("/I21/RdBank1<1>") getData("/I21/RdBank1<0>") getData("/I21/RdBank1Ack<7>") getData("/I21/RdBank1Ack<6>") getData("/I21/RdBank1Ack<5>") getData("/I21/RdBank1Ack<4>") getData("/I21/RdBank1Ack<3>") getData("/I21/RdBank1Ack<2>") getData("/I21/RdBank1Ack<1>") getData("/I21/RdBank1Ack<0>") getData("/Data1<63:0>") getData("/WDataAck<31:0>") getData("/RData<63:0>") getData("/RDataT<63>") getData("/RDataT<62>") getData("/RDataT<61>") getData("/RDataT<60>") getData("/RDataT<59>") getData("/RDataT<58>") getData("/RDataT<57>") getData("/RDataT<56>") getData("/RDataT<55>") getData("/RDataT<54>") getData("/RDataT<53>") getData("/RDataT<52>") getData("/RDataT<51>") getData("/RDataT<50>") getData("/RDataT<49>") getData("/RDataT<48>") getData("/RDataT<47>") getData("/RDataT<46>") getData("/RDataT<45>") getData("/RDataT<44>") getData("/RDataT<43>") getData("/RDataT<42>") getData("/RDataT<41>") getData("/RDataT<40>") getData("/RDataT<39>") getData("/RDataT<38>") getData("/RDataT<37>") getData("/RDataT<36>") getData("/RDataT<35>") getData("/RDataT<34>") getData("/RDataT<33>") getData("/RDataT<32>") getData("/RDataT<31>") getData("/RDataT<30>") getData("/RDataT<29>") getData("/RDataT<28>") getData("/RDataT<27>") getData("/RDataT<26>") getData("/RDataT<25>") getData("/RDataT<24>") getData("/RDataT<23>") getData("/RDataT<22>") getData("/RDataT<21>") getData("/RDataT<20>") getData("/RDataT<19>") getData("/RDataT<18>") getData("/RDataT<17>") getData("/RDataT<16>") getData("/WDataT<63>") getData("/WDataT<62>") getData("/WDataT<61>") getData("/WDataT<60>") getData("/WDataT<59>") getData("/WDataT<58>") getData("/WDataT<57>") getData("/WDataT<56>") getData("/WDataT<55>") getData("/WDataT<54>") getData("/WDataT<53>") getData("/WDataT<52>") getData("/WDataT<51>") getData("/WDataT<50>") getData("/WDataT<49>") getData("/WDataT<48>") getData("/WDataT<47>") getData("/WDataT<46>") getData("/WDataT<45>") getData("/WDataT<44>") getData("/WDataT<43>") getData("/WDataT<42>") getData("/WDataT<41>") getData("/WDataT<40>") getData("/WDataT<39>") getData("/WDataT<38>") getData("/WDataT<37>") getData("/WDataT<36>") getData("/WDataT<35>") getData("/WDataT<34>") getData("/WDataT<33>") getData("/WDataT<32>") getData("/WDataT<31>") getData("/WDataT<30>") getData("/WDataT<29>") getData("/WDataT<28>") getData("/WDataT<27>") getData("/WDataT<26>") getData("/WDataT<25>") getData("/WDataT<24>") getData("/WDataT<23>") getData("/WDataT<22>") getData("/WDataT<21>") getData("/WDataT<20>") getData("/WDataT<19>") getData("/WDataT<18>") getData("/WDataT<17>") getData("/WDataT<16>") )
resultsDir( "/net/bull/apps/Cadence/simulation/6T_MultiBank_32K_Test/spectreVerilog/config/distributed/job020" )
modelFile(
    '("/software/cadence/ncsu-FreePDK15/hspice_16nm_hp.include" "")
)
desVar(	  "vdd" .850	)
run( ?jobName "job" ?mail "rstdenis@ucdavis.edu" )
selectResult( 'tran )
plot(getData("/ReadEn") getData("/R_Address<11:0>") getData("/W_Address<11:0>") getData("/WriteEn") getData("/ReadAck") getData("/WriteAck") getData("/RAckT") getData("/WAckT") getData("/R_AddressT<11>") getData("/R_AddressT<10>") getData("/R_AddressT<9>") getData("/R_AddressT<8>") getData("/R_AddressT<7>") getData("/R_AddressT<6>") getData("/R_AddressT<5>") getData("/R_AddressT<4>") getData("/R_AddressT<3>") getData("/R_AddressT<2>") getData("/R_AddressT<1>") getData("/R_AddressT<0>") getData("/ReadEnT") getData("/W_AddressT<11>") getData("/W_AddressT<10>") getData("/W_AddressT<9>") getData("/W_AddressT<8>") getData("/W_AddressT<7>") getData("/W_AddressT<6>") getData("/W_AddressT<5>") getData("/W_AddressT<4>") getData("/W_AddressT<3>") getData("/W_AddressT<2>") getData("/W_AddressT<1>") getData("/W_AddressT<0>") getData("/WriteEnT") getData("/WDataAckT<7>") getData("/WDataAckT<6>") getData("/WDataAckT<5>") getData("/WDataAckT<4>") getData("/WDataAckT<3>") getData("/WDataAckT<2>") getData("/WDataAckT<1>") getData("/WDataAckT<0>") getData("/V0/MINUS") getData("/I21/WdBank0<31>") getData("/I21/WdBank0<30>") getData("/I21/WdBank0<29>") getData("/I21/WdBank0<28>") getData("/I21/WdBank0<27>") getData("/I21/WdBank0<26>") getData("/I21/WdBank0<25>") getData("/I21/WdBank0<24>") getData("/I21/WdBank0<23>") getData("/I21/WdBank0<22>") getData("/I21/WdBank0<21>") getData("/I21/WdBank0<20>") getData("/I21/WdBank0<19>") getData("/I21/WdBank0<18>") getData("/I21/WdBank0<17>") getData("/I21/WdBank0<16>") getData("/I21/WdBank0<15>") getData("/I21/WdBank0<14>") getData("/I21/WdBank0<13>") getData("/I21/WdBank0<12>") getData("/I21/WdBank0<11>") getData("/I21/WdBank0<10>") getData("/I21/WdBank0<9>") getData("/I21/WdBank0<8>") getData("/I21/WdBank0<7>") getData("/I21/WdBank0<6>") getData("/I21/WdBank0<5>") getData("/I21/WdBank0<4>") getData("/I21/WdBank0<3>") getData("/I21/WdBank0<2>") getData("/I21/WdBank0<1>") getData("/I21/WdBank0<0>") getData("/I21/Bank0WAck<7>") getData("/I21/Bank0WAck<6>") getData("/I21/Bank0WAck<5>") getData("/I21/Bank0WAck<4>") getData("/I21/Bank0WAck<3>") getData("/I21/Bank0WAck<2>") getData("/I21/Bank0WAck<1>") getData("/I21/Bank0WAck<0>") getData("/I21/WdBank1<31>") getData("/I21/WdBank1<30>") getData("/I21/WdBank1<29>") getData("/I21/WdBank1<28>") getData("/I21/WdBank1<27>") getData("/I21/WdBank1<26>") getData("/I21/WdBank1<25>") getData("/I21/WdBank1<24>") getData("/I21/WdBank1<23>") getData("/I21/WdBank1<22>") getData("/I21/WdBank1<21>") getData("/I21/WdBank1<20>") getData("/I21/WdBank1<19>") getData("/I21/WdBank1<18>") getData("/I21/WdBank1<17>") getData("/I21/WdBank1<16>") getData("/I21/WdBank1<15>") getData("/I21/WdBank1<14>") getData("/I21/WdBank1<13>") getData("/I21/WdBank1<12>") getData("/I21/WdBank1<11>") getData("/I21/WdBank1<10>") getData("/I21/WdBank1<9>") getData("/I21/WdBank1<8>") getData("/I21/WdBank1<7>") getData("/I21/WdBank1<6>") getData("/I21/WdBank1<5>") getData("/I21/WdBank1<4>") getData("/I21/WdBank1<3>") getData("/I21/WdBank1<2>") getData("/I21/WdBank1<1>") getData("/I21/WdBank1<0>") getData("/I21/Bank1WAck<7>") getData("/I21/Bank1WAck<6>") getData("/I21/Bank1WAck<5>") getData("/I21/Bank1WAck<4>") getData("/I21/Bank1WAck<3>") getData("/I21/Bank1WAck<2>") getData("/I21/Bank1WAck<1>") getData("/I21/Bank1WAck<0>") getData("/I21/WdBank2<31>") getData("/I21/WdBank2<30>") getData("/I21/WdBank2<29>") getData("/I21/WdBank2<28>") getData("/I21/WdBank2<27>") getData("/I21/WdBank2<26>") getData("/I21/WdBank2<25>") getData("/I21/WdBank2<24>") getData("/I21/WdBank2<23>") getData("/I21/WdBank2<22>") getData("/I21/WdBank2<21>") getData("/I21/WdBank2<20>") getData("/I21/WdBank2<19>") getData("/I21/WdBank2<18>") getData("/I21/WdBank2<17>") getData("/I21/WdBank2<16>") getData("/I21/WdBank2<15>") getData("/I21/WdBank2<14>") getData("/I21/WdBank2<13>") getData("/I21/WdBank2<12>") getData("/I21/WdBank2<11>") getData("/I21/WdBank2<10>") getData("/I21/WdBank2<9>") getData("/I21/WdBank2<8>") getData("/I21/WdBank2<7>") getData("/I21/WdBank2<6>") getData("/I21/WdBank2<5>") getData("/I21/WdBank2<4>") getData("/I21/WdBank2<3>") getData("/I21/WdBank2<2>") getData("/I21/WdBank2<1>") getData("/I21/WdBank2<0>") getData("/I21/Bank2WAck<7>") getData("/I21/Bank2WAck<6>") getData("/I21/Bank2WAck<5>") getData("/I21/Bank2WAck<4>") getData("/I21/Bank2WAck<3>") getData("/I21/Bank2WAck<2>") getData("/I21/Bank2WAck<1>") getData("/I21/Bank2WAck<0>") getData("/I21/WdBank3<31>") getData("/I21/WdBank3<30>") getData("/I21/WdBank3<29>") getData("/I21/WdBank3<28>") getData("/I21/WdBank3<27>") getData("/I21/WdBank3<26>") getData("/I21/WdBank3<25>") getData("/I21/WdBank3<24>") getData("/I21/WdBank3<23>") getData("/I21/WdBank3<22>") getData("/I21/WdBank3<21>") getData("/I21/WdBank3<20>") getData("/I21/WdBank3<19>") getData("/I21/WdBank3<18>") getData("/I21/WdBank3<17>") getData("/I21/WdBank3<16>") getData("/I21/WdBank3<15>") getData("/I21/WdBank3<14>") getData("/I21/WdBank3<13>") getData("/I21/WdBank3<12>") getData("/I21/WdBank3<11>") getData("/I21/WdBank3<10>") getData("/I21/WdBank3<9>") getData("/I21/WdBank3<8>") getData("/I21/WdBank3<7>") getData("/I21/WdBank3<6>") getData("/I21/WdBank3<5>") getData("/I21/WdBank3<4>") getData("/I21/WdBank3<3>") getData("/I21/WdBank3<2>") getData("/I21/WdBank3<1>") getData("/I21/WdBank3<0>") getData("/I21/Bank3WAck<7>") getData("/I21/Bank3WAck<6>") getData("/I21/Bank3WAck<5>") getData("/I21/Bank3WAck<4>") getData("/I21/Bank3WAck<3>") getData("/I21/Bank3WAck<2>") getData("/I21/Bank3WAck<1>") getData("/I21/Bank3WAck<0>") getData("/I21/net0201") getData("/I21/net0205") getData("/I21/net018") getData("/I21/net017") getData("/I21/net022") getData("/I21/net021") getData("/I21/net020") getData("/I21/net019") getData("/I21/RdBank0<31>") getData("/I21/RdBank0<30>") getData("/I21/RdBank0<29>") getData("/I21/RdBank0<28>") getData("/I21/RdBank0<27>") getData("/I21/RdBank0<26>") getData("/I21/RdBank0<25>") getData("/I21/RdBank0<24>") getData("/I21/RdBank0<23>") getData("/I21/RdBank0<22>") getData("/I21/RdBank0<21>") getData("/I21/RdBank0<20>") getData("/I21/RdBank0<19>") getData("/I21/RdBank0<18>") getData("/I21/RdBank0<17>") getData("/I21/RdBank0<16>") getData("/I21/RdBank0<15>") getData("/I21/RdBank0<14>") getData("/I21/RdBank0<13>") getData("/I21/RdBank0<12>") getData("/I21/RdBank0<11>") getData("/I21/RdBank0<10>") getData("/I21/RdBank0<9>") getData("/I21/RdBank0<8>") getData("/I21/RdBank0<7>") getData("/I21/RdBank0<6>") getData("/I21/RdBank0<5>") getData("/I21/RdBank0<4>") getData("/I21/RdBank0<3>") getData("/I21/RdBank0<2>") getData("/I21/RdBank0<1>") getData("/I21/RdBank0<0>") getData("/I21/RdBank0Ack<7>") getData("/I21/RdBank0Ack<6>") getData("/I21/RdBank0Ack<5>") getData("/I21/RdBank0Ack<4>") getData("/I21/RdBank0Ack<3>") getData("/I21/RdBank0Ack<2>") getData("/I21/RdBank0Ack<1>") getData("/I21/RdBank0Ack<0>") getData("/I21/RdBank1<31>") getData("/I21/RdBank1<30>") getData("/I21/RdBank1<29>") getData("/I21/RdBank1<28>") getData("/I21/RdBank1<27>") getData("/I21/RdBank1<26>") getData("/I21/RdBank1<25>") getData("/I21/RdBank1<24>") getData("/I21/RdBank1<23>") getData("/I21/RdBank1<22>") getData("/I21/RdBank1<21>") getData("/I21/RdBank1<20>") getData("/I21/RdBank1<19>") getData("/I21/RdBank1<18>") getData("/I21/RdBank1<17>") getData("/I21/RdBank1<16>") getData("/I21/RdBank1<15>") getData("/I21/RdBank1<14>") getData("/I21/RdBank1<13>") getData("/I21/RdBank1<12>") getData("/I21/RdBank1<11>") getData("/I21/RdBank1<10>") getData("/I21/RdBank1<9>") getData("/I21/RdBank1<8>") getData("/I21/RdBank1<7>") getData("/I21/RdBank1<6>") getData("/I21/RdBank1<5>") getData("/I21/RdBank1<4>") getData("/I21/RdBank1<3>") getData("/I21/RdBank1<2>") getData("/I21/RdBank1<1>") getData("/I21/RdBank1<0>") getData("/I21/RdBank1Ack<7>") getData("/I21/RdBank1Ack<6>") getData("/I21/RdBank1Ack<5>") getData("/I21/RdBank1Ack<4>") getData("/I21/RdBank1Ack<3>") getData("/I21/RdBank1Ack<2>") getData("/I21/RdBank1Ack<1>") getData("/I21/RdBank1Ack<0>") getData("/Data1<63:0>") getData("/WDataAck<31:0>") getData("/RData<63:0>") getData("/RDataT<63>") getData("/RDataT<62>") getData("/RDataT<61>") getData("/RDataT<60>") getData("/RDataT<59>") getData("/RDataT<58>") getData("/RDataT<57>") getData("/RDataT<56>") getData("/RDataT<55>") getData("/RDataT<54>") getData("/RDataT<53>") getData("/RDataT<52>") getData("/RDataT<51>") getData("/RDataT<50>") getData("/RDataT<49>") getData("/RDataT<48>") getData("/RDataT<47>") getData("/RDataT<46>") getData("/RDataT<45>") getData("/RDataT<44>") getData("/RDataT<43>") getData("/RDataT<42>") getData("/RDataT<41>") getData("/RDataT<40>") getData("/RDataT<39>") getData("/RDataT<38>") getData("/RDataT<37>") getData("/RDataT<36>") getData("/RDataT<35>") getData("/RDataT<34>") getData("/RDataT<33>") getData("/RDataT<32>") getData("/RDataT<31>") getData("/RDataT<30>") getData("/RDataT<29>") getData("/RDataT<28>") getData("/RDataT<27>") getData("/RDataT<26>") getData("/RDataT<25>") getData("/RDataT<24>") getData("/RDataT<23>") getData("/RDataT<22>") getData("/RDataT<21>") getData("/RDataT<20>") getData("/RDataT<19>") getData("/RDataT<18>") getData("/RDataT<17>") getData("/RDataT<16>") getData("/WDataT<63>") getData("/WDataT<62>") getData("/WDataT<61>") getData("/WDataT<60>") getData("/WDataT<59>") getData("/WDataT<58>") getData("/WDataT<57>") getData("/WDataT<56>") getData("/WDataT<55>") getData("/WDataT<54>") getData("/WDataT<53>") getData("/WDataT<52>") getData("/WDataT<51>") getData("/WDataT<50>") getData("/WDataT<49>") getData("/WDataT<48>") getData("/WDataT<47>") getData("/WDataT<46>") getData("/WDataT<45>") getData("/WDataT<44>") getData("/WDataT<43>") getData("/WDataT<42>") getData("/WDataT<41>") getData("/WDataT<40>") getData("/WDataT<39>") getData("/WDataT<38>") getData("/WDataT<37>") getData("/WDataT<36>") getData("/WDataT<35>") getData("/WDataT<34>") getData("/WDataT<33>") getData("/WDataT<32>") getData("/WDataT<31>") getData("/WDataT<30>") getData("/WDataT<29>") getData("/WDataT<28>") getData("/WDataT<27>") getData("/WDataT<26>") getData("/WDataT<25>") getData("/WDataT<24>") getData("/WDataT<23>") getData("/WDataT<22>") getData("/WDataT<21>") getData("/WDataT<20>") getData("/WDataT<19>") getData("/WDataT<18>") getData("/WDataT<17>") getData("/WDataT<16>") )
resultsDir( "/net/bull/apps/Cadence/simulation/6T_MultiBank_32K_Test/spectreVerilog/config/distributed/job021" )
modelFile(
    '("/software/cadence/ncsu-FreePDK15/hspice_16nm_hp.include" "")
)
desVar(	  "vdd" .500	)
option(	'temp  "57.5"
)
temp( 57.5 )
run( ?jobName "job" ?mail "rstdenis@ucdavis.edu" )
selectResult( 'tran )
plot(getData("/ReadEn") getData("/R_Address<11:0>") getData("/W_Address<11:0>") getData("/WriteEn") getData("/ReadAck") getData("/WriteAck") getData("/RAckT") getData("/WAckT") getData("/R_AddressT<11>") getData("/R_AddressT<10>") getData("/R_AddressT<9>") getData("/R_AddressT<8>") getData("/R_AddressT<7>") getData("/R_AddressT<6>") getData("/R_AddressT<5>") getData("/R_AddressT<4>") getData("/R_AddressT<3>") getData("/R_AddressT<2>") getData("/R_AddressT<1>") getData("/R_AddressT<0>") getData("/ReadEnT") getData("/W_AddressT<11>") getData("/W_AddressT<10>") getData("/W_AddressT<9>") getData("/W_AddressT<8>") getData("/W_AddressT<7>") getData("/W_AddressT<6>") getData("/W_AddressT<5>") getData("/W_AddressT<4>") getData("/W_AddressT<3>") getData("/W_AddressT<2>") getData("/W_AddressT<1>") getData("/W_AddressT<0>") getData("/WriteEnT") getData("/WDataAckT<7>") getData("/WDataAckT<6>") getData("/WDataAckT<5>") getData("/WDataAckT<4>") getData("/WDataAckT<3>") getData("/WDataAckT<2>") getData("/WDataAckT<1>") getData("/WDataAckT<0>") getData("/V0/MINUS") getData("/I21/WdBank0<31>") getData("/I21/WdBank0<30>") getData("/I21/WdBank0<29>") getData("/I21/WdBank0<28>") getData("/I21/WdBank0<27>") getData("/I21/WdBank0<26>") getData("/I21/WdBank0<25>") getData("/I21/WdBank0<24>") getData("/I21/WdBank0<23>") getData("/I21/WdBank0<22>") getData("/I21/WdBank0<21>") getData("/I21/WdBank0<20>") getData("/I21/WdBank0<19>") getData("/I21/WdBank0<18>") getData("/I21/WdBank0<17>") getData("/I21/WdBank0<16>") getData("/I21/WdBank0<15>") getData("/I21/WdBank0<14>") getData("/I21/WdBank0<13>") getData("/I21/WdBank0<12>") getData("/I21/WdBank0<11>") getData("/I21/WdBank0<10>") getData("/I21/WdBank0<9>") getData("/I21/WdBank0<8>") getData("/I21/WdBank0<7>") getData("/I21/WdBank0<6>") getData("/I21/WdBank0<5>") getData("/I21/WdBank0<4>") getData("/I21/WdBank0<3>") getData("/I21/WdBank0<2>") getData("/I21/WdBank0<1>") getData("/I21/WdBank0<0>") getData("/I21/Bank0WAck<7>") getData("/I21/Bank0WAck<6>") getData("/I21/Bank0WAck<5>") getData("/I21/Bank0WAck<4>") getData("/I21/Bank0WAck<3>") getData("/I21/Bank0WAck<2>") getData("/I21/Bank0WAck<1>") getData("/I21/Bank0WAck<0>") getData("/I21/WdBank1<31>") getData("/I21/WdBank1<30>") getData("/I21/WdBank1<29>") getData("/I21/WdBank1<28>") getData("/I21/WdBank1<27>") getData("/I21/WdBank1<26>") getData("/I21/WdBank1<25>") getData("/I21/WdBank1<24>") getData("/I21/WdBank1<23>") getData("/I21/WdBank1<22>") getData("/I21/WdBank1<21>") getData("/I21/WdBank1<20>") getData("/I21/WdBank1<19>") getData("/I21/WdBank1<18>") getData("/I21/WdBank1<17>") getData("/I21/WdBank1<16>") getData("/I21/WdBank1<15>") getData("/I21/WdBank1<14>") getData("/I21/WdBank1<13>") getData("/I21/WdBank1<12>") getData("/I21/WdBank1<11>") getData("/I21/WdBank1<10>") getData("/I21/WdBank1<9>") getData("/I21/WdBank1<8>") getData("/I21/WdBank1<7>") getData("/I21/WdBank1<6>") getData("/I21/WdBank1<5>") getData("/I21/WdBank1<4>") getData("/I21/WdBank1<3>") getData("/I21/WdBank1<2>") getData("/I21/WdBank1<1>") getData("/I21/WdBank1<0>") getData("/I21/Bank1WAck<7>") getData("/I21/Bank1WAck<6>") getData("/I21/Bank1WAck<5>") getData("/I21/Bank1WAck<4>") getData("/I21/Bank1WAck<3>") getData("/I21/Bank1WAck<2>") getData("/I21/Bank1WAck<1>") getData("/I21/Bank1WAck<0>") getData("/I21/WdBank2<31>") getData("/I21/WdBank2<30>") getData("/I21/WdBank2<29>") getData("/I21/WdBank2<28>") getData("/I21/WdBank2<27>") getData("/I21/WdBank2<26>") getData("/I21/WdBank2<25>") getData("/I21/WdBank2<24>") getData("/I21/WdBank2<23>") getData("/I21/WdBank2<22>") getData("/I21/WdBank2<21>") getData("/I21/WdBank2<20>") getData("/I21/WdBank2<19>") getData("/I21/WdBank2<18>") getData("/I21/WdBank2<17>") getData("/I21/WdBank2<16>") getData("/I21/WdBank2<15>") getData("/I21/WdBank2<14>") getData("/I21/WdBank2<13>") getData("/I21/WdBank2<12>") getData("/I21/WdBank2<11>") getData("/I21/WdBank2<10>") getData("/I21/WdBank2<9>") getData("/I21/WdBank2<8>") getData("/I21/WdBank2<7>") getData("/I21/WdBank2<6>") getData("/I21/WdBank2<5>") getData("/I21/WdBank2<4>") getData("/I21/WdBank2<3>") getData("/I21/WdBank2<2>") getData("/I21/WdBank2<1>") getData("/I21/WdBank2<0>") getData("/I21/Bank2WAck<7>") getData("/I21/Bank2WAck<6>") getData("/I21/Bank2WAck<5>") getData("/I21/Bank2WAck<4>") getData("/I21/Bank2WAck<3>") getData("/I21/Bank2WAck<2>") getData("/I21/Bank2WAck<1>") getData("/I21/Bank2WAck<0>") getData("/I21/WdBank3<31>") getData("/I21/WdBank3<30>") getData("/I21/WdBank3<29>") getData("/I21/WdBank3<28>") getData("/I21/WdBank3<27>") getData("/I21/WdBank3<26>") getData("/I21/WdBank3<25>") getData("/I21/WdBank3<24>") getData("/I21/WdBank3<23>") getData("/I21/WdBank3<22>") getData("/I21/WdBank3<21>") getData("/I21/WdBank3<20>") getData("/I21/WdBank3<19>") getData("/I21/WdBank3<18>") getData("/I21/WdBank3<17>") getData("/I21/WdBank3<16>") getData("/I21/WdBank3<15>") getData("/I21/WdBank3<14>") getData("/I21/WdBank3<13>") getData("/I21/WdBank3<12>") getData("/I21/WdBank3<11>") getData("/I21/WdBank3<10>") getData("/I21/WdBank3<9>") getData("/I21/WdBank3<8>") getData("/I21/WdBank3<7>") getData("/I21/WdBank3<6>") getData("/I21/WdBank3<5>") getData("/I21/WdBank3<4>") getData("/I21/WdBank3<3>") getData("/I21/WdBank3<2>") getData("/I21/WdBank3<1>") getData("/I21/WdBank3<0>") getData("/I21/Bank3WAck<7>") getData("/I21/Bank3WAck<6>") getData("/I21/Bank3WAck<5>") getData("/I21/Bank3WAck<4>") getData("/I21/Bank3WAck<3>") getData("/I21/Bank3WAck<2>") getData("/I21/Bank3WAck<1>") getData("/I21/Bank3WAck<0>") getData("/I21/net0201") getData("/I21/net0205") getData("/I21/net018") getData("/I21/net017") getData("/I21/net022") getData("/I21/net021") getData("/I21/net020") getData("/I21/net019") getData("/I21/RdBank0<31>") getData("/I21/RdBank0<30>") getData("/I21/RdBank0<29>") getData("/I21/RdBank0<28>") getData("/I21/RdBank0<27>") getData("/I21/RdBank0<26>") getData("/I21/RdBank0<25>") getData("/I21/RdBank0<24>") getData("/I21/RdBank0<23>") getData("/I21/RdBank0<22>") getData("/I21/RdBank0<21>") getData("/I21/RdBank0<20>") getData("/I21/RdBank0<19>") getData("/I21/RdBank0<18>") getData("/I21/RdBank0<17>") getData("/I21/RdBank0<16>") getData("/I21/RdBank0<15>") getData("/I21/RdBank0<14>") getData("/I21/RdBank0<13>") getData("/I21/RdBank0<12>") getData("/I21/RdBank0<11>") getData("/I21/RdBank0<10>") getData("/I21/RdBank0<9>") getData("/I21/RdBank0<8>") getData("/I21/RdBank0<7>") getData("/I21/RdBank0<6>") getData("/I21/RdBank0<5>") getData("/I21/RdBank0<4>") getData("/I21/RdBank0<3>") getData("/I21/RdBank0<2>") getData("/I21/RdBank0<1>") getData("/I21/RdBank0<0>") getData("/I21/RdBank0Ack<7>") getData("/I21/RdBank0Ack<6>") getData("/I21/RdBank0Ack<5>") getData("/I21/RdBank0Ack<4>") getData("/I21/RdBank0Ack<3>") getData("/I21/RdBank0Ack<2>") getData("/I21/RdBank0Ack<1>") getData("/I21/RdBank0Ack<0>") getData("/I21/RdBank1<31>") getData("/I21/RdBank1<30>") getData("/I21/RdBank1<29>") getData("/I21/RdBank1<28>") getData("/I21/RdBank1<27>") getData("/I21/RdBank1<26>") getData("/I21/RdBank1<25>") getData("/I21/RdBank1<24>") getData("/I21/RdBank1<23>") getData("/I21/RdBank1<22>") getData("/I21/RdBank1<21>") getData("/I21/RdBank1<20>") getData("/I21/RdBank1<19>") getData("/I21/RdBank1<18>") getData("/I21/RdBank1<17>") getData("/I21/RdBank1<16>") getData("/I21/RdBank1<15>") getData("/I21/RdBank1<14>") getData("/I21/RdBank1<13>") getData("/I21/RdBank1<12>") getData("/I21/RdBank1<11>") getData("/I21/RdBank1<10>") getData("/I21/RdBank1<9>") getData("/I21/RdBank1<8>") getData("/I21/RdBank1<7>") getData("/I21/RdBank1<6>") getData("/I21/RdBank1<5>") getData("/I21/RdBank1<4>") getData("/I21/RdBank1<3>") getData("/I21/RdBank1<2>") getData("/I21/RdBank1<1>") getData("/I21/RdBank1<0>") getData("/I21/RdBank1Ack<7>") getData("/I21/RdBank1Ack<6>") getData("/I21/RdBank1Ack<5>") getData("/I21/RdBank1Ack<4>") getData("/I21/RdBank1Ack<3>") getData("/I21/RdBank1Ack<2>") getData("/I21/RdBank1Ack<1>") getData("/I21/RdBank1Ack<0>") getData("/Data1<63:0>") getData("/WDataAck<31:0>") getData("/RData<63:0>") getData("/RDataT<63>") getData("/RDataT<62>") getData("/RDataT<61>") getData("/RDataT<60>") getData("/RDataT<59>") getData("/RDataT<58>") getData("/RDataT<57>") getData("/RDataT<56>") getData("/RDataT<55>") getData("/RDataT<54>") getData("/RDataT<53>") getData("/RDataT<52>") getData("/RDataT<51>") getData("/RDataT<50>") getData("/RDataT<49>") getData("/RDataT<48>") getData("/RDataT<47>") getData("/RDataT<46>") getData("/RDataT<45>") getData("/RDataT<44>") getData("/RDataT<43>") getData("/RDataT<42>") getData("/RDataT<41>") getData("/RDataT<40>") getData("/RDataT<39>") getData("/RDataT<38>") getData("/RDataT<37>") getData("/RDataT<36>") getData("/RDataT<35>") getData("/RDataT<34>") getData("/RDataT<33>") getData("/RDataT<32>") getData("/RDataT<31>") getData("/RDataT<30>") getData("/RDataT<29>") getData("/RDataT<28>") getData("/RDataT<27>") getData("/RDataT<26>") getData("/RDataT<25>") getData("/RDataT<24>") getData("/RDataT<23>") getData("/RDataT<22>") getData("/RDataT<21>") getData("/RDataT<20>") getData("/RDataT<19>") getData("/RDataT<18>") getData("/RDataT<17>") getData("/RDataT<16>") getData("/WDataT<63>") getData("/WDataT<62>") getData("/WDataT<61>") getData("/WDataT<60>") getData("/WDataT<59>") getData("/WDataT<58>") getData("/WDataT<57>") getData("/WDataT<56>") getData("/WDataT<55>") getData("/WDataT<54>") getData("/WDataT<53>") getData("/WDataT<52>") getData("/WDataT<51>") getData("/WDataT<50>") getData("/WDataT<49>") getData("/WDataT<48>") getData("/WDataT<47>") getData("/WDataT<46>") getData("/WDataT<45>") getData("/WDataT<44>") getData("/WDataT<43>") getData("/WDataT<42>") getData("/WDataT<41>") getData("/WDataT<40>") getData("/WDataT<39>") getData("/WDataT<38>") getData("/WDataT<37>") getData("/WDataT<36>") getData("/WDataT<35>") getData("/WDataT<34>") getData("/WDataT<33>") getData("/WDataT<32>") getData("/WDataT<31>") getData("/WDataT<30>") getData("/WDataT<29>") getData("/WDataT<28>") getData("/WDataT<27>") getData("/WDataT<26>") getData("/WDataT<25>") getData("/WDataT<24>") getData("/WDataT<23>") getData("/WDataT<22>") getData("/WDataT<21>") getData("/WDataT<20>") getData("/WDataT<19>") getData("/WDataT<18>") getData("/WDataT<17>") getData("/WDataT<16>") )
resultsDir( "/net/bull/apps/Cadence/simulation/6T_MultiBank_32K_Test/spectreVerilog/config/distributed/job022" )
modelFile(
    '("/software/cadence/ncsu-FreePDK15/hspice_16nm_hp.include" "")
)
desVar(	  "vdd" 675m	)
run( ?jobName "job" ?mail "rstdenis@ucdavis.edu" )
selectResult( 'tran )
plot(getData("/ReadEn") getData("/R_Address<11:0>") getData("/W_Address<11:0>") getData("/WriteEn") getData("/ReadAck") getData("/WriteAck") getData("/RAckT") getData("/WAckT") getData("/R_AddressT<11>") getData("/R_AddressT<10>") getData("/R_AddressT<9>") getData("/R_AddressT<8>") getData("/R_AddressT<7>") getData("/R_AddressT<6>") getData("/R_AddressT<5>") getData("/R_AddressT<4>") getData("/R_AddressT<3>") getData("/R_AddressT<2>") getData("/R_AddressT<1>") getData("/R_AddressT<0>") getData("/ReadEnT") getData("/W_AddressT<11>") getData("/W_AddressT<10>") getData("/W_AddressT<9>") getData("/W_AddressT<8>") getData("/W_AddressT<7>") getData("/W_AddressT<6>") getData("/W_AddressT<5>") getData("/W_AddressT<4>") getData("/W_AddressT<3>") getData("/W_AddressT<2>") getData("/W_AddressT<1>") getData("/W_AddressT<0>") getData("/WriteEnT") getData("/WDataAckT<7>") getData("/WDataAckT<6>") getData("/WDataAckT<5>") getData("/WDataAckT<4>") getData("/WDataAckT<3>") getData("/WDataAckT<2>") getData("/WDataAckT<1>") getData("/WDataAckT<0>") getData("/V0/MINUS") getData("/I21/WdBank0<31>") getData("/I21/WdBank0<30>") getData("/I21/WdBank0<29>") getData("/I21/WdBank0<28>") getData("/I21/WdBank0<27>") getData("/I21/WdBank0<26>") getData("/I21/WdBank0<25>") getData("/I21/WdBank0<24>") getData("/I21/WdBank0<23>") getData("/I21/WdBank0<22>") getData("/I21/WdBank0<21>") getData("/I21/WdBank0<20>") getData("/I21/WdBank0<19>") getData("/I21/WdBank0<18>") getData("/I21/WdBank0<17>") getData("/I21/WdBank0<16>") getData("/I21/WdBank0<15>") getData("/I21/WdBank0<14>") getData("/I21/WdBank0<13>") getData("/I21/WdBank0<12>") getData("/I21/WdBank0<11>") getData("/I21/WdBank0<10>") getData("/I21/WdBank0<9>") getData("/I21/WdBank0<8>") getData("/I21/WdBank0<7>") getData("/I21/WdBank0<6>") getData("/I21/WdBank0<5>") getData("/I21/WdBank0<4>") getData("/I21/WdBank0<3>") getData("/I21/WdBank0<2>") getData("/I21/WdBank0<1>") getData("/I21/WdBank0<0>") getData("/I21/Bank0WAck<7>") getData("/I21/Bank0WAck<6>") getData("/I21/Bank0WAck<5>") getData("/I21/Bank0WAck<4>") getData("/I21/Bank0WAck<3>") getData("/I21/Bank0WAck<2>") getData("/I21/Bank0WAck<1>") getData("/I21/Bank0WAck<0>") getData("/I21/WdBank1<31>") getData("/I21/WdBank1<30>") getData("/I21/WdBank1<29>") getData("/I21/WdBank1<28>") getData("/I21/WdBank1<27>") getData("/I21/WdBank1<26>") getData("/I21/WdBank1<25>") getData("/I21/WdBank1<24>") getData("/I21/WdBank1<23>") getData("/I21/WdBank1<22>") getData("/I21/WdBank1<21>") getData("/I21/WdBank1<20>") getData("/I21/WdBank1<19>") getData("/I21/WdBank1<18>") getData("/I21/WdBank1<17>") getData("/I21/WdBank1<16>") getData("/I21/WdBank1<15>") getData("/I21/WdBank1<14>") getData("/I21/WdBank1<13>") getData("/I21/WdBank1<12>") getData("/I21/WdBank1<11>") getData("/I21/WdBank1<10>") getData("/I21/WdBank1<9>") getData("/I21/WdBank1<8>") getData("/I21/WdBank1<7>") getData("/I21/WdBank1<6>") getData("/I21/WdBank1<5>") getData("/I21/WdBank1<4>") getData("/I21/WdBank1<3>") getData("/I21/WdBank1<2>") getData("/I21/WdBank1<1>") getData("/I21/WdBank1<0>") getData("/I21/Bank1WAck<7>") getData("/I21/Bank1WAck<6>") getData("/I21/Bank1WAck<5>") getData("/I21/Bank1WAck<4>") getData("/I21/Bank1WAck<3>") getData("/I21/Bank1WAck<2>") getData("/I21/Bank1WAck<1>") getData("/I21/Bank1WAck<0>") getData("/I21/WdBank2<31>") getData("/I21/WdBank2<30>") getData("/I21/WdBank2<29>") getData("/I21/WdBank2<28>") getData("/I21/WdBank2<27>") getData("/I21/WdBank2<26>") getData("/I21/WdBank2<25>") getData("/I21/WdBank2<24>") getData("/I21/WdBank2<23>") getData("/I21/WdBank2<22>") getData("/I21/WdBank2<21>") getData("/I21/WdBank2<20>") getData("/I21/WdBank2<19>") getData("/I21/WdBank2<18>") getData("/I21/WdBank2<17>") getData("/I21/WdBank2<16>") getData("/I21/WdBank2<15>") getData("/I21/WdBank2<14>") getData("/I21/WdBank2<13>") getData("/I21/WdBank2<12>") getData("/I21/WdBank2<11>") getData("/I21/WdBank2<10>") getData("/I21/WdBank2<9>") getData("/I21/WdBank2<8>") getData("/I21/WdBank2<7>") getData("/I21/WdBank2<6>") getData("/I21/WdBank2<5>") getData("/I21/WdBank2<4>") getData("/I21/WdBank2<3>") getData("/I21/WdBank2<2>") getData("/I21/WdBank2<1>") getData("/I21/WdBank2<0>") getData("/I21/Bank2WAck<7>") getData("/I21/Bank2WAck<6>") getData("/I21/Bank2WAck<5>") getData("/I21/Bank2WAck<4>") getData("/I21/Bank2WAck<3>") getData("/I21/Bank2WAck<2>") getData("/I21/Bank2WAck<1>") getData("/I21/Bank2WAck<0>") getData("/I21/WdBank3<31>") getData("/I21/WdBank3<30>") getData("/I21/WdBank3<29>") getData("/I21/WdBank3<28>") getData("/I21/WdBank3<27>") getData("/I21/WdBank3<26>") getData("/I21/WdBank3<25>") getData("/I21/WdBank3<24>") getData("/I21/WdBank3<23>") getData("/I21/WdBank3<22>") getData("/I21/WdBank3<21>") getData("/I21/WdBank3<20>") getData("/I21/WdBank3<19>") getData("/I21/WdBank3<18>") getData("/I21/WdBank3<17>") getData("/I21/WdBank3<16>") getData("/I21/WdBank3<15>") getData("/I21/WdBank3<14>") getData("/I21/WdBank3<13>") getData("/I21/WdBank3<12>") getData("/I21/WdBank3<11>") getData("/I21/WdBank3<10>") getData("/I21/WdBank3<9>") getData("/I21/WdBank3<8>") getData("/I21/WdBank3<7>") getData("/I21/WdBank3<6>") getData("/I21/WdBank3<5>") getData("/I21/WdBank3<4>") getData("/I21/WdBank3<3>") getData("/I21/WdBank3<2>") getData("/I21/WdBank3<1>") getData("/I21/WdBank3<0>") getData("/I21/Bank3WAck<7>") getData("/I21/Bank3WAck<6>") getData("/I21/Bank3WAck<5>") getData("/I21/Bank3WAck<4>") getData("/I21/Bank3WAck<3>") getData("/I21/Bank3WAck<2>") getData("/I21/Bank3WAck<1>") getData("/I21/Bank3WAck<0>") getData("/I21/net0201") getData("/I21/net0205") getData("/I21/net018") getData("/I21/net017") getData("/I21/net022") getData("/I21/net021") getData("/I21/net020") getData("/I21/net019") getData("/I21/RdBank0<31>") getData("/I21/RdBank0<30>") getData("/I21/RdBank0<29>") getData("/I21/RdBank0<28>") getData("/I21/RdBank0<27>") getData("/I21/RdBank0<26>") getData("/I21/RdBank0<25>") getData("/I21/RdBank0<24>") getData("/I21/RdBank0<23>") getData("/I21/RdBank0<22>") getData("/I21/RdBank0<21>") getData("/I21/RdBank0<20>") getData("/I21/RdBank0<19>") getData("/I21/RdBank0<18>") getData("/I21/RdBank0<17>") getData("/I21/RdBank0<16>") getData("/I21/RdBank0<15>") getData("/I21/RdBank0<14>") getData("/I21/RdBank0<13>") getData("/I21/RdBank0<12>") getData("/I21/RdBank0<11>") getData("/I21/RdBank0<10>") getData("/I21/RdBank0<9>") getData("/I21/RdBank0<8>") getData("/I21/RdBank0<7>") getData("/I21/RdBank0<6>") getData("/I21/RdBank0<5>") getData("/I21/RdBank0<4>") getData("/I21/RdBank0<3>") getData("/I21/RdBank0<2>") getData("/I21/RdBank0<1>") getData("/I21/RdBank0<0>") getData("/I21/RdBank0Ack<7>") getData("/I21/RdBank0Ack<6>") getData("/I21/RdBank0Ack<5>") getData("/I21/RdBank0Ack<4>") getData("/I21/RdBank0Ack<3>") getData("/I21/RdBank0Ack<2>") getData("/I21/RdBank0Ack<1>") getData("/I21/RdBank0Ack<0>") getData("/I21/RdBank1<31>") getData("/I21/RdBank1<30>") getData("/I21/RdBank1<29>") getData("/I21/RdBank1<28>") getData("/I21/RdBank1<27>") getData("/I21/RdBank1<26>") getData("/I21/RdBank1<25>") getData("/I21/RdBank1<24>") getData("/I21/RdBank1<23>") getData("/I21/RdBank1<22>") getData("/I21/RdBank1<21>") getData("/I21/RdBank1<20>") getData("/I21/RdBank1<19>") getData("/I21/RdBank1<18>") getData("/I21/RdBank1<17>") getData("/I21/RdBank1<16>") getData("/I21/RdBank1<15>") getData("/I21/RdBank1<14>") getData("/I21/RdBank1<13>") getData("/I21/RdBank1<12>") getData("/I21/RdBank1<11>") getData("/I21/RdBank1<10>") getData("/I21/RdBank1<9>") getData("/I21/RdBank1<8>") getData("/I21/RdBank1<7>") getData("/I21/RdBank1<6>") getData("/I21/RdBank1<5>") getData("/I21/RdBank1<4>") getData("/I21/RdBank1<3>") getData("/I21/RdBank1<2>") getData("/I21/RdBank1<1>") getData("/I21/RdBank1<0>") getData("/I21/RdBank1Ack<7>") getData("/I21/RdBank1Ack<6>") getData("/I21/RdBank1Ack<5>") getData("/I21/RdBank1Ack<4>") getData("/I21/RdBank1Ack<3>") getData("/I21/RdBank1Ack<2>") getData("/I21/RdBank1Ack<1>") getData("/I21/RdBank1Ack<0>") getData("/Data1<63:0>") getData("/WDataAck<31:0>") getData("/RData<63:0>") getData("/RDataT<63>") getData("/RDataT<62>") getData("/RDataT<61>") getData("/RDataT<60>") getData("/RDataT<59>") getData("/RDataT<58>") getData("/RDataT<57>") getData("/RDataT<56>") getData("/RDataT<55>") getData("/RDataT<54>") getData("/RDataT<53>") getData("/RDataT<52>") getData("/RDataT<51>") getData("/RDataT<50>") getData("/RDataT<49>") getData("/RDataT<48>") getData("/RDataT<47>") getData("/RDataT<46>") getData("/RDataT<45>") getData("/RDataT<44>") getData("/RDataT<43>") getData("/RDataT<42>") getData("/RDataT<41>") getData("/RDataT<40>") getData("/RDataT<39>") getData("/RDataT<38>") getData("/RDataT<37>") getData("/RDataT<36>") getData("/RDataT<35>") getData("/RDataT<34>") getData("/RDataT<33>") getData("/RDataT<32>") getData("/RDataT<31>") getData("/RDataT<30>") getData("/RDataT<29>") getData("/RDataT<28>") getData("/RDataT<27>") getData("/RDataT<26>") getData("/RDataT<25>") getData("/RDataT<24>") getData("/RDataT<23>") getData("/RDataT<22>") getData("/RDataT<21>") getData("/RDataT<20>") getData("/RDataT<19>") getData("/RDataT<18>") getData("/RDataT<17>") getData("/RDataT<16>") getData("/WDataT<63>") getData("/WDataT<62>") getData("/WDataT<61>") getData("/WDataT<60>") getData("/WDataT<59>") getData("/WDataT<58>") getData("/WDataT<57>") getData("/WDataT<56>") getData("/WDataT<55>") getData("/WDataT<54>") getData("/WDataT<53>") getData("/WDataT<52>") getData("/WDataT<51>") getData("/WDataT<50>") getData("/WDataT<49>") getData("/WDataT<48>") getData("/WDataT<47>") getData("/WDataT<46>") getData("/WDataT<45>") getData("/WDataT<44>") getData("/WDataT<43>") getData("/WDataT<42>") getData("/WDataT<41>") getData("/WDataT<40>") getData("/WDataT<39>") getData("/WDataT<38>") getData("/WDataT<37>") getData("/WDataT<36>") getData("/WDataT<35>") getData("/WDataT<34>") getData("/WDataT<33>") getData("/WDataT<32>") getData("/WDataT<31>") getData("/WDataT<30>") getData("/WDataT<29>") getData("/WDataT<28>") getData("/WDataT<27>") getData("/WDataT<26>") getData("/WDataT<25>") getData("/WDataT<24>") getData("/WDataT<23>") getData("/WDataT<22>") getData("/WDataT<21>") getData("/WDataT<20>") getData("/WDataT<19>") getData("/WDataT<18>") getData("/WDataT<17>") getData("/WDataT<16>") )
resultsDir( "/net/bull/apps/Cadence/simulation/6T_MultiBank_32K_Test/spectreVerilog/config/distributed/job023" )
modelFile(
    '("/software/cadence/ncsu-FreePDK15/hspice_16nm_hp.include" "")
)
desVar(	  "vdd" .850	)
run( ?jobName "job" ?mail "rstdenis@ucdavis.edu" )
selectResult( 'tran )
plot(getData("/ReadEn") getData("/R_Address<11:0>") getData("/W_Address<11:0>") getData("/WriteEn") getData("/ReadAck") getData("/WriteAck") getData("/RAckT") getData("/WAckT") getData("/R_AddressT<11>") getData("/R_AddressT<10>") getData("/R_AddressT<9>") getData("/R_AddressT<8>") getData("/R_AddressT<7>") getData("/R_AddressT<6>") getData("/R_AddressT<5>") getData("/R_AddressT<4>") getData("/R_AddressT<3>") getData("/R_AddressT<2>") getData("/R_AddressT<1>") getData("/R_AddressT<0>") getData("/ReadEnT") getData("/W_AddressT<11>") getData("/W_AddressT<10>") getData("/W_AddressT<9>") getData("/W_AddressT<8>") getData("/W_AddressT<7>") getData("/W_AddressT<6>") getData("/W_AddressT<5>") getData("/W_AddressT<4>") getData("/W_AddressT<3>") getData("/W_AddressT<2>") getData("/W_AddressT<1>") getData("/W_AddressT<0>") getData("/WriteEnT") getData("/WDataAckT<7>") getData("/WDataAckT<6>") getData("/WDataAckT<5>") getData("/WDataAckT<4>") getData("/WDataAckT<3>") getData("/WDataAckT<2>") getData("/WDataAckT<1>") getData("/WDataAckT<0>") getData("/V0/MINUS") getData("/I21/WdBank0<31>") getData("/I21/WdBank0<30>") getData("/I21/WdBank0<29>") getData("/I21/WdBank0<28>") getData("/I21/WdBank0<27>") getData("/I21/WdBank0<26>") getData("/I21/WdBank0<25>") getData("/I21/WdBank0<24>") getData("/I21/WdBank0<23>") getData("/I21/WdBank0<22>") getData("/I21/WdBank0<21>") getData("/I21/WdBank0<20>") getData("/I21/WdBank0<19>") getData("/I21/WdBank0<18>") getData("/I21/WdBank0<17>") getData("/I21/WdBank0<16>") getData("/I21/WdBank0<15>") getData("/I21/WdBank0<14>") getData("/I21/WdBank0<13>") getData("/I21/WdBank0<12>") getData("/I21/WdBank0<11>") getData("/I21/WdBank0<10>") getData("/I21/WdBank0<9>") getData("/I21/WdBank0<8>") getData("/I21/WdBank0<7>") getData("/I21/WdBank0<6>") getData("/I21/WdBank0<5>") getData("/I21/WdBank0<4>") getData("/I21/WdBank0<3>") getData("/I21/WdBank0<2>") getData("/I21/WdBank0<1>") getData("/I21/WdBank0<0>") getData("/I21/Bank0WAck<7>") getData("/I21/Bank0WAck<6>") getData("/I21/Bank0WAck<5>") getData("/I21/Bank0WAck<4>") getData("/I21/Bank0WAck<3>") getData("/I21/Bank0WAck<2>") getData("/I21/Bank0WAck<1>") getData("/I21/Bank0WAck<0>") getData("/I21/WdBank1<31>") getData("/I21/WdBank1<30>") getData("/I21/WdBank1<29>") getData("/I21/WdBank1<28>") getData("/I21/WdBank1<27>") getData("/I21/WdBank1<26>") getData("/I21/WdBank1<25>") getData("/I21/WdBank1<24>") getData("/I21/WdBank1<23>") getData("/I21/WdBank1<22>") getData("/I21/WdBank1<21>") getData("/I21/WdBank1<20>") getData("/I21/WdBank1<19>") getData("/I21/WdBank1<18>") getData("/I21/WdBank1<17>") getData("/I21/WdBank1<16>") getData("/I21/WdBank1<15>") getData("/I21/WdBank1<14>") getData("/I21/WdBank1<13>") getData("/I21/WdBank1<12>") getData("/I21/WdBank1<11>") getData("/I21/WdBank1<10>") getData("/I21/WdBank1<9>") getData("/I21/WdBank1<8>") getData("/I21/WdBank1<7>") getData("/I21/WdBank1<6>") getData("/I21/WdBank1<5>") getData("/I21/WdBank1<4>") getData("/I21/WdBank1<3>") getData("/I21/WdBank1<2>") getData("/I21/WdBank1<1>") getData("/I21/WdBank1<0>") getData("/I21/Bank1WAck<7>") getData("/I21/Bank1WAck<6>") getData("/I21/Bank1WAck<5>") getData("/I21/Bank1WAck<4>") getData("/I21/Bank1WAck<3>") getData("/I21/Bank1WAck<2>") getData("/I21/Bank1WAck<1>") getData("/I21/Bank1WAck<0>") getData("/I21/WdBank2<31>") getData("/I21/WdBank2<30>") getData("/I21/WdBank2<29>") getData("/I21/WdBank2<28>") getData("/I21/WdBank2<27>") getData("/I21/WdBank2<26>") getData("/I21/WdBank2<25>") getData("/I21/WdBank2<24>") getData("/I21/WdBank2<23>") getData("/I21/WdBank2<22>") getData("/I21/WdBank2<21>") getData("/I21/WdBank2<20>") getData("/I21/WdBank2<19>") getData("/I21/WdBank2<18>") getData("/I21/WdBank2<17>") getData("/I21/WdBank2<16>") getData("/I21/WdBank2<15>") getData("/I21/WdBank2<14>") getData("/I21/WdBank2<13>") getData("/I21/WdBank2<12>") getData("/I21/WdBank2<11>") getData("/I21/WdBank2<10>") getData("/I21/WdBank2<9>") getData("/I21/WdBank2<8>") getData("/I21/WdBank2<7>") getData("/I21/WdBank2<6>") getData("/I21/WdBank2<5>") getData("/I21/WdBank2<4>") getData("/I21/WdBank2<3>") getData("/I21/WdBank2<2>") getData("/I21/WdBank2<1>") getData("/I21/WdBank2<0>") getData("/I21/Bank2WAck<7>") getData("/I21/Bank2WAck<6>") getData("/I21/Bank2WAck<5>") getData("/I21/Bank2WAck<4>") getData("/I21/Bank2WAck<3>") getData("/I21/Bank2WAck<2>") getData("/I21/Bank2WAck<1>") getData("/I21/Bank2WAck<0>") getData("/I21/WdBank3<31>") getData("/I21/WdBank3<30>") getData("/I21/WdBank3<29>") getData("/I21/WdBank3<28>") getData("/I21/WdBank3<27>") getData("/I21/WdBank3<26>") getData("/I21/WdBank3<25>") getData("/I21/WdBank3<24>") getData("/I21/WdBank3<23>") getData("/I21/WdBank3<22>") getData("/I21/WdBank3<21>") getData("/I21/WdBank3<20>") getData("/I21/WdBank3<19>") getData("/I21/WdBank3<18>") getData("/I21/WdBank3<17>") getData("/I21/WdBank3<16>") getData("/I21/WdBank3<15>") getData("/I21/WdBank3<14>") getData("/I21/WdBank3<13>") getData("/I21/WdBank3<12>") getData("/I21/WdBank3<11>") getData("/I21/WdBank3<10>") getData("/I21/WdBank3<9>") getData("/I21/WdBank3<8>") getData("/I21/WdBank3<7>") getData("/I21/WdBank3<6>") getData("/I21/WdBank3<5>") getData("/I21/WdBank3<4>") getData("/I21/WdBank3<3>") getData("/I21/WdBank3<2>") getData("/I21/WdBank3<1>") getData("/I21/WdBank3<0>") getData("/I21/Bank3WAck<7>") getData("/I21/Bank3WAck<6>") getData("/I21/Bank3WAck<5>") getData("/I21/Bank3WAck<4>") getData("/I21/Bank3WAck<3>") getData("/I21/Bank3WAck<2>") getData("/I21/Bank3WAck<1>") getData("/I21/Bank3WAck<0>") getData("/I21/net0201") getData("/I21/net0205") getData("/I21/net018") getData("/I21/net017") getData("/I21/net022") getData("/I21/net021") getData("/I21/net020") getData("/I21/net019") getData("/I21/RdBank0<31>") getData("/I21/RdBank0<30>") getData("/I21/RdBank0<29>") getData("/I21/RdBank0<28>") getData("/I21/RdBank0<27>") getData("/I21/RdBank0<26>") getData("/I21/RdBank0<25>") getData("/I21/RdBank0<24>") getData("/I21/RdBank0<23>") getData("/I21/RdBank0<22>") getData("/I21/RdBank0<21>") getData("/I21/RdBank0<20>") getData("/I21/RdBank0<19>") getData("/I21/RdBank0<18>") getData("/I21/RdBank0<17>") getData("/I21/RdBank0<16>") getData("/I21/RdBank0<15>") getData("/I21/RdBank0<14>") getData("/I21/RdBank0<13>") getData("/I21/RdBank0<12>") getData("/I21/RdBank0<11>") getData("/I21/RdBank0<10>") getData("/I21/RdBank0<9>") getData("/I21/RdBank0<8>") getData("/I21/RdBank0<7>") getData("/I21/RdBank0<6>") getData("/I21/RdBank0<5>") getData("/I21/RdBank0<4>") getData("/I21/RdBank0<3>") getData("/I21/RdBank0<2>") getData("/I21/RdBank0<1>") getData("/I21/RdBank0<0>") getData("/I21/RdBank0Ack<7>") getData("/I21/RdBank0Ack<6>") getData("/I21/RdBank0Ack<5>") getData("/I21/RdBank0Ack<4>") getData("/I21/RdBank0Ack<3>") getData("/I21/RdBank0Ack<2>") getData("/I21/RdBank0Ack<1>") getData("/I21/RdBank0Ack<0>") getData("/I21/RdBank1<31>") getData("/I21/RdBank1<30>") getData("/I21/RdBank1<29>") getData("/I21/RdBank1<28>") getData("/I21/RdBank1<27>") getData("/I21/RdBank1<26>") getData("/I21/RdBank1<25>") getData("/I21/RdBank1<24>") getData("/I21/RdBank1<23>") getData("/I21/RdBank1<22>") getData("/I21/RdBank1<21>") getData("/I21/RdBank1<20>") getData("/I21/RdBank1<19>") getData("/I21/RdBank1<18>") getData("/I21/RdBank1<17>") getData("/I21/RdBank1<16>") getData("/I21/RdBank1<15>") getData("/I21/RdBank1<14>") getData("/I21/RdBank1<13>") getData("/I21/RdBank1<12>") getData("/I21/RdBank1<11>") getData("/I21/RdBank1<10>") getData("/I21/RdBank1<9>") getData("/I21/RdBank1<8>") getData("/I21/RdBank1<7>") getData("/I21/RdBank1<6>") getData("/I21/RdBank1<5>") getData("/I21/RdBank1<4>") getData("/I21/RdBank1<3>") getData("/I21/RdBank1<2>") getData("/I21/RdBank1<1>") getData("/I21/RdBank1<0>") getData("/I21/RdBank1Ack<7>") getData("/I21/RdBank1Ack<6>") getData("/I21/RdBank1Ack<5>") getData("/I21/RdBank1Ack<4>") getData("/I21/RdBank1Ack<3>") getData("/I21/RdBank1Ack<2>") getData("/I21/RdBank1Ack<1>") getData("/I21/RdBank1Ack<0>") getData("/Data1<63:0>") getData("/WDataAck<31:0>") getData("/RData<63:0>") getData("/RDataT<63>") getData("/RDataT<62>") getData("/RDataT<61>") getData("/RDataT<60>") getData("/RDataT<59>") getData("/RDataT<58>") getData("/RDataT<57>") getData("/RDataT<56>") getData("/RDataT<55>") getData("/RDataT<54>") getData("/RDataT<53>") getData("/RDataT<52>") getData("/RDataT<51>") getData("/RDataT<50>") getData("/RDataT<49>") getData("/RDataT<48>") getData("/RDataT<47>") getData("/RDataT<46>") getData("/RDataT<45>") getData("/RDataT<44>") getData("/RDataT<43>") getData("/RDataT<42>") getData("/RDataT<41>") getData("/RDataT<40>") getData("/RDataT<39>") getData("/RDataT<38>") getData("/RDataT<37>") getData("/RDataT<36>") getData("/RDataT<35>") getData("/RDataT<34>") getData("/RDataT<33>") getData("/RDataT<32>") getData("/RDataT<31>") getData("/RDataT<30>") getData("/RDataT<29>") getData("/RDataT<28>") getData("/RDataT<27>") getData("/RDataT<26>") getData("/RDataT<25>") getData("/RDataT<24>") getData("/RDataT<23>") getData("/RDataT<22>") getData("/RDataT<21>") getData("/RDataT<20>") getData("/RDataT<19>") getData("/RDataT<18>") getData("/RDataT<17>") getData("/RDataT<16>") getData("/WDataT<63>") getData("/WDataT<62>") getData("/WDataT<61>") getData("/WDataT<60>") getData("/WDataT<59>") getData("/WDataT<58>") getData("/WDataT<57>") getData("/WDataT<56>") getData("/WDataT<55>") getData("/WDataT<54>") getData("/WDataT<53>") getData("/WDataT<52>") getData("/WDataT<51>") getData("/WDataT<50>") getData("/WDataT<49>") getData("/WDataT<48>") getData("/WDataT<47>") getData("/WDataT<46>") getData("/WDataT<45>") getData("/WDataT<44>") getData("/WDataT<43>") getData("/WDataT<42>") getData("/WDataT<41>") getData("/WDataT<40>") getData("/WDataT<39>") getData("/WDataT<38>") getData("/WDataT<37>") getData("/WDataT<36>") getData("/WDataT<35>") getData("/WDataT<34>") getData("/WDataT<33>") getData("/WDataT<32>") getData("/WDataT<31>") getData("/WDataT<30>") getData("/WDataT<29>") getData("/WDataT<28>") getData("/WDataT<27>") getData("/WDataT<26>") getData("/WDataT<25>") getData("/WDataT<24>") getData("/WDataT<23>") getData("/WDataT<22>") getData("/WDataT<21>") getData("/WDataT<20>") getData("/WDataT<19>") getData("/WDataT<18>") getData("/WDataT<17>") getData("/WDataT<16>") )
resultsDir( "/net/bull/apps/Cadence/simulation/6T_MultiBank_32K_Test/spectreVerilog/config/distributed/job024" )
modelFile(
    '("/software/cadence/ncsu-FreePDK15/hspice_16nm_hp.include" "")
)
desVar(	  "vdd" .500	)
option(	'temp  "85.0"
)
temp( 85.0 )
run( ?jobName "job" ?mail "rstdenis@ucdavis.edu" )
selectResult( 'tran )
plot(getData("/ReadEn") getData("/R_Address<11:0>") getData("/W_Address<11:0>") getData("/WriteEn") getData("/ReadAck") getData("/WriteAck") getData("/RAckT") getData("/WAckT") getData("/R_AddressT<11>") getData("/R_AddressT<10>") getData("/R_AddressT<9>") getData("/R_AddressT<8>") getData("/R_AddressT<7>") getData("/R_AddressT<6>") getData("/R_AddressT<5>") getData("/R_AddressT<4>") getData("/R_AddressT<3>") getData("/R_AddressT<2>") getData("/R_AddressT<1>") getData("/R_AddressT<0>") getData("/ReadEnT") getData("/W_AddressT<11>") getData("/W_AddressT<10>") getData("/W_AddressT<9>") getData("/W_AddressT<8>") getData("/W_AddressT<7>") getData("/W_AddressT<6>") getData("/W_AddressT<5>") getData("/W_AddressT<4>") getData("/W_AddressT<3>") getData("/W_AddressT<2>") getData("/W_AddressT<1>") getData("/W_AddressT<0>") getData("/WriteEnT") getData("/WDataAckT<7>") getData("/WDataAckT<6>") getData("/WDataAckT<5>") getData("/WDataAckT<4>") getData("/WDataAckT<3>") getData("/WDataAckT<2>") getData("/WDataAckT<1>") getData("/WDataAckT<0>") getData("/V0/MINUS") getData("/I21/WdBank0<31>") getData("/I21/WdBank0<30>") getData("/I21/WdBank0<29>") getData("/I21/WdBank0<28>") getData("/I21/WdBank0<27>") getData("/I21/WdBank0<26>") getData("/I21/WdBank0<25>") getData("/I21/WdBank0<24>") getData("/I21/WdBank0<23>") getData("/I21/WdBank0<22>") getData("/I21/WdBank0<21>") getData("/I21/WdBank0<20>") getData("/I21/WdBank0<19>") getData("/I21/WdBank0<18>") getData("/I21/WdBank0<17>") getData("/I21/WdBank0<16>") getData("/I21/WdBank0<15>") getData("/I21/WdBank0<14>") getData("/I21/WdBank0<13>") getData("/I21/WdBank0<12>") getData("/I21/WdBank0<11>") getData("/I21/WdBank0<10>") getData("/I21/WdBank0<9>") getData("/I21/WdBank0<8>") getData("/I21/WdBank0<7>") getData("/I21/WdBank0<6>") getData("/I21/WdBank0<5>") getData("/I21/WdBank0<4>") getData("/I21/WdBank0<3>") getData("/I21/WdBank0<2>") getData("/I21/WdBank0<1>") getData("/I21/WdBank0<0>") getData("/I21/Bank0WAck<7>") getData("/I21/Bank0WAck<6>") getData("/I21/Bank0WAck<5>") getData("/I21/Bank0WAck<4>") getData("/I21/Bank0WAck<3>") getData("/I21/Bank0WAck<2>") getData("/I21/Bank0WAck<1>") getData("/I21/Bank0WAck<0>") getData("/I21/WdBank1<31>") getData("/I21/WdBank1<30>") getData("/I21/WdBank1<29>") getData("/I21/WdBank1<28>") getData("/I21/WdBank1<27>") getData("/I21/WdBank1<26>") getData("/I21/WdBank1<25>") getData("/I21/WdBank1<24>") getData("/I21/WdBank1<23>") getData("/I21/WdBank1<22>") getData("/I21/WdBank1<21>") getData("/I21/WdBank1<20>") getData("/I21/WdBank1<19>") getData("/I21/WdBank1<18>") getData("/I21/WdBank1<17>") getData("/I21/WdBank1<16>") getData("/I21/WdBank1<15>") getData("/I21/WdBank1<14>") getData("/I21/WdBank1<13>") getData("/I21/WdBank1<12>") getData("/I21/WdBank1<11>") getData("/I21/WdBank1<10>") getData("/I21/WdBank1<9>") getData("/I21/WdBank1<8>") getData("/I21/WdBank1<7>") getData("/I21/WdBank1<6>") getData("/I21/WdBank1<5>") getData("/I21/WdBank1<4>") getData("/I21/WdBank1<3>") getData("/I21/WdBank1<2>") getData("/I21/WdBank1<1>") getData("/I21/WdBank1<0>") getData("/I21/Bank1WAck<7>") getData("/I21/Bank1WAck<6>") getData("/I21/Bank1WAck<5>") getData("/I21/Bank1WAck<4>") getData("/I21/Bank1WAck<3>") getData("/I21/Bank1WAck<2>") getData("/I21/Bank1WAck<1>") getData("/I21/Bank1WAck<0>") getData("/I21/WdBank2<31>") getData("/I21/WdBank2<30>") getData("/I21/WdBank2<29>") getData("/I21/WdBank2<28>") getData("/I21/WdBank2<27>") getData("/I21/WdBank2<26>") getData("/I21/WdBank2<25>") getData("/I21/WdBank2<24>") getData("/I21/WdBank2<23>") getData("/I21/WdBank2<22>") getData("/I21/WdBank2<21>") getData("/I21/WdBank2<20>") getData("/I21/WdBank2<19>") getData("/I21/WdBank2<18>") getData("/I21/WdBank2<17>") getData("/I21/WdBank2<16>") getData("/I21/WdBank2<15>") getData("/I21/WdBank2<14>") getData("/I21/WdBank2<13>") getData("/I21/WdBank2<12>") getData("/I21/WdBank2<11>") getData("/I21/WdBank2<10>") getData("/I21/WdBank2<9>") getData("/I21/WdBank2<8>") getData("/I21/WdBank2<7>") getData("/I21/WdBank2<6>") getData("/I21/WdBank2<5>") getData("/I21/WdBank2<4>") getData("/I21/WdBank2<3>") getData("/I21/WdBank2<2>") getData("/I21/WdBank2<1>") getData("/I21/WdBank2<0>") getData("/I21/Bank2WAck<7>") getData("/I21/Bank2WAck<6>") getData("/I21/Bank2WAck<5>") getData("/I21/Bank2WAck<4>") getData("/I21/Bank2WAck<3>") getData("/I21/Bank2WAck<2>") getData("/I21/Bank2WAck<1>") getData("/I21/Bank2WAck<0>") getData("/I21/WdBank3<31>") getData("/I21/WdBank3<30>") getData("/I21/WdBank3<29>") getData("/I21/WdBank3<28>") getData("/I21/WdBank3<27>") getData("/I21/WdBank3<26>") getData("/I21/WdBank3<25>") getData("/I21/WdBank3<24>") getData("/I21/WdBank3<23>") getData("/I21/WdBank3<22>") getData("/I21/WdBank3<21>") getData("/I21/WdBank3<20>") getData("/I21/WdBank3<19>") getData("/I21/WdBank3<18>") getData("/I21/WdBank3<17>") getData("/I21/WdBank3<16>") getData("/I21/WdBank3<15>") getData("/I21/WdBank3<14>") getData("/I21/WdBank3<13>") getData("/I21/WdBank3<12>") getData("/I21/WdBank3<11>") getData("/I21/WdBank3<10>") getData("/I21/WdBank3<9>") getData("/I21/WdBank3<8>") getData("/I21/WdBank3<7>") getData("/I21/WdBank3<6>") getData("/I21/WdBank3<5>") getData("/I21/WdBank3<4>") getData("/I21/WdBank3<3>") getData("/I21/WdBank3<2>") getData("/I21/WdBank3<1>") getData("/I21/WdBank3<0>") getData("/I21/Bank3WAck<7>") getData("/I21/Bank3WAck<6>") getData("/I21/Bank3WAck<5>") getData("/I21/Bank3WAck<4>") getData("/I21/Bank3WAck<3>") getData("/I21/Bank3WAck<2>") getData("/I21/Bank3WAck<1>") getData("/I21/Bank3WAck<0>") getData("/I21/net0201") getData("/I21/net0205") getData("/I21/net018") getData("/I21/net017") getData("/I21/net022") getData("/I21/net021") getData("/I21/net020") getData("/I21/net019") getData("/I21/RdBank0<31>") getData("/I21/RdBank0<30>") getData("/I21/RdBank0<29>") getData("/I21/RdBank0<28>") getData("/I21/RdBank0<27>") getData("/I21/RdBank0<26>") getData("/I21/RdBank0<25>") getData("/I21/RdBank0<24>") getData("/I21/RdBank0<23>") getData("/I21/RdBank0<22>") getData("/I21/RdBank0<21>") getData("/I21/RdBank0<20>") getData("/I21/RdBank0<19>") getData("/I21/RdBank0<18>") getData("/I21/RdBank0<17>") getData("/I21/RdBank0<16>") getData("/I21/RdBank0<15>") getData("/I21/RdBank0<14>") getData("/I21/RdBank0<13>") getData("/I21/RdBank0<12>") getData("/I21/RdBank0<11>") getData("/I21/RdBank0<10>") getData("/I21/RdBank0<9>") getData("/I21/RdBank0<8>") getData("/I21/RdBank0<7>") getData("/I21/RdBank0<6>") getData("/I21/RdBank0<5>") getData("/I21/RdBank0<4>") getData("/I21/RdBank0<3>") getData("/I21/RdBank0<2>") getData("/I21/RdBank0<1>") getData("/I21/RdBank0<0>") getData("/I21/RdBank0Ack<7>") getData("/I21/RdBank0Ack<6>") getData("/I21/RdBank0Ack<5>") getData("/I21/RdBank0Ack<4>") getData("/I21/RdBank0Ack<3>") getData("/I21/RdBank0Ack<2>") getData("/I21/RdBank0Ack<1>") getData("/I21/RdBank0Ack<0>") getData("/I21/RdBank1<31>") getData("/I21/RdBank1<30>") getData("/I21/RdBank1<29>") getData("/I21/RdBank1<28>") getData("/I21/RdBank1<27>") getData("/I21/RdBank1<26>") getData("/I21/RdBank1<25>") getData("/I21/RdBank1<24>") getData("/I21/RdBank1<23>") getData("/I21/RdBank1<22>") getData("/I21/RdBank1<21>") getData("/I21/RdBank1<20>") getData("/I21/RdBank1<19>") getData("/I21/RdBank1<18>") getData("/I21/RdBank1<17>") getData("/I21/RdBank1<16>") getData("/I21/RdBank1<15>") getData("/I21/RdBank1<14>") getData("/I21/RdBank1<13>") getData("/I21/RdBank1<12>") getData("/I21/RdBank1<11>") getData("/I21/RdBank1<10>") getData("/I21/RdBank1<9>") getData("/I21/RdBank1<8>") getData("/I21/RdBank1<7>") getData("/I21/RdBank1<6>") getData("/I21/RdBank1<5>") getData("/I21/RdBank1<4>") getData("/I21/RdBank1<3>") getData("/I21/RdBank1<2>") getData("/I21/RdBank1<1>") getData("/I21/RdBank1<0>") getData("/I21/RdBank1Ack<7>") getData("/I21/RdBank1Ack<6>") getData("/I21/RdBank1Ack<5>") getData("/I21/RdBank1Ack<4>") getData("/I21/RdBank1Ack<3>") getData("/I21/RdBank1Ack<2>") getData("/I21/RdBank1Ack<1>") getData("/I21/RdBank1Ack<0>") getData("/Data1<63:0>") getData("/WDataAck<31:0>") getData("/RData<63:0>") getData("/RDataT<63>") getData("/RDataT<62>") getData("/RDataT<61>") getData("/RDataT<60>") getData("/RDataT<59>") getData("/RDataT<58>") getData("/RDataT<57>") getData("/RDataT<56>") getData("/RDataT<55>") getData("/RDataT<54>") getData("/RDataT<53>") getData("/RDataT<52>") getData("/RDataT<51>") getData("/RDataT<50>") getData("/RDataT<49>") getData("/RDataT<48>") getData("/RDataT<47>") getData("/RDataT<46>") getData("/RDataT<45>") getData("/RDataT<44>") getData("/RDataT<43>") getData("/RDataT<42>") getData("/RDataT<41>") getData("/RDataT<40>") getData("/RDataT<39>") getData("/RDataT<38>") getData("/RDataT<37>") getData("/RDataT<36>") getData("/RDataT<35>") getData("/RDataT<34>") getData("/RDataT<33>") getData("/RDataT<32>") getData("/RDataT<31>") getData("/RDataT<30>") getData("/RDataT<29>") getData("/RDataT<28>") getData("/RDataT<27>") getData("/RDataT<26>") getData("/RDataT<25>") getData("/RDataT<24>") getData("/RDataT<23>") getData("/RDataT<22>") getData("/RDataT<21>") getData("/RDataT<20>") getData("/RDataT<19>") getData("/RDataT<18>") getData("/RDataT<17>") getData("/RDataT<16>") getData("/WDataT<63>") getData("/WDataT<62>") getData("/WDataT<61>") getData("/WDataT<60>") getData("/WDataT<59>") getData("/WDataT<58>") getData("/WDataT<57>") getData("/WDataT<56>") getData("/WDataT<55>") getData("/WDataT<54>") getData("/WDataT<53>") getData("/WDataT<52>") getData("/WDataT<51>") getData("/WDataT<50>") getData("/WDataT<49>") getData("/WDataT<48>") getData("/WDataT<47>") getData("/WDataT<46>") getData("/WDataT<45>") getData("/WDataT<44>") getData("/WDataT<43>") getData("/WDataT<42>") getData("/WDataT<41>") getData("/WDataT<40>") getData("/WDataT<39>") getData("/WDataT<38>") getData("/WDataT<37>") getData("/WDataT<36>") getData("/WDataT<35>") getData("/WDataT<34>") getData("/WDataT<33>") getData("/WDataT<32>") getData("/WDataT<31>") getData("/WDataT<30>") getData("/WDataT<29>") getData("/WDataT<28>") getData("/WDataT<27>") getData("/WDataT<26>") getData("/WDataT<25>") getData("/WDataT<24>") getData("/WDataT<23>") getData("/WDataT<22>") getData("/WDataT<21>") getData("/WDataT<20>") getData("/WDataT<19>") getData("/WDataT<18>") getData("/WDataT<17>") getData("/WDataT<16>") )
resultsDir( "/net/bull/apps/Cadence/simulation/6T_MultiBank_32K_Test/spectreVerilog/config/distributed/job025" )
modelFile(
    '("/software/cadence/ncsu-FreePDK15/hspice_16nm_hp.include" "")
)
desVar(	  "vdd" .675	)
run( ?jobName "job" ?mail "rstdenis@ucdavis.edu" )
selectResult( 'tran )
plot(getData("/ReadEn") getData("/R_Address<11:0>") getData("/W_Address<11:0>") getData("/WriteEn") getData("/ReadAck") getData("/WriteAck") getData("/RAckT") getData("/WAckT") getData("/R_AddressT<11>") getData("/R_AddressT<10>") getData("/R_AddressT<9>") getData("/R_AddressT<8>") getData("/R_AddressT<7>") getData("/R_AddressT<6>") getData("/R_AddressT<5>") getData("/R_AddressT<4>") getData("/R_AddressT<3>") getData("/R_AddressT<2>") getData("/R_AddressT<1>") getData("/R_AddressT<0>") getData("/ReadEnT") getData("/W_AddressT<11>") getData("/W_AddressT<10>") getData("/W_AddressT<9>") getData("/W_AddressT<8>") getData("/W_AddressT<7>") getData("/W_AddressT<6>") getData("/W_AddressT<5>") getData("/W_AddressT<4>") getData("/W_AddressT<3>") getData("/W_AddressT<2>") getData("/W_AddressT<1>") getData("/W_AddressT<0>") getData("/WriteEnT") getData("/WDataAckT<7>") getData("/WDataAckT<6>") getData("/WDataAckT<5>") getData("/WDataAckT<4>") getData("/WDataAckT<3>") getData("/WDataAckT<2>") getData("/WDataAckT<1>") getData("/WDataAckT<0>") getData("/V0/MINUS") getData("/I21/WdBank0<31>") getData("/I21/WdBank0<30>") getData("/I21/WdBank0<29>") getData("/I21/WdBank0<28>") getData("/I21/WdBank0<27>") getData("/I21/WdBank0<26>") getData("/I21/WdBank0<25>") getData("/I21/WdBank0<24>") getData("/I21/WdBank0<23>") getData("/I21/WdBank0<22>") getData("/I21/WdBank0<21>") getData("/I21/WdBank0<20>") getData("/I21/WdBank0<19>") getData("/I21/WdBank0<18>") getData("/I21/WdBank0<17>") getData("/I21/WdBank0<16>") getData("/I21/WdBank0<15>") getData("/I21/WdBank0<14>") getData("/I21/WdBank0<13>") getData("/I21/WdBank0<12>") getData("/I21/WdBank0<11>") getData("/I21/WdBank0<10>") getData("/I21/WdBank0<9>") getData("/I21/WdBank0<8>") getData("/I21/WdBank0<7>") getData("/I21/WdBank0<6>") getData("/I21/WdBank0<5>") getData("/I21/WdBank0<4>") getData("/I21/WdBank0<3>") getData("/I21/WdBank0<2>") getData("/I21/WdBank0<1>") getData("/I21/WdBank0<0>") getData("/I21/Bank0WAck<7>") getData("/I21/Bank0WAck<6>") getData("/I21/Bank0WAck<5>") getData("/I21/Bank0WAck<4>") getData("/I21/Bank0WAck<3>") getData("/I21/Bank0WAck<2>") getData("/I21/Bank0WAck<1>") getData("/I21/Bank0WAck<0>") getData("/I21/WdBank1<31>") getData("/I21/WdBank1<30>") getData("/I21/WdBank1<29>") getData("/I21/WdBank1<28>") getData("/I21/WdBank1<27>") getData("/I21/WdBank1<26>") getData("/I21/WdBank1<25>") getData("/I21/WdBank1<24>") getData("/I21/WdBank1<23>") getData("/I21/WdBank1<22>") getData("/I21/WdBank1<21>") getData("/I21/WdBank1<20>") getData("/I21/WdBank1<19>") getData("/I21/WdBank1<18>") getData("/I21/WdBank1<17>") getData("/I21/WdBank1<16>") getData("/I21/WdBank1<15>") getData("/I21/WdBank1<14>") getData("/I21/WdBank1<13>") getData("/I21/WdBank1<12>") getData("/I21/WdBank1<11>") getData("/I21/WdBank1<10>") getData("/I21/WdBank1<9>") getData("/I21/WdBank1<8>") getData("/I21/WdBank1<7>") getData("/I21/WdBank1<6>") getData("/I21/WdBank1<5>") getData("/I21/WdBank1<4>") getData("/I21/WdBank1<3>") getData("/I21/WdBank1<2>") getData("/I21/WdBank1<1>") getData("/I21/WdBank1<0>") getData("/I21/Bank1WAck<7>") getData("/I21/Bank1WAck<6>") getData("/I21/Bank1WAck<5>") getData("/I21/Bank1WAck<4>") getData("/I21/Bank1WAck<3>") getData("/I21/Bank1WAck<2>") getData("/I21/Bank1WAck<1>") getData("/I21/Bank1WAck<0>") getData("/I21/WdBank2<31>") getData("/I21/WdBank2<30>") getData("/I21/WdBank2<29>") getData("/I21/WdBank2<28>") getData("/I21/WdBank2<27>") getData("/I21/WdBank2<26>") getData("/I21/WdBank2<25>") getData("/I21/WdBank2<24>") getData("/I21/WdBank2<23>") getData("/I21/WdBank2<22>") getData("/I21/WdBank2<21>") getData("/I21/WdBank2<20>") getData("/I21/WdBank2<19>") getData("/I21/WdBank2<18>") getData("/I21/WdBank2<17>") getData("/I21/WdBank2<16>") getData("/I21/WdBank2<15>") getData("/I21/WdBank2<14>") getData("/I21/WdBank2<13>") getData("/I21/WdBank2<12>") getData("/I21/WdBank2<11>") getData("/I21/WdBank2<10>") getData("/I21/WdBank2<9>") getData("/I21/WdBank2<8>") getData("/I21/WdBank2<7>") getData("/I21/WdBank2<6>") getData("/I21/WdBank2<5>") getData("/I21/WdBank2<4>") getData("/I21/WdBank2<3>") getData("/I21/WdBank2<2>") getData("/I21/WdBank2<1>") getData("/I21/WdBank2<0>") getData("/I21/Bank2WAck<7>") getData("/I21/Bank2WAck<6>") getData("/I21/Bank2WAck<5>") getData("/I21/Bank2WAck<4>") getData("/I21/Bank2WAck<3>") getData("/I21/Bank2WAck<2>") getData("/I21/Bank2WAck<1>") getData("/I21/Bank2WAck<0>") getData("/I21/WdBank3<31>") getData("/I21/WdBank3<30>") getData("/I21/WdBank3<29>") getData("/I21/WdBank3<28>") getData("/I21/WdBank3<27>") getData("/I21/WdBank3<26>") getData("/I21/WdBank3<25>") getData("/I21/WdBank3<24>") getData("/I21/WdBank3<23>") getData("/I21/WdBank3<22>") getData("/I21/WdBank3<21>") getData("/I21/WdBank3<20>") getData("/I21/WdBank3<19>") getData("/I21/WdBank3<18>") getData("/I21/WdBank3<17>") getData("/I21/WdBank3<16>") getData("/I21/WdBank3<15>") getData("/I21/WdBank3<14>") getData("/I21/WdBank3<13>") getData("/I21/WdBank3<12>") getData("/I21/WdBank3<11>") getData("/I21/WdBank3<10>") getData("/I21/WdBank3<9>") getData("/I21/WdBank3<8>") getData("/I21/WdBank3<7>") getData("/I21/WdBank3<6>") getData("/I21/WdBank3<5>") getData("/I21/WdBank3<4>") getData("/I21/WdBank3<3>") getData("/I21/WdBank3<2>") getData("/I21/WdBank3<1>") getData("/I21/WdBank3<0>") getData("/I21/Bank3WAck<7>") getData("/I21/Bank3WAck<6>") getData("/I21/Bank3WAck<5>") getData("/I21/Bank3WAck<4>") getData("/I21/Bank3WAck<3>") getData("/I21/Bank3WAck<2>") getData("/I21/Bank3WAck<1>") getData("/I21/Bank3WAck<0>") getData("/I21/net0201") getData("/I21/net0205") getData("/I21/net018") getData("/I21/net017") getData("/I21/net022") getData("/I21/net021") getData("/I21/net020") getData("/I21/net019") getData("/I21/RdBank0<31>") getData("/I21/RdBank0<30>") getData("/I21/RdBank0<29>") getData("/I21/RdBank0<28>") getData("/I21/RdBank0<27>") getData("/I21/RdBank0<26>") getData("/I21/RdBank0<25>") getData("/I21/RdBank0<24>") getData("/I21/RdBank0<23>") getData("/I21/RdBank0<22>") getData("/I21/RdBank0<21>") getData("/I21/RdBank0<20>") getData("/I21/RdBank0<19>") getData("/I21/RdBank0<18>") getData("/I21/RdBank0<17>") getData("/I21/RdBank0<16>") getData("/I21/RdBank0<15>") getData("/I21/RdBank0<14>") getData("/I21/RdBank0<13>") getData("/I21/RdBank0<12>") getData("/I21/RdBank0<11>") getData("/I21/RdBank0<10>") getData("/I21/RdBank0<9>") getData("/I21/RdBank0<8>") getData("/I21/RdBank0<7>") getData("/I21/RdBank0<6>") getData("/I21/RdBank0<5>") getData("/I21/RdBank0<4>") getData("/I21/RdBank0<3>") getData("/I21/RdBank0<2>") getData("/I21/RdBank0<1>") getData("/I21/RdBank0<0>") getData("/I21/RdBank0Ack<7>") getData("/I21/RdBank0Ack<6>") getData("/I21/RdBank0Ack<5>") getData("/I21/RdBank0Ack<4>") getData("/I21/RdBank0Ack<3>") getData("/I21/RdBank0Ack<2>") getData("/I21/RdBank0Ack<1>") getData("/I21/RdBank0Ack<0>") getData("/I21/RdBank1<31>") getData("/I21/RdBank1<30>") getData("/I21/RdBank1<29>") getData("/I21/RdBank1<28>") getData("/I21/RdBank1<27>") getData("/I21/RdBank1<26>") getData("/I21/RdBank1<25>") getData("/I21/RdBank1<24>") getData("/I21/RdBank1<23>") getData("/I21/RdBank1<22>") getData("/I21/RdBank1<21>") getData("/I21/RdBank1<20>") getData("/I21/RdBank1<19>") getData("/I21/RdBank1<18>") getData("/I21/RdBank1<17>") getData("/I21/RdBank1<16>") getData("/I21/RdBank1<15>") getData("/I21/RdBank1<14>") getData("/I21/RdBank1<13>") getData("/I21/RdBank1<12>") getData("/I21/RdBank1<11>") getData("/I21/RdBank1<10>") getData("/I21/RdBank1<9>") getData("/I21/RdBank1<8>") getData("/I21/RdBank1<7>") getData("/I21/RdBank1<6>") getData("/I21/RdBank1<5>") getData("/I21/RdBank1<4>") getData("/I21/RdBank1<3>") getData("/I21/RdBank1<2>") getData("/I21/RdBank1<1>") getData("/I21/RdBank1<0>") getData("/I21/RdBank1Ack<7>") getData("/I21/RdBank1Ack<6>") getData("/I21/RdBank1Ack<5>") getData("/I21/RdBank1Ack<4>") getData("/I21/RdBank1Ack<3>") getData("/I21/RdBank1Ack<2>") getData("/I21/RdBank1Ack<1>") getData("/I21/RdBank1Ack<0>") getData("/Data1<63:0>") getData("/WDataAck<31:0>") getData("/RData<63:0>") getData("/RDataT<63>") getData("/RDataT<62>") getData("/RDataT<61>") getData("/RDataT<60>") getData("/RDataT<59>") getData("/RDataT<58>") getData("/RDataT<57>") getData("/RDataT<56>") getData("/RDataT<55>") getData("/RDataT<54>") getData("/RDataT<53>") getData("/RDataT<52>") getData("/RDataT<51>") getData("/RDataT<50>") getData("/RDataT<49>") getData("/RDataT<48>") getData("/RDataT<47>") getData("/RDataT<46>") getData("/RDataT<45>") getData("/RDataT<44>") getData("/RDataT<43>") getData("/RDataT<42>") getData("/RDataT<41>") getData("/RDataT<40>") getData("/RDataT<39>") getData("/RDataT<38>") getData("/RDataT<37>") getData("/RDataT<36>") getData("/RDataT<35>") getData("/RDataT<34>") getData("/RDataT<33>") getData("/RDataT<32>") getData("/RDataT<31>") getData("/RDataT<30>") getData("/RDataT<29>") getData("/RDataT<28>") getData("/RDataT<27>") getData("/RDataT<26>") getData("/RDataT<25>") getData("/RDataT<24>") getData("/RDataT<23>") getData("/RDataT<22>") getData("/RDataT<21>") getData("/RDataT<20>") getData("/RDataT<19>") getData("/RDataT<18>") getData("/RDataT<17>") getData("/RDataT<16>") getData("/WDataT<63>") getData("/WDataT<62>") getData("/WDataT<61>") getData("/WDataT<60>") getData("/WDataT<59>") getData("/WDataT<58>") getData("/WDataT<57>") getData("/WDataT<56>") getData("/WDataT<55>") getData("/WDataT<54>") getData("/WDataT<53>") getData("/WDataT<52>") getData("/WDataT<51>") getData("/WDataT<50>") getData("/WDataT<49>") getData("/WDataT<48>") getData("/WDataT<47>") getData("/WDataT<46>") getData("/WDataT<45>") getData("/WDataT<44>") getData("/WDataT<43>") getData("/WDataT<42>") getData("/WDataT<41>") getData("/WDataT<40>") getData("/WDataT<39>") getData("/WDataT<38>") getData("/WDataT<37>") getData("/WDataT<36>") getData("/WDataT<35>") getData("/WDataT<34>") getData("/WDataT<33>") getData("/WDataT<32>") getData("/WDataT<31>") getData("/WDataT<30>") getData("/WDataT<29>") getData("/WDataT<28>") getData("/WDataT<27>") getData("/WDataT<26>") getData("/WDataT<25>") getData("/WDataT<24>") getData("/WDataT<23>") getData("/WDataT<22>") getData("/WDataT<21>") getData("/WDataT<20>") getData("/WDataT<19>") getData("/WDataT<18>") getData("/WDataT<17>") getData("/WDataT<16>") )
resultsDir( "/net/bull/apps/Cadence/simulation/6T_MultiBank_32K_Test/spectreVerilog/config/distributed/job026" )
modelFile(
    '("/software/cadence/ncsu-FreePDK15/hspice_16nm_hp.include" "")
)
desVar(	  "vdd" .850	)
run( ?jobName "job" ?mail "rstdenis@ucdavis.edu" )
selectResult( 'tran )
plot(getData("/ReadEn") getData("/R_Address<11:0>") getData("/W_Address<11:0>") getData("/WriteEn") getData("/ReadAck") getData("/WriteAck") getData("/RAckT") getData("/WAckT") getData("/R_AddressT<11>") getData("/R_AddressT<10>") getData("/R_AddressT<9>") getData("/R_AddressT<8>") getData("/R_AddressT<7>") getData("/R_AddressT<6>") getData("/R_AddressT<5>") getData("/R_AddressT<4>") getData("/R_AddressT<3>") getData("/R_AddressT<2>") getData("/R_AddressT<1>") getData("/R_AddressT<0>") getData("/ReadEnT") getData("/W_AddressT<11>") getData("/W_AddressT<10>") getData("/W_AddressT<9>") getData("/W_AddressT<8>") getData("/W_AddressT<7>") getData("/W_AddressT<6>") getData("/W_AddressT<5>") getData("/W_AddressT<4>") getData("/W_AddressT<3>") getData("/W_AddressT<2>") getData("/W_AddressT<1>") getData("/W_AddressT<0>") getData("/WriteEnT") getData("/WDataAckT<7>") getData("/WDataAckT<6>") getData("/WDataAckT<5>") getData("/WDataAckT<4>") getData("/WDataAckT<3>") getData("/WDataAckT<2>") getData("/WDataAckT<1>") getData("/WDataAckT<0>") getData("/V0/MINUS") getData("/I21/WdBank0<31>") getData("/I21/WdBank0<30>") getData("/I21/WdBank0<29>") getData("/I21/WdBank0<28>") getData("/I21/WdBank0<27>") getData("/I21/WdBank0<26>") getData("/I21/WdBank0<25>") getData("/I21/WdBank0<24>") getData("/I21/WdBank0<23>") getData("/I21/WdBank0<22>") getData("/I21/WdBank0<21>") getData("/I21/WdBank0<20>") getData("/I21/WdBank0<19>") getData("/I21/WdBank0<18>") getData("/I21/WdBank0<17>") getData("/I21/WdBank0<16>") getData("/I21/WdBank0<15>") getData("/I21/WdBank0<14>") getData("/I21/WdBank0<13>") getData("/I21/WdBank0<12>") getData("/I21/WdBank0<11>") getData("/I21/WdBank0<10>") getData("/I21/WdBank0<9>") getData("/I21/WdBank0<8>") getData("/I21/WdBank0<7>") getData("/I21/WdBank0<6>") getData("/I21/WdBank0<5>") getData("/I21/WdBank0<4>") getData("/I21/WdBank0<3>") getData("/I21/WdBank0<2>") getData("/I21/WdBank0<1>") getData("/I21/WdBank0<0>") getData("/I21/Bank0WAck<7>") getData("/I21/Bank0WAck<6>") getData("/I21/Bank0WAck<5>") getData("/I21/Bank0WAck<4>") getData("/I21/Bank0WAck<3>") getData("/I21/Bank0WAck<2>") getData("/I21/Bank0WAck<1>") getData("/I21/Bank0WAck<0>") getData("/I21/WdBank1<31>") getData("/I21/WdBank1<30>") getData("/I21/WdBank1<29>") getData("/I21/WdBank1<28>") getData("/I21/WdBank1<27>") getData("/I21/WdBank1<26>") getData("/I21/WdBank1<25>") getData("/I21/WdBank1<24>") getData("/I21/WdBank1<23>") getData("/I21/WdBank1<22>") getData("/I21/WdBank1<21>") getData("/I21/WdBank1<20>") getData("/I21/WdBank1<19>") getData("/I21/WdBank1<18>") getData("/I21/WdBank1<17>") getData("/I21/WdBank1<16>") getData("/I21/WdBank1<15>") getData("/I21/WdBank1<14>") getData("/I21/WdBank1<13>") getData("/I21/WdBank1<12>") getData("/I21/WdBank1<11>") getData("/I21/WdBank1<10>") getData("/I21/WdBank1<9>") getData("/I21/WdBank1<8>") getData("/I21/WdBank1<7>") getData("/I21/WdBank1<6>") getData("/I21/WdBank1<5>") getData("/I21/WdBank1<4>") getData("/I21/WdBank1<3>") getData("/I21/WdBank1<2>") getData("/I21/WdBank1<1>") getData("/I21/WdBank1<0>") getData("/I21/Bank1WAck<7>") getData("/I21/Bank1WAck<6>") getData("/I21/Bank1WAck<5>") getData("/I21/Bank1WAck<4>") getData("/I21/Bank1WAck<3>") getData("/I21/Bank1WAck<2>") getData("/I21/Bank1WAck<1>") getData("/I21/Bank1WAck<0>") getData("/I21/WdBank2<31>") getData("/I21/WdBank2<30>") getData("/I21/WdBank2<29>") getData("/I21/WdBank2<28>") getData("/I21/WdBank2<27>") getData("/I21/WdBank2<26>") getData("/I21/WdBank2<25>") getData("/I21/WdBank2<24>") getData("/I21/WdBank2<23>") getData("/I21/WdBank2<22>") getData("/I21/WdBank2<21>") getData("/I21/WdBank2<20>") getData("/I21/WdBank2<19>") getData("/I21/WdBank2<18>") getData("/I21/WdBank2<17>") getData("/I21/WdBank2<16>") getData("/I21/WdBank2<15>") getData("/I21/WdBank2<14>") getData("/I21/WdBank2<13>") getData("/I21/WdBank2<12>") getData("/I21/WdBank2<11>") getData("/I21/WdBank2<10>") getData("/I21/WdBank2<9>") getData("/I21/WdBank2<8>") getData("/I21/WdBank2<7>") getData("/I21/WdBank2<6>") getData("/I21/WdBank2<5>") getData("/I21/WdBank2<4>") getData("/I21/WdBank2<3>") getData("/I21/WdBank2<2>") getData("/I21/WdBank2<1>") getData("/I21/WdBank2<0>") getData("/I21/Bank2WAck<7>") getData("/I21/Bank2WAck<6>") getData("/I21/Bank2WAck<5>") getData("/I21/Bank2WAck<4>") getData("/I21/Bank2WAck<3>") getData("/I21/Bank2WAck<2>") getData("/I21/Bank2WAck<1>") getData("/I21/Bank2WAck<0>") getData("/I21/WdBank3<31>") getData("/I21/WdBank3<30>") getData("/I21/WdBank3<29>") getData("/I21/WdBank3<28>") getData("/I21/WdBank3<27>") getData("/I21/WdBank3<26>") getData("/I21/WdBank3<25>") getData("/I21/WdBank3<24>") getData("/I21/WdBank3<23>") getData("/I21/WdBank3<22>") getData("/I21/WdBank3<21>") getData("/I21/WdBank3<20>") getData("/I21/WdBank3<19>") getData("/I21/WdBank3<18>") getData("/I21/WdBank3<17>") getData("/I21/WdBank3<16>") getData("/I21/WdBank3<15>") getData("/I21/WdBank3<14>") getData("/I21/WdBank3<13>") getData("/I21/WdBank3<12>") getData("/I21/WdBank3<11>") getData("/I21/WdBank3<10>") getData("/I21/WdBank3<9>") getData("/I21/WdBank3<8>") getData("/I21/WdBank3<7>") getData("/I21/WdBank3<6>") getData("/I21/WdBank3<5>") getData("/I21/WdBank3<4>") getData("/I21/WdBank3<3>") getData("/I21/WdBank3<2>") getData("/I21/WdBank3<1>") getData("/I21/WdBank3<0>") getData("/I21/Bank3WAck<7>") getData("/I21/Bank3WAck<6>") getData("/I21/Bank3WAck<5>") getData("/I21/Bank3WAck<4>") getData("/I21/Bank3WAck<3>") getData("/I21/Bank3WAck<2>") getData("/I21/Bank3WAck<1>") getData("/I21/Bank3WAck<0>") getData("/I21/net0201") getData("/I21/net0205") getData("/I21/net018") getData("/I21/net017") getData("/I21/net022") getData("/I21/net021") getData("/I21/net020") getData("/I21/net019") getData("/I21/RdBank0<31>") getData("/I21/RdBank0<30>") getData("/I21/RdBank0<29>") getData("/I21/RdBank0<28>") getData("/I21/RdBank0<27>") getData("/I21/RdBank0<26>") getData("/I21/RdBank0<25>") getData("/I21/RdBank0<24>") getData("/I21/RdBank0<23>") getData("/I21/RdBank0<22>") getData("/I21/RdBank0<21>") getData("/I21/RdBank0<20>") getData("/I21/RdBank0<19>") getData("/I21/RdBank0<18>") getData("/I21/RdBank0<17>") getData("/I21/RdBank0<16>") getData("/I21/RdBank0<15>") getData("/I21/RdBank0<14>") getData("/I21/RdBank0<13>") getData("/I21/RdBank0<12>") getData("/I21/RdBank0<11>") getData("/I21/RdBank0<10>") getData("/I21/RdBank0<9>") getData("/I21/RdBank0<8>") getData("/I21/RdBank0<7>") getData("/I21/RdBank0<6>") getData("/I21/RdBank0<5>") getData("/I21/RdBank0<4>") getData("/I21/RdBank0<3>") getData("/I21/RdBank0<2>") getData("/I21/RdBank0<1>") getData("/I21/RdBank0<0>") getData("/I21/RdBank0Ack<7>") getData("/I21/RdBank0Ack<6>") getData("/I21/RdBank0Ack<5>") getData("/I21/RdBank0Ack<4>") getData("/I21/RdBank0Ack<3>") getData("/I21/RdBank0Ack<2>") getData("/I21/RdBank0Ack<1>") getData("/I21/RdBank0Ack<0>") getData("/I21/RdBank1<31>") getData("/I21/RdBank1<30>") getData("/I21/RdBank1<29>") getData("/I21/RdBank1<28>") getData("/I21/RdBank1<27>") getData("/I21/RdBank1<26>") getData("/I21/RdBank1<25>") getData("/I21/RdBank1<24>") getData("/I21/RdBank1<23>") getData("/I21/RdBank1<22>") getData("/I21/RdBank1<21>") getData("/I21/RdBank1<20>") getData("/I21/RdBank1<19>") getData("/I21/RdBank1<18>") getData("/I21/RdBank1<17>") getData("/I21/RdBank1<16>") getData("/I21/RdBank1<15>") getData("/I21/RdBank1<14>") getData("/I21/RdBank1<13>") getData("/I21/RdBank1<12>") getData("/I21/RdBank1<11>") getData("/I21/RdBank1<10>") getData("/I21/RdBank1<9>") getData("/I21/RdBank1<8>") getData("/I21/RdBank1<7>") getData("/I21/RdBank1<6>") getData("/I21/RdBank1<5>") getData("/I21/RdBank1<4>") getData("/I21/RdBank1<3>") getData("/I21/RdBank1<2>") getData("/I21/RdBank1<1>") getData("/I21/RdBank1<0>") getData("/I21/RdBank1Ack<7>") getData("/I21/RdBank1Ack<6>") getData("/I21/RdBank1Ack<5>") getData("/I21/RdBank1Ack<4>") getData("/I21/RdBank1Ack<3>") getData("/I21/RdBank1Ack<2>") getData("/I21/RdBank1Ack<1>") getData("/I21/RdBank1Ack<0>") getData("/Data1<63:0>") getData("/WDataAck<31:0>") getData("/RData<63:0>") getData("/RDataT<63>") getData("/RDataT<62>") getData("/RDataT<61>") getData("/RDataT<60>") getData("/RDataT<59>") getData("/RDataT<58>") getData("/RDataT<57>") getData("/RDataT<56>") getData("/RDataT<55>") getData("/RDataT<54>") getData("/RDataT<53>") getData("/RDataT<52>") getData("/RDataT<51>") getData("/RDataT<50>") getData("/RDataT<49>") getData("/RDataT<48>") getData("/RDataT<47>") getData("/RDataT<46>") getData("/RDataT<45>") getData("/RDataT<44>") getData("/RDataT<43>") getData("/RDataT<42>") getData("/RDataT<41>") getData("/RDataT<40>") getData("/RDataT<39>") getData("/RDataT<38>") getData("/RDataT<37>") getData("/RDataT<36>") getData("/RDataT<35>") getData("/RDataT<34>") getData("/RDataT<33>") getData("/RDataT<32>") getData("/RDataT<31>") getData("/RDataT<30>") getData("/RDataT<29>") getData("/RDataT<28>") getData("/RDataT<27>") getData("/RDataT<26>") getData("/RDataT<25>") getData("/RDataT<24>") getData("/RDataT<23>") getData("/RDataT<22>") getData("/RDataT<21>") getData("/RDataT<20>") getData("/RDataT<19>") getData("/RDataT<18>") getData("/RDataT<17>") getData("/RDataT<16>") getData("/WDataT<63>") getData("/WDataT<62>") getData("/WDataT<61>") getData("/WDataT<60>") getData("/WDataT<59>") getData("/WDataT<58>") getData("/WDataT<57>") getData("/WDataT<56>") getData("/WDataT<55>") getData("/WDataT<54>") getData("/WDataT<53>") getData("/WDataT<52>") getData("/WDataT<51>") getData("/WDataT<50>") getData("/WDataT<49>") getData("/WDataT<48>") getData("/WDataT<47>") getData("/WDataT<46>") getData("/WDataT<45>") getData("/WDataT<44>") getData("/WDataT<43>") getData("/WDataT<42>") getData("/WDataT<41>") getData("/WDataT<40>") getData("/WDataT<39>") getData("/WDataT<38>") getData("/WDataT<37>") getData("/WDataT<36>") getData("/WDataT<35>") getData("/WDataT<34>") getData("/WDataT<33>") getData("/WDataT<32>") getData("/WDataT<31>") getData("/WDataT<30>") getData("/WDataT<29>") getData("/WDataT<28>") getData("/WDataT<27>") getData("/WDataT<26>") getData("/WDataT<25>") getData("/WDataT<24>") getData("/WDataT<23>") getData("/WDataT<22>") getData("/WDataT<21>") getData("/WDataT<20>") getData("/WDataT<19>") getData("/WDataT<18>") getData("/WDataT<17>") getData("/WDataT<16>") )
hostMode( 'local )
resultsDir( "/net/bull/apps/Cadence/simulation/6T_MultiBank_32K_Test/spectreVerilog/config" )
modelFile(
    '("/software/cadence/ncsu-FreePDK15/hspice_16nm_hp.include" "")
)
desVar(	  "vdd" .675	)
option(	'temp  "30.0"
)
temp( 30.0 )
run()
selectResult( 'tran )
plot(getData("/ReadEn") getData("/R_Address<11:0>") getData("/W_Address<11:0>") getData("/WriteEn") getData("/ReadAck") getData("/WriteAck") getData("/RAckT") getData("/WAckT") getData("/R_AddressT<11>") getData("/R_AddressT<10>") getData("/R_AddressT<9>") getData("/R_AddressT<8>") getData("/R_AddressT<7>") getData("/R_AddressT<6>") getData("/R_AddressT<5>") getData("/R_AddressT<4>") getData("/R_AddressT<3>") getData("/R_AddressT<2>") getData("/R_AddressT<1>") getData("/R_AddressT<0>") getData("/ReadEnT") getData("/W_AddressT<11>") getData("/W_AddressT<10>") getData("/W_AddressT<9>") getData("/W_AddressT<8>") getData("/W_AddressT<7>") getData("/W_AddressT<6>") getData("/W_AddressT<5>") getData("/W_AddressT<4>") getData("/W_AddressT<3>") getData("/W_AddressT<2>") getData("/W_AddressT<1>") getData("/W_AddressT<0>") getData("/WriteEnT") getData("/WDataAckT<7>") getData("/WDataAckT<6>") getData("/WDataAckT<5>") getData("/WDataAckT<4>") getData("/WDataAckT<3>") getData("/WDataAckT<2>") getData("/WDataAckT<1>") getData("/WDataAckT<0>") getData("/V0/MINUS") getData("/I21/WdBank0<31>") getData("/I21/WdBank0<30>") getData("/I21/WdBank0<29>") getData("/I21/WdBank0<28>") getData("/I21/WdBank0<27>") getData("/I21/WdBank0<26>") getData("/I21/WdBank0<25>") getData("/I21/WdBank0<24>") getData("/I21/WdBank0<23>") getData("/I21/WdBank0<22>") getData("/I21/WdBank0<21>") getData("/I21/WdBank0<20>") getData("/I21/WdBank0<19>") getData("/I21/WdBank0<18>") getData("/I21/WdBank0<17>") getData("/I21/WdBank0<16>") getData("/I21/WdBank0<15>") getData("/I21/WdBank0<14>") getData("/I21/WdBank0<13>") getData("/I21/WdBank0<12>") getData("/I21/WdBank0<11>") getData("/I21/WdBank0<10>") getData("/I21/WdBank0<9>") getData("/I21/WdBank0<8>") getData("/I21/WdBank0<7>") getData("/I21/WdBank0<6>") getData("/I21/WdBank0<5>") getData("/I21/WdBank0<4>") getData("/I21/WdBank0<3>") getData("/I21/WdBank0<2>") getData("/I21/WdBank0<1>") getData("/I21/WdBank0<0>") getData("/I21/Bank0WAck<7>") getData("/I21/Bank0WAck<6>") getData("/I21/Bank0WAck<5>") getData("/I21/Bank0WAck<4>") getData("/I21/Bank0WAck<3>") getData("/I21/Bank0WAck<2>") getData("/I21/Bank0WAck<1>") getData("/I21/Bank0WAck<0>") getData("/I21/WdBank1<31>") getData("/I21/WdBank1<30>") getData("/I21/WdBank1<29>") getData("/I21/WdBank1<28>") getData("/I21/WdBank1<27>") getData("/I21/WdBank1<26>") getData("/I21/WdBank1<25>") getData("/I21/WdBank1<24>") getData("/I21/WdBank1<23>") getData("/I21/WdBank1<22>") getData("/I21/WdBank1<21>") getData("/I21/WdBank1<20>") getData("/I21/WdBank1<19>") getData("/I21/WdBank1<18>") getData("/I21/WdBank1<17>") getData("/I21/WdBank1<16>") getData("/I21/WdBank1<15>") getData("/I21/WdBank1<14>") getData("/I21/WdBank1<13>") getData("/I21/WdBank1<12>") getData("/I21/WdBank1<11>") getData("/I21/WdBank1<10>") getData("/I21/WdBank1<9>") getData("/I21/WdBank1<8>") getData("/I21/WdBank1<7>") getData("/I21/WdBank1<6>") getData("/I21/WdBank1<5>") getData("/I21/WdBank1<4>") getData("/I21/WdBank1<3>") getData("/I21/WdBank1<2>") getData("/I21/WdBank1<1>") getData("/I21/WdBank1<0>") getData("/I21/Bank1WAck<7>") getData("/I21/Bank1WAck<6>") getData("/I21/Bank1WAck<5>") getData("/I21/Bank1WAck<4>") getData("/I21/Bank1WAck<3>") getData("/I21/Bank1WAck<2>") getData("/I21/Bank1WAck<1>") getData("/I21/Bank1WAck<0>") getData("/I21/WdBank2<31>") getData("/I21/WdBank2<30>") getData("/I21/WdBank2<29>") getData("/I21/WdBank2<28>") getData("/I21/WdBank2<27>") getData("/I21/WdBank2<26>") getData("/I21/WdBank2<25>") getData("/I21/WdBank2<24>") getData("/I21/WdBank2<23>") getData("/I21/WdBank2<22>") getData("/I21/WdBank2<21>") getData("/I21/WdBank2<20>") getData("/I21/WdBank2<19>") getData("/I21/WdBank2<18>") getData("/I21/WdBank2<17>") getData("/I21/WdBank2<16>") getData("/I21/WdBank2<15>") getData("/I21/WdBank2<14>") getData("/I21/WdBank2<13>") getData("/I21/WdBank2<12>") getData("/I21/WdBank2<11>") getData("/I21/WdBank2<10>") getData("/I21/WdBank2<9>") getData("/I21/WdBank2<8>") getData("/I21/WdBank2<7>") getData("/I21/WdBank2<6>") getData("/I21/WdBank2<5>") getData("/I21/WdBank2<4>") getData("/I21/WdBank2<3>") getData("/I21/WdBank2<2>") getData("/I21/WdBank2<1>") getData("/I21/WdBank2<0>") getData("/I21/Bank2WAck<7>") getData("/I21/Bank2WAck<6>") getData("/I21/Bank2WAck<5>") getData("/I21/Bank2WAck<4>") getData("/I21/Bank2WAck<3>") getData("/I21/Bank2WAck<2>") getData("/I21/Bank2WAck<1>") getData("/I21/Bank2WAck<0>") getData("/I21/WdBank3<31>") getData("/I21/WdBank3<30>") getData("/I21/WdBank3<29>") getData("/I21/WdBank3<28>") getData("/I21/WdBank3<27>") getData("/I21/WdBank3<26>") getData("/I21/WdBank3<25>") getData("/I21/WdBank3<24>") getData("/I21/WdBank3<23>") getData("/I21/WdBank3<22>") getData("/I21/WdBank3<21>") getData("/I21/WdBank3<20>") getData("/I21/WdBank3<19>") getData("/I21/WdBank3<18>") getData("/I21/WdBank3<17>") getData("/I21/WdBank3<16>") getData("/I21/WdBank3<15>") getData("/I21/WdBank3<14>") getData("/I21/WdBank3<13>") getData("/I21/WdBank3<12>") getData("/I21/WdBank3<11>") getData("/I21/WdBank3<10>") getData("/I21/WdBank3<9>") getData("/I21/WdBank3<8>") getData("/I21/WdBank3<7>") getData("/I21/WdBank3<6>") getData("/I21/WdBank3<5>") getData("/I21/WdBank3<4>") getData("/I21/WdBank3<3>") getData("/I21/WdBank3<2>") getData("/I21/WdBank3<1>") getData("/I21/WdBank3<0>") getData("/I21/Bank3WAck<7>") getData("/I21/Bank3WAck<6>") getData("/I21/Bank3WAck<5>") getData("/I21/Bank3WAck<4>") getData("/I21/Bank3WAck<3>") getData("/I21/Bank3WAck<2>") getData("/I21/Bank3WAck<1>") getData("/I21/Bank3WAck<0>") getData("/I21/net0201") getData("/I21/net0205") getData("/I21/net018") getData("/I21/net017") getData("/I21/net022") getData("/I21/net021") getData("/I21/net020") getData("/I21/net019") getData("/I21/RdBank0<31>") getData("/I21/RdBank0<30>") getData("/I21/RdBank0<29>") getData("/I21/RdBank0<28>") getData("/I21/RdBank0<27>") getData("/I21/RdBank0<26>") getData("/I21/RdBank0<25>") getData("/I21/RdBank0<24>") getData("/I21/RdBank0<23>") getData("/I21/RdBank0<22>") getData("/I21/RdBank0<21>") getData("/I21/RdBank0<20>") getData("/I21/RdBank0<19>") getData("/I21/RdBank0<18>") getData("/I21/RdBank0<17>") getData("/I21/RdBank0<16>") getData("/I21/RdBank0<15>") getData("/I21/RdBank0<14>") getData("/I21/RdBank0<13>") getData("/I21/RdBank0<12>") getData("/I21/RdBank0<11>") getData("/I21/RdBank0<10>") getData("/I21/RdBank0<9>") getData("/I21/RdBank0<8>") getData("/I21/RdBank0<7>") getData("/I21/RdBank0<6>") getData("/I21/RdBank0<5>") getData("/I21/RdBank0<4>") getData("/I21/RdBank0<3>") getData("/I21/RdBank0<2>") getData("/I21/RdBank0<1>") getData("/I21/RdBank0<0>") getData("/I21/RdBank0Ack<7>") getData("/I21/RdBank0Ack<6>") getData("/I21/RdBank0Ack<5>") getData("/I21/RdBank0Ack<4>") getData("/I21/RdBank0Ack<3>") getData("/I21/RdBank0Ack<2>") getData("/I21/RdBank0Ack<1>") getData("/I21/RdBank0Ack<0>") getData("/I21/RdBank1<31>") getData("/I21/RdBank1<30>") getData("/I21/RdBank1<29>") getData("/I21/RdBank1<28>") getData("/I21/RdBank1<27>") getData("/I21/RdBank1<26>") getData("/I21/RdBank1<25>") getData("/I21/RdBank1<24>") getData("/I21/RdBank1<23>") getData("/I21/RdBank1<22>") getData("/I21/RdBank1<21>") getData("/I21/RdBank1<20>") getData("/I21/RdBank1<19>") getData("/I21/RdBank1<18>") getData("/I21/RdBank1<17>") getData("/I21/RdBank1<16>") getData("/I21/RdBank1<15>") getData("/I21/RdBank1<14>") getData("/I21/RdBank1<13>") getData("/I21/RdBank1<12>") getData("/I21/RdBank1<11>") getData("/I21/RdBank1<10>") getData("/I21/RdBank1<9>") getData("/I21/RdBank1<8>") getData("/I21/RdBank1<7>") getData("/I21/RdBank1<6>") getData("/I21/RdBank1<5>") getData("/I21/RdBank1<4>") getData("/I21/RdBank1<3>") getData("/I21/RdBank1<2>") getData("/I21/RdBank1<1>") getData("/I21/RdBank1<0>") getData("/I21/RdBank1Ack<7>") getData("/I21/RdBank1Ack<6>") getData("/I21/RdBank1Ack<5>") getData("/I21/RdBank1Ack<4>") getData("/I21/RdBank1Ack<3>") getData("/I21/RdBank1Ack<2>") getData("/I21/RdBank1Ack<1>") getData("/I21/RdBank1Ack<0>") getData("/Data1<63:0>") getData("/WDataAck<31:0>") getData("/RData<63:0>") getData("/RDataT<63>") getData("/RDataT<62>") getData("/RDataT<61>") getData("/RDataT<60>") getData("/RDataT<59>") getData("/RDataT<58>") getData("/RDataT<57>") getData("/RDataT<56>") getData("/RDataT<55>") getData("/RDataT<54>") getData("/RDataT<53>") getData("/RDataT<52>") getData("/RDataT<51>") getData("/RDataT<50>") getData("/RDataT<49>") getData("/RDataT<48>") getData("/RDataT<47>") getData("/RDataT<46>") getData("/RDataT<45>") getData("/RDataT<44>") getData("/RDataT<43>") getData("/RDataT<42>") getData("/RDataT<41>") getData("/RDataT<40>") getData("/RDataT<39>") getData("/RDataT<38>") getData("/RDataT<37>") getData("/RDataT<36>") getData("/RDataT<35>") getData("/RDataT<34>") getData("/RDataT<33>") getData("/RDataT<32>") getData("/RDataT<31>") getData("/RDataT<30>") getData("/RDataT<29>") getData("/RDataT<28>") getData("/RDataT<27>") getData("/RDataT<26>") getData("/RDataT<25>") getData("/RDataT<24>") getData("/RDataT<23>") getData("/RDataT<22>") getData("/RDataT<21>") getData("/RDataT<20>") getData("/RDataT<19>") getData("/RDataT<18>") getData("/RDataT<17>") getData("/RDataT<16>") getData("/WDataT<63>") getData("/WDataT<62>") getData("/WDataT<61>") getData("/WDataT<60>") getData("/WDataT<59>") getData("/WDataT<58>") getData("/WDataT<57>") getData("/WDataT<56>") getData("/WDataT<55>") getData("/WDataT<54>") getData("/WDataT<53>") getData("/WDataT<52>") getData("/WDataT<51>") getData("/WDataT<50>") getData("/WDataT<49>") getData("/WDataT<48>") getData("/WDataT<47>") getData("/WDataT<46>") getData("/WDataT<45>") getData("/WDataT<44>") getData("/WDataT<43>") getData("/WDataT<42>") getData("/WDataT<41>") getData("/WDataT<40>") getData("/WDataT<39>") getData("/WDataT<38>") getData("/WDataT<37>") getData("/WDataT<36>") getData("/WDataT<35>") getData("/WDataT<34>") getData("/WDataT<33>") getData("/WDataT<32>") getData("/WDataT<31>") getData("/WDataT<30>") getData("/WDataT<29>") getData("/WDataT<28>") getData("/WDataT<27>") getData("/WDataT<26>") getData("/WDataT<25>") getData("/WDataT<24>") getData("/WDataT<23>") getData("/WDataT<22>") getData("/WDataT<21>") getData("/WDataT<20>") getData("/WDataT<19>") getData("/WDataT<18>") getData("/WDataT<17>") getData("/WDataT<16>") )
