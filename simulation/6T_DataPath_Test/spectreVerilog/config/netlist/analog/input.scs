// Design: 16nm_Tests/6T_DataPath_Test
simulator lang=spectre
global 0 vdd! vcc!
parameters vdd=0.850
include "/software/cadence/ncsu-FreePDK15/hspice_16nm_hp.include"

// 16nm/inv_1x/schematic
//system verilogNetlist schematic cmos.sch cmos_sch veriloga ahdl
subckt inv_1x A Y
    M0 (Y A 0 0) nfet w=60n l=20n nfin=1 m=1 degradation=no
    M1 (Y A vdd! vdd!) pfet w=100n l=20n nfin=1 m=1 degradation=no
ends inv_1x

// 16nm/TH22~/schematic
//system verilogNetlist schematic cmos.sch cmos_sch veriloga ahdl
subckt _sub132 A B Y
    I6 (net010 Y) inv_1x
    M5 (net010 net5 0 0) nfet w=48n l=16n nfin=1 m=1 degradation=no
    M4 (net5 net010 net9 0) nfet w=48n l=16n nfin=1 m=1 degradation=no
    M3 (net9 B 0 0) nfet w=48n l=16n nfin=1 m=1 degradation=no
    M2 (net9 A 0 0) nfet w=48n l=16n nfin=1 m=1 degradation=no
    M1 (net5 B net17 0) nfet w=80n l=16n nfin=1 m=1 degradation=no
    M0 (net17 A 0 0) nfet w=80n l=16n nfin=1 m=1 degradation=no
    M11 (net010 net5 vdd! vdd!) pfet w=80n l=16n nfin=1 m=1 degradation=yes
    M10 (net5 B net032 vdd!) pfet w=160n l=16n nfin=1 m=1 degradation=yes
    M9 (net032 A vdd! vdd!) pfet w=160n l=16n nfin=1 m=1 degradation=yes
    M8 (net037 B vdd! vdd!) pfet w=80n l=16n nfin=1 m=1 degradation=yes
    M7 (net037 A vdd! vdd!) pfet w=80n l=16n nfin=1 m=1 degradation=yes
    M6 (net5 net010 net037 vdd!) pfet w=80n l=16n nfin=1 m=1 degradation=yes
ends _sub132

// 16nm/nand_1x/schematic
//system verilogNetlist schematic cmos.sch cmos_sch veriloga ahdl
subckt nand_1x A B Y
    M1 (Y B vdd! vdd!) pfet w=100n l=20n nfin=1 m=1 degradation=no
    M0 (Y A vdd! vdd!) pfet w=100n l=20n nfin=1 m=1 degradation=no
    M3 (net22 B 0 0) nfet w=120n l=20n nfin=1 m=1 degradation=no
    M2 (Y A net22 0) nfet w=120n l=20n nfin=1 m=1 degradation=no
ends nand_1x

// 16nm/nor_1x/schematic
//system verilogNetlist schematic cmos.sch cmos_sch veriloga ahdl
subckt nor_1x A B Y
    M3 (Y B or_pd_ps vdd!) pfet w=200n l=20n nfin=1 m=1 degradation=yes
    M2 (or_pd_ps A vdd! vdd!) pfet w=200n l=20n nfin=1 m=1 degradation=yes
    M1 (Y B 0 0) nfet w=60n l=20n nfin=1 m=1 degradation=no
    M0 (Y A 0 0) nfet w=60n l=20n nfin=1 m=1 degradation=no
ends nor_1x

// 16nm/or_1x/schematic
//system verilogNetlist schematic cmos.sch cmos_sch veriloga ahdl
subckt or_1x A B Y
    I6 (A B AnorB) nor_1x
    I7 (AnorB Y) inv_1x
ends or_1x

// 16nm/inv_weak_1x/schematic
//system verilogNetlist schematic cmos.sch cmos_sch veriloga ahdl
subckt inv_weak_1x A Y
    M2 (net13 vdd! 0 0) nfet w=60n l=20n nfin=1 ls=105n m=1 degradation=no
    M0 (Y A net13 0) nfet w=60n l=20n nfin=1 ls=105n m=1 degradation=no
    M3 (net14 0 vdd! vdd!) pfet w=100n l=20n nfin=1 m=1 degradation=yes
    M1 (Y A net14 vdd!) pfet w=100n l=20n nfin=1 m=1 degradation=yes
ends inv_weak_1x

// 16nm/TH22/schematic
//system verilogNetlist schematic cmos.sch cmos_sch veriloga ahdl
subckt TH22 A B Y
    M5 (Y net5 0 0) nfet w=60n l=20n nfin=1 m=1 degradation=no
    M4 (net5 Y net9 0) nfet w=120n l=20n nfin=1 m=1 degradation=no
    M3 (net9 B 0 0) nfet w=120n l=20n nfin=1 m=1 degradation=no
    M2 (net9 A 0 0) nfet w=120n l=20n nfin=1 m=1 degradation=no
    M1 (net5 B net17 0) nfet w=120n l=20n nfin=1 m=1 degradation=no
    M0 (net17 A 0 0) nfet w=120n l=20n nfin=1 m=1 degradation=no
    M11 (Y net5 vdd! vdd!) pfet w=100n l=20n nfin=1 m=1 degradation=yes
    M10 (net5 B net032 vdd!) pfet w=200n l=20n nfin=1 m=1 degradation=yes
    M9 (net032 A vdd! vdd!) pfet w=200n l=20n nfin=1 m=1 degradation=yes
    M8 (net037 B vdd! vdd!) pfet w=200n l=20n nfin=1 m=1 degradation=yes
    M7 (net037 A vdd! vdd!) pfet w=200n l=20n nfin=1 m=1 degradation=yes
    M6 (net5 Y net037 vdd!) pfet w=200n l=20n nfin=1 m=1 degradation=yes
ends TH22

// 16nm/PCHBd/schematic
//system verilogNetlist schematic cmos.sch cmos_sch veriloga ahdl
subckt PCHBd Ai Ai\+1 R0i R0i\+1 R1i R1i\+1
    I32 (net019 R0i\+1) inv_1x
    I5 (net032 R1i\+1) inv_1x
    I12 (net031 net030 Ai) _sub132
    M16 (net019 R0i net034 0) nfet w=60n l=20n nfin=1 m=1 degradation=no
    M3 (net032 R1i net033 0) nfet w=60n l=20n nfin=1 m=1 degradation=no
    M4 (net034 net022 0 0) nfet w=60n l=20n nfin=1 m=1 degradation=no
    M5 (net033 net022 0 0) nfet w=60n l=20n nfin=1 m=1 degradation=no
    M10 (net019 net022 vdd! vdd!) pfet w=200n l=20n nfin=1 m=1 degradation=yes
    M1 (net032 net022 vdd! vdd!) pfet w=200n l=20n nfin=1 m=1 degradation=yes
    I6 (net032 net019 net031) nand_1x
    I9 (R0i R1i net030) or_1x
    I2 (R0i\+1 net019) inv_weak_1x
    I33 (R1i\+1 net032) inv_weak_1x
    I30 (Ai Ai\+1 net022) TH22
ends PCHBd

// 16nm/WCHB/schematic
//system verilogNetlist schematic cmos.sch cmos_sch veriloga ahdl
subckt WCHB L0 L1 Lack R0 R1 Rack
    I1 (Rack L1 R1) TH22
    I0 (L0 Rack R0) TH22
    I6 (R1 R0 Lack) nor_1x
ends WCHB

// 16nm/TH44/schematic
//system verilogNetlist schematic cmos.sch cmos_sch veriloga ahdl
subckt TH44 A B C D Y
    M19 (net13 A 0 0) nfet w=120n l=20n nfin=1 m=1 degradation=no
    M18 (net13 B 0 0) nfet w=120n l=20n nfin=1 m=1 degradation=no
    M17 (net13 C 0 0) nfet w=120n l=20n nfin=1 m=1 degradation=no
    M16 (net13 D 0 0) nfet w=120n l=20n nfin=1 m=1 degradation=no
    M15 (Y net19 0 0) nfet w=60n l=20n nfin=1 m=1 degradation=no
    M14 (net42 A 0 0) nfet w=240n l=20n nfin=1 m=1 degradation=no
    M13 (net43 B net42 0) nfet w=240n l=20n nfin=1 m=1 degradation=no
    M12 (net44 C net43 0) nfet w=240n l=20n nfin=1 m=1 degradation=no
    M11 (net19 D net44 0) nfet w=240n l=20n nfin=1 m=1 degradation=no
    M10 (net19 Y net13 0) nfet w=120n l=20n nfin=1 m=1 degradation=no
    M9 (Y net19 vdd! vdd!) pfet w=100n l=20n nfin=1 m=1 degradation=yes
    M8 (net19 Y net15 vdd!) pfet w=200n l=20n nfin=1 m=1 degradation=yes
    M7 (net15 D vdd! vdd!) pfet w=200n l=20n nfin=1 m=1 degradation=yes
    M6 (net15 C vdd! vdd!) pfet w=200n l=20n nfin=1 m=1 degradation=yes
    M5 (net15 B vdd! vdd!) pfet w=200n l=20n nfin=1 m=1 degradation=yes
    M4 (net15 A vdd! vdd!) pfet w=200n l=20n nfin=1 m=1 degradation=yes
    M3 (net19 D net45 vdd!) pfet w=320n l=20n nfin=1 m=1 degradation=yes
    M2 (net45 C net46 vdd!) pfet w=320n l=20n nfin=1 m=1 degradation=yes
    M1 (net46 B net47 vdd!) pfet w=320n l=20n nfin=1 m=1 degradation=yes
    M0 (net47 A vdd! vdd!) pfet w=320n l=20n nfin=1 m=1 degradation=yes
ends TH44

// 16nm/and_1x/schematic
//system verilogNetlist schematic cmos.sch cmos_sch veriloga ahdl
subckt and_1x A B Y
    I7 (A B ntYbar) nand_1x
    I6 (ntYbar Y) inv_1x
ends and_1x

// 16nm/THaC/schematic
//system verilogNetlist schematic cmos.sch cmos_sch veriloga ahdl
subckt THaC A B\+ C\- Y
    M8 (net11 A 0 A) nfet w=120n l=20n nfin=1 m=1 degradation=no
    M5 (net7 A net33 A) nfet w=120n l=20n nfin=1 m=1 degradation=no
    M6 (net7 net021 net11 net021) nfet w=120n l=20n nfin=1 m=1 degradation=no
    M9 (net11 C\- 0 C\-) nfet w=120n l=20n nfin=1 m=1 degradation=no
    M7 (net33 \~B\+ 0 \~B\+) nfet w=120n l=20n nfin=1 m=1 degradation=no
    I2 (net7 net021) inv_1x
    I9 (B\+ \~B\+) inv_1x
    I8 (net021 Y) inv_1x
    M4 (net7 net021 net17 net021) pfet w=100n l=20n nfin=1 m=1 degradation=yes
    M3 (net7 C\- net32 C\-) pfet w=100n l=20n nfin=1 m=1 degradation=yes
    M0 (net32 A vdd! A) pfet w=100n l=20n nfin=1 m=1 degradation=yes
    M2 (net17 \~B\+ vdd! \~B\+) pfet w=100n l=20n nfin=1 m=1 degradation=yes
    M1 (net17 A vdd! A) pfet w=100n l=20n nfin=1 m=1 degradation=yes
ends THaC

// 16nm/PCHB_FIFO/schematic
//system verilogNetlist schematic cmos.sch cmos_sch veriloga ahdl
subckt PCHB_FIFO outAck R0i R0i\+1 R1i R1i\+1 W0 W1
    I5 (net029 R1i\+1) inv_1x
    I4 (net18 R0i\+1) inv_1x
    I12 (inValid inAck outValid outAck) THaC
    M5 (net026 oE 0 0) nfet w=60n l=20n nfin=1 m=1 degradation=no
    M4 (net22 oE 0 0) nfet w=60n l=20n nfin=1 m=1 degradation=no
    M3 (net029 R1i net026 0) nfet w=60n l=20n nfin=1 m=1 degradation=no
    M2 (net18 R0i net22 0) nfet w=60n l=20n nfin=1 m=1 degradation=no
    M1 (net029 oE vdd! vdd!) pfet w=200n l=20n nfin=1 m=1 degradation=yes
    M0 (net18 oE vdd! vdd!) pfet w=200n l=20n nfin=1 m=1 degradation=yes
    I6 (net029 net18 outValid) nand_1x
    I9 (R0i R1i inValid) or_1x
    I2 (R0i\+1 net18) inv_weak_1x
    I3 (R1i\+1 net029) inv_weak_1x
    I11 (outAck inAck oE) TH22
    I31 (W1 W0 inAck) nor_1x
ends PCHB_FIFO

// 16nm/WCHB~/schematic
//system verilogNetlist schematic cmos.sch cmos_sch veriloga ahdl
subckt _sub133 L0 L1 Lack Rack \~R0 \~R1
    I15 (net18 Lack) inv_1x
    I2 (\~R1 \~R0 net18) nand_1x
    I10 (Rack L1 \~R1) _sub132
    I0 (L0 Rack \~R0) _sub132
ends _sub133

// 16nm/6T_DATA/schematic
//system verilogNetlist schematic cmos.sch cmos_sch veriloga ahdl
subckt _sub134 Ack B0_3 B0_2 B0_1 B0_0 B1_3 B1_2 B1_1 B1_0 Go R1_1of4_3 R1_1of4_2 R1_1of4_1 R1_1of4_0 R2_1of4_3 R2_1of4_2 R2_1of4_1 R2_1of4_0 RW_1 RW_0 Reset ValAddr W0_3 W0_2 W0_1 W0_0 W1_3 W1_2 W1_1 W1_0 W1_1of4_3 W1_1of4_2 W1_1of4_1 W1_1of4_0 W2_1of4_3 W2_1of4_2 W2_1of4_1 W2_1of4_0 AckThruBot AckThruTop RAck_1 RAck_0 WAck_1 WAck_0 \~R0_3 \~R0_2 \~R0_1 \~R0_0 \~R1_3 \~R1_2 \~R1_1 \~R1_0
    I80_3 (Lack_3 RpAck_3 R0_3 R0q_3 R1_3 R1q_3) PCHBd
    I80_2 (Lack_2 RpAck_2 R0_2 R0q_2 R1_2 R1q_2) PCHBd
    I80_1 (Lack_1 RpAck_1 R0_1 R0q_1 R1_1 R1q_1) PCHBd
    I80_0 (Lack_0 RpAck_0 R0_0 R0q_0 R1_0 R1q_0) PCHBd
    I54 (Out0_2 Out1_3 R2_1of4_2) nor_1x
    I53 (Out0_3 Out0_2 R2_1of4_3) nor_1x
    I52 (Out0_3 Out1_2 R2_1of4_1) nor_1x
    I51 (Out1_3 Out1_2 R2_1of4_0) nor_1x
    I50 (Out0_1 Out0_0 R1_1of4_3) nor_1x
    I49 (Out1_1 Out0_0 R1_1of4_2) nor_1x
    I47 (Out1_1 Out1_0 R1_1of4_0) nor_1x
    I48 (Out1_0 Out0_1 R1_1of4_1) nor_1x
    I21 (B0p_0 B1p_0 WLAck_0 B0q_0 B1q_0 wack_0) WCHB
    I24 (B0p_3 B1p_3 WLAck_3 B0q_3 B1q_3 wack_3) WCHB
    I23 (B0p_2 B1p_2 WLAck_2 B0q_2 B1q_2 wack_2) WCHB
    I22 (B0p_1 B1p_1 WLAck_1 B0q_1 B1q_1 wack_1) WCHB
    I43 (Lack_3 Lack_2 Lack_1 Lack_0 intRack) TH44
    I29 (wack_3 wack_2 wack_1 wack_0 intWack) TH44
    I18 (W2_1of4_2 W2_1of4_3 B0p_3) or_1x
    I17 (W2_1of4_0 W2_1of4_1 B1p_3) or_1x
    I11 (W1_1of4_2 W1_1of4_3 B0p_1) or_1x
    I10 (W1_1of4_0 W1_1of4_1 B1p_1) or_1x
    I16 (W2_1of4_1 W2_1of4_3 B0p_2) or_1x
    I15 (W2_1of4_0 W2_1of4_2 B1p_2) or_1x
    I1 (W1_1of4_1 W1_1of4_3 B0p_0) or_1x
    I0 (W1_1of4_0 W1_1of4_2 B1p_0) or_1x
    I78_3 (Wen B0_3 W0_3) and_1x
    I78_2 (Wen B0_2 W0_2) and_1x
    I78_1 (Wen B0_1 W0_1) and_1x
    I78_0 (Wen B0_0 W0_0) and_1x
    I77_3 (Wen B1_3 W1_3) and_1x
    I77_2 (Wen B1_2 W1_2) and_1x
    I77_1 (Wen B1_1 W1_1) and_1x
    I77_0 (Wen B1_0 W1_0) and_1x
    M1_3 (\~R1_3 Go vdd! vdd!) pfet w=100n l=20n nfin=1 m=1 degradation=yes
    M1_2 (\~R1_2 Go vdd! vdd!) pfet w=100n l=20n nfin=1 m=1 degradation=yes
    M1_1 (\~R1_1 Go vdd! vdd!) pfet w=100n l=20n nfin=1 m=1 degradation=yes
    M1_0 (\~R1_0 Go vdd! vdd!) pfet w=100n l=20n nfin=1 m=1 degradation=yes
    M0_3 (\~R0_3 Go vdd! vdd!) pfet w=100n l=20n nfin=1 m=1 degradation=yes
    M0_2 (\~R0_2 Go vdd! vdd!) pfet w=100n l=20n nfin=1 m=1 degradation=yes
    M0_1 (\~R0_1 Go vdd! vdd!) pfet w=100n l=20n nfin=1 m=1 degradation=yes
    M0_0 (\~R0_0 Go vdd! vdd!) pfet w=100n l=20n nfin=1 m=1 degradation=yes
    I35_3 (\~R1_3 R1_3) inv_1x
    I35_2 (\~R1_2 R1_2) inv_1x
    I35_1 (\~R1_1 R1_1) inv_1x
    I35_0 (\~R1_0 R1_0) inv_1x
    I34_3 (\~R0_3 R0_3) inv_1x
    I34_2 (\~R0_2 R0_2) inv_1x
    I34_1 (\~R0_1 R0_1) inv_1x
    I34_0 (\~R0_0 R0_0) inv_1x
    I64 (RAck_0 Rack_0) iprobe
    I63 (RAck_0 Rack_1) iprobe
    I62 (RAck_1 Rack_2) iprobe
    I56 (AckThruBot AckThruTop) iprobe
    I61 (RAck_1 Rack_3) iprobe
    I65 (ValAddr RW_0 Wen) TH22
    I58 (WLAck_1 WLAck_0 WAck_0) TH22
    I38 (ValAddr RW_1 Go) TH22
    I57 (WLAck_3 WLAck_2 WAck_1) TH22
    I73 (wack_0 B0q_0 B0_0 B1q_0 B1_0 W0_0 W1_0) PCHB_FIFO
    I74 (wack_1 B0q_1 B0_1 B1q_1 B1_1 W0_1 W1_1) PCHB_FIFO
    I75 (wack_2 B0q_2 B0_2 B1q_2 B1_2 W0_2 W1_2) PCHB_FIFO
    I76 (wack_3 B0q_3 B0_3 B1q_3 B1_3 W0_3 W1_3) PCHB_FIFO
    I82 (intRack intWack Ack) nand_1x
    I67_3 (R0q_3 R1q_3 RpAck_3 Rack_3 Out0_3 Out1_3) _sub133
    I67_2 (R0q_2 R1q_2 RpAck_2 Rack_2 Out0_2 Out1_2) _sub133
    I67_1 (R0q_1 R1q_1 RpAck_1 Rack_1 Out0_1 Out1_1) _sub133
    I67_0 (R0q_0 R1q_0 RpAck_0 Rack_0 Out0_0 Out1_0) _sub133
ends _sub134

// 16nm/6T/schematic
//system verilogNetlist schematic cmos.sch cmos_sch veriloga ahdl
subckt _sub135 A B0 B1
    M5 (Q0 Q1 0 0) nfet w=120n l=20n nfin=2 m=1 degradation=no
    M4 (Q1 Q0 0 0) nfet w=120n l=20n nfin=2 m=1 degradation=no
    M1 (Q1 A B1 0) nfet w=120n l=20n nfin=2 m=1 degradation=no
    M0 (Q0 A B0 0) nfet w=120n l=20n nfin=2 m=1 degradation=no
    M3 (Q0 Q1 vdd! vdd!) pfet w=100n l=20n nfin=1 m=1 degradation=yes
    M2 (Q1 Q0 vdd! vdd!) pfet w=100n l=20n nfin=1 m=1 degradation=yes
ends _sub135

// 16nm/6T_4x/schematic
//system verilogNetlist schematic cmos.sch cmos_sch veriloga ahdl
subckt _sub136 A_3 A_2 A_1 A_0 B0 B1
    I3 (A_0 B0 B1) _sub135
    I2 (A_1 B0 B1) _sub135
    I1 (A_2 B0 B1) _sub135
    I0 (A_3 B0 B1) _sub135
ends _sub136

// 16nm/6T_32x/schematic
//system verilogNetlist schematic cmos.sch cmos_sch veriloga ahdl
subckt _sub137 A_31 A_30 A_29 A_28 A_27 A_26 A_25 A_24 A_23 A_22 A_21 A_20 A_19 A_18 A_17 A_16 A_15 A_14 A_13 A_12 A_11 A_10 A_9 A_8 A_7 A_6 A_5 A_4 A_3 A_2 A_1 A_0 B0 B1
    I7 (A_3 A_2 A_1 A_0 B0 B1) _sub136
    I6 (A_7 A_6 A_5 A_4 B0 B1) _sub136
    I5 (A_11 A_10 A_9 A_8 B0 B1) _sub136
    I4 (A_15 A_14 A_13 A_12 B0 B1) _sub136
    I3 (A_19 A_18 A_17 A_16 B0 B1) _sub136
    I2 (A_23 A_22 A_21 A_20 B0 B1) _sub136
    I1 (A_27 A_26 A_25 A_24 B0 B1) _sub136
    I0 (A_31 A_30 A_29 A_28 B0 B1) _sub136
ends _sub137

// 16nm/6T_32x_CTRL/schematic
//system verilogNetlist schematic cmos.sch cmos_sch veriloga ahdl
subckt _sub138 B0 B1 S W0 W1
    M10 (B1 B0 net22 vdd!) pfet w=100n l=20n nfin=1 m=1 degradation=yes
    M9 (net22 W0 vdd! vdd!) pfet w=100n l=20n nfin=1 m=1 degradation=yes
    M8 (B0 B1 net23 vdd!) pfet w=100n l=20n nfin=1 m=1 degradation=yes
    M7 (net23 W1 vdd! vdd!) pfet w=100n l=20n nfin=1 m=1 degradation=yes
    M2 (B1 S vdd! vdd!) pfet w=50n l=20n nfin=1 m=1 degradation=yes
    M0 (B0 S vdd! vdd!) pfet w=50n l=20n nfin=1 m=1 degradation=yes
    M6 (B1 W0 net24 0) nfet w=120n l=20n nfin=1 m=1 degradation=no
    M5 (net24 S 0 0) nfet w=120n l=20n nfin=1 m=1 degradation=no
    M4 (net25 S 0 0) nfet w=120n l=20n nfin=1 m=1 degradation=no
    M3 (B0 W1 net25 0) nfet w=120n l=20n nfin=1 m=1 degradation=no
ends _sub138

// 16nm/nand4_1x/schematic
//system verilogNetlist schematic cmos.sch cmos_sch veriloga ahdl
subckt nand4_1x A B C D Y
    M5 (Y D vdd! vdd!) pfet w=100n l=20n nfin=1 m=1 degradation=no
    M4 (Y C vdd! vdd!) pfet w=100n l=20n nfin=1 m=1 degradation=no
    M1 (Y B vdd! vdd!) pfet w=100n l=20n nfin=1 m=1 degradation=no
    M0 (Y A vdd! vdd!) pfet w=100n l=20n nfin=1 m=1 degradation=no
    M7 (net23 D 0 0) nfet w=240n l=20n nfin=1 m=1 degradation=no
    M6 (net25 C net23 0) nfet w=240n l=20n nfin=1 m=1 degradation=no
    M3 (net24 B net25 0) nfet w=240n l=20n nfin=1 m=1 degradation=no
    M2 (Y A net24 0) nfet w=240n l=20n nfin=1 m=1 degradation=no
ends nand4_1x

// 16nm/6T_32x4/schematic
//system verilogNetlist schematic cmos.sch cmos_sch veriloga ahdl
subckt _sub139 A_31 A_30 A_29 A_28 A_27 A_26 A_25 A_24 A_23 A_22 A_21 A_20 A_19 A_18 A_17 A_16 A_15 A_14 A_13 A_12 A_11 A_10 A_9 A_8 A_7 A_6 A_5 A_4 A_3 A_2 A_1 A_0 B0 B1 S_3 S_2 S_1 S_0 W0 W1 SM0 SM1
    I3 (A_31 A_30 A_29 A_28 A_27 A_26 A_25 A_24 A_23 A_22 A_21 A_20 A_19 A_18 A_17 A_16 A_15 A_14 A_13 A_12 A_11 A_10 A_9 A_8 A_7 A_6 A_5 A_4 A_3 A_2 A_1 A_0 B0P4 B1P4) _sub137
    I1 (A_31 A_30 A_29 A_28 A_27 A_26 A_25 A_24 A_23 A_22 A_21 A_20 A_19 A_18 A_17 A_16 A_15 A_14 A_13 A_12 A_11 A_10 A_9 A_8 A_7 A_6 A_5 A_4 A_3 A_2 A_1 A_0 B0P2 B1P2) _sub137
    I2 (A_31 A_30 A_29 A_28 A_27 A_26 A_25 A_24 A_23 A_22 A_21 A_20 A_19 A_18 A_17 A_16 A_15 A_14 A_13 A_12 A_11 A_10 A_9 A_8 A_7 A_6 A_5 A_4 A_3 A_2 A_1 A_0 B0P3 B1P3) _sub137
    I0 (A_31 A_30 A_29 A_28 A_27 A_26 A_25 A_24 A_23 A_22 A_21 A_20 A_19 A_18 A_17 A_16 A_15 A_14 A_13 A_12 A_11 A_10 A_9 A_8 A_7 A_6 A_5 A_4 A_3 A_2 A_1 A_0 B0P1 B1P1) _sub137
    M0 (B0P1 B0 net67 0) nfet w=120n l=20n nfin=1 m=1 degradation=no
    M1 (net67 S_0 0 0) nfet w=120n l=20n nfin=1 m=1 degradation=no
    M2 (net66 S_0 0 0) nfet w=120n l=20n nfin=1 m=1 degradation=no
    M8 (B1P2 B1 net65 0) nfet w=120n l=20n nfin=1 m=1 degradation=no
    M9 (net65 S_1 0 0) nfet w=120n l=20n nfin=1 m=1 degradation=no
    M10 (net64 S_1 0 0) nfet w=120n l=20n nfin=1 m=1 degradation=no
    M11 (B0P2 B0 net64 0) nfet w=120n l=20n nfin=1 m=1 degradation=no
    M12 (B0P3 B0 net63 0) nfet w=120n l=20n nfin=1 m=1 degradation=no
    M13 (net63 S_2 0 0) nfet w=120n l=20n nfin=1 m=1 degradation=no
    M14 (net62 S_2 0 0) nfet w=120n l=20n nfin=1 m=1 degradation=no
    M15 (B1P3 B1 net62 0) nfet w=120n l=20n nfin=1 m=1 degradation=no
    M16 (B1P4 B1 net61 0) nfet w=120n l=20n nfin=1 m=1 degradation=no
    M17 (net61 S_3 0 0) nfet w=120n l=20n nfin=1 m=1 degradation=no
    M18 (net60 S_3 0 0) nfet w=120n l=20n nfin=1 m=1 degradation=no
    M19 (B0P4 B0 net60 0) nfet w=120n l=20n nfin=1 m=1 degradation=no
    M3 (B1P1 B1 net66 0) nfet w=120n l=20n nfin=1 m=1 degradation=no
    I4 (B0P1 B1P1 S_0 W0 W1) _sub138
    I5 (B0P2 B1P2 S_1 W0 W1) _sub138
    I6 (B0P3 B1P3 S_2 W0 W1) _sub138
    I7 (B0P4 B1P4 S_3 W0 W1) _sub138
    I11 (B1P1 B1P2 B1P3 B1P4 SM1) nand4_1x
    I10 (B0P1 B0P2 B0P3 B0P4 SM0) nand4_1x
    C7 (B1P4 0) capacitor c=0 m=1
    C6 (B1P2 0) capacitor c=0 m=1
    C5 (B1P3 0) capacitor c=0 m=1
    C4 (B0P4 0) capacitor c=0 m=1
    C3 (B0P3 0) capacitor c=0 m=1
    C2 (B0P2 0) capacitor c=0 m=1
    C1 (B1P1 0) capacitor c=0 m=1
    C0 (B0P1 0) capacitor c=0 m=1
    M23 (B1P4 S_3 vdd! vdd!) pfet w=100n l=20n nfin=1 m=1 degradation=no
    M22 (B0P4 S_3 vdd! vdd!) pfet w=100n l=20n nfin=1 m=1 degradation=no
    M21 (B0P3 S_2 vdd! vdd!) pfet w=100n l=20n nfin=1 m=1 degradation=no
    M20 (B1P3 S_2 vdd! vdd!) pfet w=100n l=20n nfin=1 m=1 degradation=no
    M7 (B1P2 S_1 vdd! vdd!) pfet w=100n l=20n nfin=1 m=1 degradation=no
    M6 (B0P2 S_1 vdd! vdd!) pfet w=100n l=20n nfin=1 m=1 degradation=no
    M5 (B1P1 S_0 vdd! vdd!) pfet w=100n l=20n nfin=1 m=1 degradation=no
    M4 (B0P1 S_0 vdd! vdd!) pfet w=100n l=20n nfin=1 m=1 degradation=no
ends _sub139

// 16nm/6T_SetRead/schematic
//system verilogNetlist schematic cmos.sch cmos_sch veriloga ahdl
subckt _sub140 Go SM0_0 SM0_1 SM1_0 SM1_1 \~R0 \~R1
    M5 (\~R0 SM0_0 net18 0) nfet w=60n l=20n nfin=1 m=1 degradation=no
    M3 (\~R0 SM0_1 net18 0) nfet w=60n l=20n nfin=1 m=1 degradation=no
    M2 (net18 Go 0 0) nfet w=120n l=20n nfin=2 m=1 degradation=no
    M1 (\~R1 SM1_1 net18 0) nfet w=60n l=20n nfin=1 m=1 degradation=no
    M0 (\~R1 SM1_0 net18 0) nfet w=60n l=20n nfin=1 m=1 degradation=no
ends _sub140

// 16nm/6T_CHUNK/schematic
//system verilogNetlist schematic cmos.sch cmos_sch veriloga ahdl
subckt _sub141 A_63 A_62 A_61 A_60 A_59 A_58 A_57 A_56 A_55 A_54 A_53 A_52 A_51 A_50 A_49 A_48 A_47 A_46 A_45 A_44 A_43 A_42 A_41 A_40 A_39 A_38 A_37 A_36 A_35 A_34 A_33 A_32 A_31 A_30 A_29 A_28 A_27 A_26 A_25 A_24 A_23 A_22 A_21 A_20 A_19 A_18 A_17 A_16 A_15 A_14 A_13 A_12 A_11 A_10 A_9 A_8 A_7 A_6 A_5 A_4 A_3 A_2 A_1 A_0 B0_3 B0_2 B0_1 B0_0 B1_3 B1_2 B1_1 B1_0 Go S_7 S_6 S_5 S_4 S_3 S_2 S_1 S_0 W0_3 W0_2 W0_1 W0_0 W1_3 W1_2 W1_1 W1_0 \~R0_3 \~R0_2 \~R0_1 \~R0_0 \~R1_3 \~R1_2 \~R1_1 \~R1_0
    I11 (A_63 A_62 A_61 A_60 A_59 A_58 A_57 A_56 A_55 A_54 A_53 A_52 A_51 A_50 A_49 A_48 A_47 A_46 A_45 A_44 A_43 A_42 A_41 A_40 A_39 A_38 A_37 A_36 A_35 A_34 A_33 A_32 B0_3 B1_3 S_7 S_6 S_5 S_4 W0_3 W1_3 SM0_1_bit3 SM1_1_bit3) _sub139
    I10 (A_63 A_62 A_61 A_60 A_59 A_58 A_57 A_56 A_55 A_54 A_53 A_52 A_51 A_50 A_49 A_48 A_47 A_46 A_45 A_44 A_43 A_42 A_41 A_40 A_39 A_38 A_37 A_36 A_35 A_34 A_33 A_32 B0_2 B1_2 S_7 S_6 S_5 S_4 W0_2 W1_2 SM0_1_bit2 SM1_1_bit2) _sub139
    I9 (A_63 A_62 A_61 A_60 A_59 A_58 A_57 A_56 A_55 A_54 A_53 A_52 A_51 A_50 A_49 A_48 A_47 A_46 A_45 A_44 A_43 A_42 A_41 A_40 A_39 A_38 A_37 A_36 A_35 A_34 A_33 A_32 B0_1 B1_1 S_7 S_6 S_5 S_4 W0_1 W1_1 SM0_1_bit1 SM1_1_bit1) _sub139
    I8 (A_63 A_62 A_61 A_60 A_59 A_58 A_57 A_56 A_55 A_54 A_53 A_52 A_51 A_50 A_49 A_48 A_47 A_46 A_45 A_44 A_43 A_42 A_41 A_40 A_39 A_38 A_37 A_36 A_35 A_34 A_33 A_32 B0_0 B1_0 S_7 S_6 S_5 S_4 W0_0 W1_0 SM0_1_bit0 SM1_1_bit0) _sub139
    I3 (A_31 A_30 A_29 A_28 A_27 A_26 A_25 A_24 A_23 A_22 A_21 A_20 A_19 A_18 A_17 A_16 A_15 A_14 A_13 A_12 A_11 A_10 A_9 A_8 A_7 A_6 A_5 A_4 A_3 A_2 A_1 A_0 B0_3 B1_3 S_3 S_2 S_1 S_0 W0_3 W1_3 SM0_0_bit3 SM1_0_bit3) _sub139
    I2 (A_31 A_30 A_29 A_28 A_27 A_26 A_25 A_24 A_23 A_22 A_21 A_20 A_19 A_18 A_17 A_16 A_15 A_14 A_13 A_12 A_11 A_10 A_9 A_8 A_7 A_6 A_5 A_4 A_3 A_2 A_1 A_0 B0_2 B1_2 S_3 S_2 S_1 S_0 W0_2 W1_2 SM0_0_bit2 SM1_0_bit2) _sub139
    I1 (A_31 A_30 A_29 A_28 A_27 A_26 A_25 A_24 A_23 A_22 A_21 A_20 A_19 A_18 A_17 A_16 A_15 A_14 A_13 A_12 A_11 A_10 A_9 A_8 A_7 A_6 A_5 A_4 A_3 A_2 A_1 A_0 B0_1 B1_1 S_3 S_2 S_1 S_0 W0_1 W1_1 SM0_0_bit1 SM1_0_bit1) _sub139
    I0 (A_31 A_30 A_29 A_28 A_27 A_26 A_25 A_24 A_23 A_22 A_21 A_20 A_19 A_18 A_17 A_16 A_15 A_14 A_13 A_12 A_11 A_10 A_9 A_8 A_7 A_6 A_5 A_4 A_3 A_2 A_1 A_0 B0_0 B1_0 S_3 S_2 S_1 S_0 W0_0 W1_0 SM0_0_bit0 SM1_0_bit0) _sub139
    I7 (Go SM0_0_bit3 SM0_1_bit3 SM1_0_bit3 SM1_1_bit3 \~R0_3 \~R1_3) _sub140
    I6 (Go SM0_0_bit2 SM0_1_bit2 SM1_0_bit2 SM1_1_bit2 \~R0_2 \~R1_2) _sub140
    I5 (Go SM0_0_bit1 SM0_1_bit1 SM1_0_bit1 SM1_1_bit1 \~R0_1 \~R1_1) _sub140
    I4 (Go SM0_0_bit0 SM0_1_bit0 SM1_0_bit0 SM1_1_bit0 \~R0_0 \~R1_0) _sub140
ends _sub141

// 16nm/and4_1x/schematic
//system verilogNetlist schematic cmos.sch cmos_sch veriloga ahdl
subckt and4_1x A B C D Y
    I15 (A B C D net1) nand4_1x
    I16 (net1 Y) inv_1x
ends and4_1x

// 16nm/Demux_2e1of4/schematic
//system verilogNetlist schematic cmos.sch cmos_sch veriloga ahdl
subckt Demux_2e1of4 _1of4_1_3 _1of4_1_2 _1of4_1_1 _1of4_1_0 _1of4_2_3 _1of4_2_2 _1of4_2_1 _1of4_2_0 A_15 A_14 A_13 A_12 A_11 A_10 A_9 A_8 A_7 A_6 A_5 A_4 A_3 A_2 A_1 A_0 En EnOut
    I15 (_1of4_1_3 _1of4_2_3 EnOut En A_15) and4_1x
    I14 (_1of4_1_2 _1of4_2_3 EnOut En A_14) and4_1x
    I13 (_1of4_1_1 _1of4_2_3 EnOut En A_13) and4_1x
    I12 (_1of4_1_0 _1of4_2_3 EnOut En A_12) and4_1x
    I11 (_1of4_1_3 _1of4_2_2 EnOut En A_11) and4_1x
    I10 (_1of4_1_2 _1of4_2_2 EnOut En A_10) and4_1x
    I9 (_1of4_1_1 _1of4_2_2 EnOut En A_9) and4_1x
    I8 (_1of4_1_0 _1of4_2_2 EnOut En A_8) and4_1x
    I7 (_1of4_1_3 _1of4_2_1 EnOut En A_7) and4_1x
    I6 (_1of4_1_2 _1of4_2_1 EnOut En A_6) and4_1x
    I5 (_1of4_1_1 _1of4_2_1 EnOut En A_5) and4_1x
    I4 (_1of4_1_0 _1of4_2_1 EnOut En A_4) and4_1x
    I3 (_1of4_1_3 _1of4_2_0 EnOut En A_3) and4_1x
    I2 (_1of4_1_2 _1of4_2_0 EnOut En A_2) and4_1x
    I1 (_1of4_1_1 _1of4_2_0 EnOut En A_1) and4_1x
    I0 (_1of4_1_0 _1of4_2_0 EnOut En A_0) and4_1x
ends Demux_2e1of4

// 16nm/nor4_1x/schematic
//system verilogNetlist schematic cmos.sch cmos_sch veriloga ahdl
subckt nor4_1x A B C D Y
    M5 (net017 C net21 vdd!) pfet w=400n l=20n nfin=1 m=1 degradation=yes
    M4 (Y D net017 vdd!) pfet w=400n l=20n nfin=1 m=1 degradation=yes
    M3 (net21 B net018 vdd!) pfet w=400n l=20n nfin=1 m=1 degradation=yes
    M2 (net018 A vdd! vdd!) pfet w=400n l=20n nfin=1 m=1 degradation=yes
    M7 (Y D 0 0) nfet w=60n l=20n nfin=1 m=1 degradation=no
    M6 (Y C 0 0) nfet w=60n l=20n nfin=1 m=1 degradation=no
    M1 (Y A 0 0) nfet w=60n l=20n nfin=1 m=1 degradation=no
    M0 (Y B 0 0) nfet w=60n l=20n nfin=1 m=1 degradation=no
ends nor4_1x

// 16nm/or16_1x/schematic
//system verilogNetlist schematic cmos.sch cmos_sch veriloga ahdl
subckt or16_1x Y X_15 X_14 X_13 X_12 X_11 X_10 X_9 X_8 X_7 X_6 X_5 X_4 X_3 X_2 X_1 X_0
    I2 (nX30 nX74 nX118 nX1512 Y) nand4_1x
    I0 (X_0 X_1 X_2 X_3 nX30) nor4_1x
    I1 (X_4 X_5 X_6 X_7 nX74) nor4_1x
    I3 (X_8 X_9 X_10 X_11 nX118) nor4_1x
    I4 (X_12 X_13 X_14 X_15 nX1512) nor4_1x
ends or16_1x

// 16nm/or4_1x/schematic
//system verilogNetlist schematic cmos.sch cmos_sch veriloga ahdl
subckt or4_1x A B C D Y
    I0 (A B C D net11) nor4_1x
    I1 (net11 Y) inv_1x
ends or4_1x

// 16nm/Demux_3e1of4/schematic
//system verilogNetlist schematic cmos.sch cmos_sch veriloga ahdl
subckt Demux_3e1of4 _1of4_1_3 _1of4_1_2 _1of4_1_1 _1of4_1_0 _1of4_2_3 _1of4_2_2 _1of4_2_1 _1of4_2_0 _1of4_3_3 _1of4_3_2 _1of4_3_1 _1of4_3_0 A_63 A_62 A_61 A_60 A_59 A_58 A_57 A_56 A_55 A_54 A_53 A_52 A_51 A_50 A_49 A_48 A_47 A_46 A_45 A_44 A_43 A_42 A_41 A_40 A_39 A_38 A_37 A_36 A_35 A_34 A_33 A_32 A_31 A_30 A_29 A_28 A_27 A_26 A_25 A_24 A_23 A_22 A_21 A_20 A_19 A_18 A_17 A_16 A_15 A_14 A_13 A_12 A_11 A_10 A_9 A_8 A_7 A_6 A_5 A_4 A_3 A_2 A_1 A_0 En AddrValid
    I3 (_1of4_1_3 _1of4_1_2 _1of4_1_1 _1of4_1_0 _1of4_2_3 _1of4_2_2 _1of4_2_1 _1of4_2_0 A_63 A_62 A_61 A_60 A_59 A_58 A_57 A_56 A_55 A_54 A_53 A_52 A_51 A_50 A_49 A_48 En _1of4_3_3) Demux_2e1of4
    I2 (_1of4_1_3 _1of4_1_2 _1of4_1_1 _1of4_1_0 _1of4_2_3 _1of4_2_2 _1of4_2_1 _1of4_2_0 A_47 A_46 A_45 A_44 A_43 A_42 A_41 A_40 A_39 A_38 A_37 A_36 A_35 A_34 A_33 A_32 En _1of4_3_2) Demux_2e1of4
    I1 (_1of4_1_3 _1of4_1_2 _1of4_1_1 _1of4_1_0 _1of4_2_3 _1of4_2_2 _1of4_2_1 _1of4_2_0 A_31 A_30 A_29 A_28 A_27 A_26 A_25 A_24 A_23 A_22 A_21 A_20 A_19 A_18 A_17 A_16 En _1of4_3_1) Demux_2e1of4
    I0 (_1of4_1_3 _1of4_1_2 _1of4_1_1 _1of4_1_0 _1of4_2_3 _1of4_2_2 _1of4_2_1 _1of4_2_0 A_15 A_14 A_13 A_12 A_11 A_10 A_9 A_8 A_7 A_6 A_5 A_4 A_3 A_2 A_1 A_0 En _1of4_3_0) Demux_2e1of4
    I8 (net22 A_63 A_62 A_61 A_60 A_59 A_58 A_57 A_56 A_55 A_54 A_53 A_52 A_51 A_50 A_49 A_48) or16_1x
    I7 (net23 A_47 A_46 A_45 A_44 A_43 A_42 A_41 A_40 A_39 A_38 A_37 A_36 A_35 A_34 A_33 A_32) or16_1x
    I6 (net24 A_31 A_30 A_29 A_28 A_27 A_26 A_25 A_24 A_23 A_22 A_21 A_20 A_19 A_18 A_17 A_16) or16_1x
    I17 (net25 A_15 A_14 A_13 A_12 A_11 A_10 A_9 A_8 A_7 A_6 A_5 A_4 A_3 A_2 A_1 A_0) or16_1x
    I11 (net25 net24 net23 net22 AddrValid) or4_1x
ends Demux_3e1of4

// 16nm/nor3_1x/schematic
//system verilogNetlist schematic cmos.sch cmos_sch veriloga ahdl
subckt nor3_1x A B C Y
    M5 (Y C net21 vdd!) pfet w=300n l=20n nfin=1 m=1 degradation=yes
    M3 (net21 B net018 vdd!) pfet w=300n l=20n nfin=1 m=1 degradation=yes
    M2 (net018 A vdd! vdd!) pfet w=300n l=20n nfin=1 m=1 degradation=yes
    M6 (Y C 0 0) nfet w=60n l=20n nfin=1 m=1 degradation=no
    M1 (Y A 0 0) nfet w=60n l=20n nfin=1 m=1 degradation=no
    M0 (Y B 0 0) nfet w=60n l=20n nfin=1 m=1 degradation=no
ends nor3_1x

// 16nm/6T_DEMUX_/schematic
//system verilogNetlist schematic cmos.sch cmos_sch veriloga ahdl
subckt _sub142 _1of4_1_3 _1of4_1_2 _1of4_1_1 _1of4_1_0 _1of4_2_3 _1of4_2_2 _1of4_2_1 _1of4_2_0 _1of4_3_3 _1of4_3_2 _1of4_3_1 _1of4_3_0 _1of4_4_3 _1of4_4_2 _1of4_4_1 _1of4_4_0 A_63 A_62 A_61 A_60 A_59 A_58 A_57 A_56 A_55 A_54 A_53 A_52 A_51 A_50 A_49 A_48 A_47 A_46 A_45 A_44 A_43 A_42 A_41 A_40 A_39 A_38 A_37 A_36 A_35 A_34 A_33 A_32 A_31 A_30 A_29 A_28 A_27 A_26 A_25 A_24 A_23 A_22 A_21 A_20 A_19 A_18 A_17 A_16 A_15 A_14 A_13 A_12 A_11 A_10 A_9 A_8 A_7 A_6 A_5 A_4 A_3 A_2 A_1 A_0 En S_7 S_6 S_5 S_4 S_3 S_2 S_1 S_0 Ack
    I0 (_1of4_1_3 _1of4_1_2 _1of4_1_1 _1of4_1_0 _1of4_2_3 _1of4_2_2 _1of4_2_1 _1of4_2_0 _1of4_3_3 _1of4_3_2 _1of4_3_1 _1of4_3_0 A_63 A_62 A_61 A_60 A_59 A_58 A_57 A_56 A_55 A_54 A_53 A_52 A_51 A_50 A_49 A_48 A_47 A_46 A_45 A_44 A_43 A_42 A_41 A_40 A_39 A_38 A_37 A_36 A_35 A_34 A_33 A_32 A_31 A_30 A_29 A_28 A_27 A_26 A_25 A_24 A_23 A_22 A_21 A_20 A_19 A_18 A_17 A_16 A_15 A_14 A_13 A_12 A_11 A_10 A_9 A_8 A_7 A_6 A_5 A_4 A_3 A_2 A_1 A_0 En Ack) Demux_3e1of4
    I10_3 (_1of4_4_3 net020_0) inv_1x
    I10_2 (_1of4_4_2 net020_1) inv_1x
    I10_1 (_1of4_4_1 net020_2) inv_1x
    I10_0 (_1of4_4_0 net020_3) inv_1x
    I9 (En net015) inv_1x
    I6 (En net016) inv_1x
    I4 (_1of4_3_0 _1of4_3_1 net23) nor_1x
    I5 (_1of4_3_2 _1of4_3_3 net22) nor_1x
    I1_3 (net020_0 net23 net016 S_3) nor3_1x
    I1_2 (net020_1 net23 net016 S_2) nor3_1x
    I1_1 (net020_2 net23 net016 S_1) nor3_1x
    I1_0 (net020_3 net23 net016 S_0) nor3_1x
    I2_3 (net020_0 net22 net015 S_7) nor3_1x
    I2_2 (net020_1 net22 net015 S_6) nor3_1x
    I2_1 (net020_2 net22 net015 S_5) nor3_1x
    I2_0 (net020_3 net22 net015 S_4) nor3_1x
ends _sub142

// 16nm/inv_1xt/schematic
//system verilogNetlist schematic cmos.sch cmos_sch veriloga ahdl
subckt inv_1xt A Y
    M0 (Y A 0 0) nfet w=60n l=20n nfin=1 m=1 degradation=no
    M1 (Y A vcc! vcc!) pfet w=100n l=20n nfin=1 m=1 degradation=no
ends inv_1xt

// 16nm_Tests/6T_DataPath_Test/schematic
// system verilogNetlist schematic cmos.sch cmos_sch veriloga ahdl
IDATA (net28 B0_1_3 B0_1_2 B0_1_1 B0_1_0 B1_1_3 B1_1_2 B1_1_1 B1_1_0 G01 RDataT_3 RDataT_2 RDataT_1 RDataT_0 RDataT_7 RDataT_6 RDataT_5 RDataT_4 RWT_1 RWT_0 net58 ValAddr W0_1_3 W0_1_2 W0_1_1 W0_1_0 W1_1_3 W1_1_2 W1_1_1 W1_1_0 WDataT_3 WDataT_2 WDataT_1 WDataT_0 WDataT_7 WDataT_6 WDataT_5 WDataT_4 net57 net56 RAckT_1 RAckT_0 WAckT_1 WAckT_0 \~R0_1_3 \~R0_1_2 \~R0_1_1 \~R0_1_0 \~R1_1_3 \~R1_1_2 \~R1_1_1 \~R1_1_0) _sub134
ICHUNK (Aline_63 Aline_62 Aline_61 Aline_60 Aline_59 Aline_58 Aline_57 Aline_56 Aline_55 Aline_54 Aline_53 Aline_52 Aline_51 Aline_50 Aline_49 Aline_48 Aline_47 Aline_46 Aline_45 Aline_44 Aline_43 Aline_42 Aline_41 Aline_40 Aline_39 Aline_38 Aline_37 Aline_36 Aline_35 Aline_34 Aline_33 Aline_32 Aline_31 Aline_30 Aline_29 Aline_28 Aline_27 Aline_26 Aline_25 Aline_24 Aline_23 Aline_22 Aline_21 Aline_20 Aline_19 Aline_18 Aline_17 Aline_16 Aline_15 Aline_14 Aline_13 Aline_12 Aline_11 Aline_10 Aline_9 Aline_8 Aline_7 Aline_6 Aline_5 Aline_4 Aline_3 Aline_2 Aline_1 Aline_0 B0_1_3 B0_1_2 B0_1_1 B0_1_0 B1_1_3 B1_1_2 B1_1_1 B1_1_0 G01 S_7 S_6 S_5 S_4 S_3 S_2 S_1 S_0 W0_1_3 W0_1_2 W0_1_1 W0_1_0 W1_1_3 W1_1_2 W1_1_1 W1_1_0 \~R0_1_3 \~R0_1_2 \~R0_1_1 \~R0_1_0 \~R1_1_3 \~R1_1_2 \~R1_1_1 \~R1_1_0) _sub141
IMUX (AT_3 AT_2 AT_1 AT_0 AT_7 AT_6 AT_5 AT_4 AT_11 AT_10 AT_9 AT_8 AT_15 AT_14 AT_13 AT_12 Aline_63 Aline_62 Aline_61 Aline_60 Aline_59 Aline_58 Aline_57 Aline_56 Aline_55 Aline_54 Aline_53 Aline_52 Aline_51 Aline_50 Aline_49 Aline_48 Aline_47 Aline_46 Aline_45 Aline_44 Aline_43 Aline_42 Aline_41 Aline_40 Aline_39 Aline_38 Aline_37 Aline_36 Aline_35 Aline_34 Aline_33 Aline_32 Aline_31 Aline_30 Aline_29 Aline_28 Aline_27 Aline_26 Aline_25 Aline_24 Aline_23 Aline_22 Aline_21 Aline_20 Aline_19 Aline_18 Aline_17 Aline_16 Aline_15 Aline_14 Aline_13 Aline_12 Aline_11 Aline_10 Aline_9 Aline_8 Aline_7 Aline_6 Aline_5 Aline_4 Aline_3 Aline_2 Aline_1 Aline_0 En S_7 S_6 S_5 S_4 S_3 S_2 S_1 S_0 ValAddr) _sub142
V1 (vcc! 0) vsource type=dc dc=vdd
V0 (vdd! 0) vsource type=dc dc=vdd
I17 (AckT net020) inv_1xt
I15_1 (net40_0 RWT_1) inv_1xt
I15_0 (net40_1 RWT_0) inv_1xt
I11_7 (RDataT_7 net027_0) inv_1xt
I11_6 (RDataT_6 net027_1) inv_1xt
I11_5 (RDataT_5 net027_2) inv_1xt
I11_4 (RDataT_4 net027_3) inv_1xt
I11_3 (RDataT_3 net027_4) inv_1xt
I11_2 (RDataT_2 net027_5) inv_1xt
I11_1 (RDataT_1 net027_6) inv_1xt
I11_0 (RDataT_0 net027_7) inv_1xt
I20_15 (net031_0 AT_15) inv_1xt
I20_14 (net031_1 AT_14) inv_1xt
I20_13 (net031_2 AT_13) inv_1xt
I20_12 (net031_3 AT_12) inv_1xt
I20_11 (net031_4 AT_11) inv_1xt
I20_10 (net031_5 AT_10) inv_1xt
I20_9 (net031_6 AT_9) inv_1xt
I20_8 (net031_7 AT_8) inv_1xt
I20_7 (net031_8 AT_7) inv_1xt
I20_6 (net031_9 AT_6) inv_1xt
I20_5 (net031_10 AT_5) inv_1xt
I20_4 (net031_11 AT_4) inv_1xt
I20_3 (net031_12 AT_3) inv_1xt
I20_2 (net031_13 AT_2) inv_1xt
I20_1 (net031_14 AT_1) inv_1xt
I20_0 (net031_15 AT_0) inv_1xt
I9_1 (WAckT_1 net036_0) inv_1xt
I9_0 (WAckT_0 net036_1) inv_1xt
I13_1 (net41_0 RAckT_1) inv_1xt
I13_0 (net41_1 RAckT_0) inv_1xt
I5_7 (net44_0 WDataT_7) inv_1xt
I5_6 (net44_1 WDataT_6) inv_1xt
I5_5 (net44_2 WDataT_5) inv_1xt
I5_4 (net44_3 WDataT_4) inv_1xt
I5_3 (net44_4 WDataT_3) inv_1xt
I5_2 (net44_5 WDataT_2) inv_1xt
I5_1 (net44_6 WDataT_1) inv_1xt
I5_0 (net44_7 WDataT_0) inv_1xt
I23 (net021 En) inv_1x
I18 (net28 AckT) inv_1x
// BEGIN Hierarchical Interface Elements
_ie99960 (net031_5 0) d2a src="99960" val0=0.0 val1=vdd valx=vdd/2 rise=2p fall=2p
_ie99961 (net40_0 0) d2a src="99961" val0=0.0 val1=vdd valx=vdd/2 rise=2p fall=2p
_ie99962 (net031_1 0) d2a src="99962" val0=0.0 val1=vdd valx=vdd/2 rise=2p fall=2p
_ie99963 (net031_10 0) d2a src="99963" val0=0.0 val1=vdd valx=vdd/2 rise=2p fall=2p
_ie99964 (net031_9 0) d2a src="99964" val0=0.0 val1=vdd valx=vdd/2 rise=2p fall=2p
_ie99965 (net031_8 0) d2a src="99965" val0=0.0 val1=vdd valx=vdd/2 rise=2p fall=2p
_ie99966 (net031_11 0) d2a src="99966" val0=0.0 val1=vdd valx=vdd/2 rise=2p fall=2p
_ie99967 (net41_1 0) d2a src="99967" val0=0.0 val1=vdd valx=vdd/2 rise=2p fall=2p
_ie99968 (net44_3 0) d2a src="99968" val0=0.0 val1=vdd valx=vdd/2 rise=2p fall=2p
_ie99969 (net40_1 0) d2a src="99969" val0=0.0 val1=vdd valx=vdd/2 rise=2p fall=2p
_ie99970 (net031_6 0) d2a src="99970" val0=0.0 val1=vdd valx=vdd/2 rise=2p fall=2p
_ie99971 (net031_3 0) d2a src="99971" val0=0.0 val1=vdd valx=vdd/2 rise=2p fall=2p
_ie99972 (net031_14 0) d2a src="99972" val0=0.0 val1=vdd valx=vdd/2 rise=2p fall=2p
_ie99973 (net031_13 0) d2a src="99973" val0=0.0 val1=vdd valx=vdd/2 rise=2p fall=2p
_ie99974 (net036_1 0) a2d dest="99974" vl=0.3*vdd vh=0.7*vdd timex=20n
_ie99975 (net031_12 0) d2a src="99975" val0=0.0 val1=vdd valx=vdd/2 rise=2p fall=2p
_ie99976 (net036_0 0) a2d dest="99976" vl=0.3*vdd vh=0.7*vdd timex=20n
_ie99977 (net027_3 0) a2d dest="99977" vl=0.3*vdd vh=0.7*vdd timex=20n
_ie99978 (net027_5 0) a2d dest="99978" vl=0.3*vdd vh=0.7*vdd timex=20n
_ie99979 (net020 0) a2d dest="99979" vl=0.3*vdd vh=0.7*vdd timex=20n
_ie99980 (net021 0) d2a src="99980" val0=0.0 val1=vdd valx=vdd/2 rise=2p fall=2p
_ie99981 (net44_7 0) d2a src="99981" val0=0.0 val1=vdd valx=vdd/2 rise=2p fall=2p
_ie99982 (net44_6 0) d2a src="99982" val0=0.0 val1=vdd valx=vdd/2 rise=2p fall=2p
_ie99983 (net027_7 0) a2d dest="99983" vl=0.3*vdd vh=0.7*vdd timex=20n
_ie99984 (net44_0 0) d2a src="99984" val0=0.0 val1=vdd valx=vdd/2 rise=2p fall=2p
_ie99985 (net027_6 0) a2d dest="99985" vl=0.3*vdd vh=0.7*vdd timex=20n
_ie99986 (net031_7 0) d2a src="99986" val0=0.0 val1=vdd valx=vdd/2 rise=2p fall=2p
_ie99987 (net031_2 0) d2a src="99987" val0=0.0 val1=vdd valx=vdd/2 rise=2p fall=2p
_ie99988 (net031_0 0) d2a src="99988" val0=0.0 val1=vdd valx=vdd/2 rise=2p fall=2p
_ie99989 (net44_2 0) d2a src="99989" val0=0.0 val1=vdd valx=vdd/2 rise=2p fall=2p
_ie99990 (net027_1 0) a2d dest="99990" vl=0.3*vdd vh=0.7*vdd timex=20n
_ie99991 (net031_15 0) d2a src="99991" val0=0.0 val1=vdd valx=vdd/2 rise=2p fall=2p
_ie99992 (net027_0 0) a2d dest="99992" vl=0.3*vdd vh=0.7*vdd timex=20n
_ie99993 (net027_4 0) a2d dest="99993" vl=0.3*vdd vh=0.7*vdd timex=20n
_ie99994 (net031_4 0) d2a src="99994" val0=0.0 val1=vdd valx=vdd/2 rise=2p fall=2p
_ie99995 (net44_1 0) d2a src="99995" val0=0.0 val1=vdd valx=vdd/2 rise=2p fall=2p
_ie99996 (net44_5 0) d2a src="99996" val0=0.0 val1=vdd valx=vdd/2 rise=2p fall=2p
_ie99997 (net41_0 0) d2a src="99997" val0=0.0 val1=vdd valx=vdd/2 rise=2p fall=2p
_ie99998 (net44_4 0) d2a src="99998" val0=0.0 val1=vdd valx=vdd/2 rise=2p fall=2p
_ie99999 (net027_2 0) a2d dest="99999" vl=0.3*vdd vh=0.7*vdd timex=20n
// END Hierarchical Interface Elements
ic RAckT_1=vdd RAckT_0=vdd WAckT_1=vdd WAckT_0=vdd \~R0_1_3=vdd \~R0_1_2=vdd \~R0_1_1=vdd \~R0_1_0=vdd \~R1_1_3=vdd \~R1_1_2=vdd \~R1_1_1=vdd \~R1_1_0=vdd G01=0 W0_1_3=0 W0_1_2=0 W0_1_1=0 W0_1_0=0 W1_1_3=0 W1_1_2=0 W1_1_1=0 W1_1_0=0 B0_1_3=0 B0_1_2=0 B0_1_1=0 B0_1_0=0 B1_1_3=0 B1_1_2=0 B1_1_1=0 B1_1_0=0 S_7=0 S_6=0 S_5=0 S_4=0 S_3=0 S_2=0 S_1=0 S_0=0 Aline_63=0 Aline_62=0 Aline_61=0 Aline_60=0 Aline_59=0 Aline_58=0 Aline_57=0 Aline_56=0 Aline_55=0 Aline_54=0 Aline_53=0 Aline_52=0 Aline_51=0 Aline_50=0 Aline_49=0 Aline_48=0 Aline_47=0 Aline_46=0 Aline_45=0 Aline_44=0 Aline_43=0 Aline_42=0 Aline_41=0 Aline_40=0 Aline_39=0 Aline_38=0 Aline_37=0 Aline_36=0 Aline_35=0 Aline_34=0 Aline_33=0 Aline_32=0 Aline_31=0 Aline_30=0 Aline_29=0 Aline_28=0 Aline_27=0 Aline_26=0 Aline_25=0 Aline_24=0 Aline_23=0 Aline_22=0 Aline_21=0 Aline_20=0 Aline_19=0 Aline_18=0 Aline_17=0 Aline_16=0 Aline_15=0 Aline_14=0 Aline_13=0 Aline_12=0 Aline_11=0 Aline_10=0 Aline_9=0 Aline_8=0 Aline_7=0 Aline_6=0 Aline_5=0 Aline_4=0 Aline_3=0 Aline_2=0 Aline_1=0 Aline_0=0 ValAddr=0 En=0 AT_15=0 AT_14=0 AT_13=0 AT_12=0 AT_11=0 AT_10=0 AT_9=0 AT_8=0 AT_7=0 AT_6=0 AT_5=0 AT_4=0 AT_3=0 AT_2=0 AT_1=0 AT_0=0 RWT_1=0 RWT_0=0 RDataT_7=0 RDataT_6=0 RDataT_5=0 RDataT_4=0 RDataT_3=0 RDataT_2=0 RDataT_1=0 RDataT_0=0 WDataT_7=0 WDataT_6=0 WDataT_5=0 WDataT_4=0 WDataT_3=0 WDataT_2=0 WDataT_1=0 WDataT_0=0 IDATA.R1q_3=0 IDATA.R0q_3=0 IDATA.I67_3.net18=0 IDATA.I67_3.net19=0 IDATA.Rack_3=vdd IDATA.Rack_2=vdd IDATA.Rack_1=vdd IDATA.Rack_0=vdd IDATA.Out0_3=vdd IDATA.Out0_2=vdd IDATA.Out0_1=vdd IDATA.Out0_0=vdd IDATA.Out1_3=vdd IDATA.Out1_2=vdd IDATA.Out1_1=vdd IDATA.Out1_0=vdd
simulatorOptions options temp=30.0
tran tran stop=6n errpreset=conservative
save V1:p V0:p
