// Design: 16nm_Tests/6T_DataPath_Test
simulator lang=spectre
global 0 vdd! vcc!
parameters vdd=.700
include "/software/cadence/ncsu-FreePDK15/hspice_16nm_hp.include"

// 16nm_Tests/6T_DataPath_Test/schematic
// system verilogNetlist schematic cmos.sch cmos_sch veriloga ahdl
// BEGIN Hierarchical Interface Elements
_ie99924 (net060_4 0) d2a src="99924" val0=0.0 val1=vdd valx=vdd/2 rise=2p fall=2p
_ie99925 (net060_3 0) d2a src="99925" val0=0.0 val1=vdd valx=vdd/2 rise=2p fall=2p
_ie99926 (net060_0 0) d2a src="99926" val0=0.0 val1=vdd valx=vdd/2 rise=2p fall=2p
_ie99927 (net045_0 0) a2d dest="99927" vl=0.3*vdd vh=0.7*vdd timex=20n
_ie99928 (net049_18 0) d2a src="99928" val0=0.0 val1=vdd valx=vdd/2 rise=2p fall=2p
_ie99929 (net049_13 0) d2a src="99929" val0=0.0 val1=vdd valx=vdd/2 rise=2p fall=2p
_ie99930 (net049_12 0) d2a src="99930" val0=0.0 val1=vdd valx=vdd/2 rise=2p fall=2p
_ie99931 (net44_4 0) d2a src="99931" val0=0.0 val1=vdd valx=vdd/2 rise=2p fall=2p
_ie99932 (\~RRW_1 0) d2a src="99932" val0=0.0 val1=vdd valx=vdd/2 rise=2p fall=2p
_ie99933 (net027_5 0) a2d dest="99933" vl=0.3*vdd vh=0.7*vdd timex=20n
_ie99934 (net049_11 0) d2a src="99934" val0=0.0 val1=vdd valx=vdd/2 rise=2p fall=2p
_ie99935 (net44_7 0) d2a src="99935" val0=0.0 val1=vdd valx=vdd/2 rise=2p fall=2p
_ie99936 (net048_0 0) a2d dest="99936" vl=0.3*vdd vh=0.7*vdd timex=20n
_ie99937 (net027_2 0) a2d dest="99937" vl=0.3*vdd vh=0.7*vdd timex=20n
_ie99938 (net049_14 0) d2a src="99938" val0=0.0 val1=vdd valx=vdd/2 rise=2p fall=2p
_ie99939 (net44_6 0) d2a src="99939" val0=0.0 val1=vdd valx=vdd/2 rise=2p fall=2p
_ie99940 (net060_2 0) d2a src="99940" val0=0.0 val1=vdd valx=vdd/2 rise=2p fall=2p
_ie99941 (net060_8 0) d2a src="99941" val0=0.0 val1=vdd valx=vdd/2 rise=2p fall=2p
_ie99942 (net045_2 0) a2d dest="99942" vl=0.3*vdd vh=0.7*vdd timex=20n
_ie99943 (net060_18 0) d2a src="99943" val0=0.0 val1=vdd valx=vdd/2 rise=2p fall=2p
_ie99944 (net048_2 0) a2d dest="99944" vl=0.3*vdd vh=0.7*vdd timex=20n
_ie99945 (net060_5 0) d2a src="99945" val0=0.0 val1=vdd valx=vdd/2 rise=2p fall=2p
_ie99946 (net41_0 0) d2a src="99946" val0=0.0 val1=vdd valx=vdd/2 rise=2p fall=2p
_ie99947 (net049_7 0) d2a src="99947" val0=0.0 val1=vdd valx=vdd/2 rise=2p fall=2p
_ie99948 (net060_1 0) d2a src="99948" val0=0.0 val1=vdd valx=vdd/2 rise=2p fall=2p
_ie99949 (net049_19 0) d2a src="99949" val0=0.0 val1=vdd valx=vdd/2 rise=2p fall=2p
_ie99950 (net060_10 0) d2a src="99950" val0=0.0 val1=vdd valx=vdd/2 rise=2p fall=2p
_ie99951 (net060_12 0) d2a src="99951" val0=0.0 val1=vdd valx=vdd/2 rise=2p fall=2p
_ie99952 (net060_17 0) d2a src="99952" val0=0.0 val1=vdd valx=vdd/2 rise=2p fall=2p
_ie99953 (net049_3 0) d2a src="99953" val0=0.0 val1=vdd valx=vdd/2 rise=2p fall=2p
_ie99954 (net060_15 0) d2a src="99954" val0=0.0 val1=vdd valx=vdd/2 rise=2p fall=2p
_ie99955 (net060_14 0) d2a src="99955" val0=0.0 val1=vdd valx=vdd/2 rise=2p fall=2p
_ie99956 (net060_16 0) d2a src="99956" val0=0.0 val1=vdd valx=vdd/2 rise=2p fall=2p
_ie99957 (net045_4 0) a2d dest="99957" vl=0.3*vdd vh=0.7*vdd timex=20n
_ie99958 (\~RRW_0 0) d2a src="99958" val0=0.0 val1=vdd valx=vdd/2 rise=2p fall=2p
_ie99959 (net41_1 0) d2a src="99959" val0=0.0 val1=vdd valx=vdd/2 rise=2p fall=2p
_ie99960 (net44_3 0) d2a src="99960" val0=0.0 val1=vdd valx=vdd/2 rise=2p fall=2p
_ie99961 (net049_15 0) d2a src="99961" val0=0.0 val1=vdd valx=vdd/2 rise=2p fall=2p
_ie99962 (net049_1 0) d2a src="99962" val0=0.0 val1=vdd valx=vdd/2 rise=2p fall=2p
_ie99963 (net049_10 0) d2a src="99963" val0=0.0 val1=vdd valx=vdd/2 rise=2p fall=2p
_ie99964 (net049_9 0) d2a src="99964" val0=0.0 val1=vdd valx=vdd/2 rise=2p fall=2p
_ie99965 (net064_1 0) d2a src="99965" val0=0.0 val1=vdd valx=vdd/2 rise=2p fall=2p
_ie99966 (net027_7 0) a2d dest="99966" vl=0.3*vdd vh=0.7*vdd timex=20n
_ie99967 (net048_4 0) a2d dest="99967" vl=0.3*vdd vh=0.7*vdd timex=20n
_ie99968 (net027_6 0) a2d dest="99968" vl=0.3*vdd vh=0.7*vdd timex=20n
_ie99969 (net048_3 0) a2d dest="99969" vl=0.3*vdd vh=0.7*vdd timex=20n
_ie99970 (\~WriteAck 0) a2d dest="99970" vl=0.3*vdd vh=0.7*vdd timex=20n
_ie99971 (net44_5 0) d2a src="99971" val0=0.0 val1=vdd valx=vdd/2 rise=2p fall=2p
_ie99972 (net027_4 0) a2d dest="99972" vl=0.3*vdd vh=0.7*vdd timex=20n
_ie99973 (net44_0 0) d2a src="99973" val0=0.0 val1=vdd valx=vdd/2 rise=2p fall=2p
_ie99974 (net049_6 0) d2a src="99974" val0=0.0 val1=vdd valx=vdd/2 rise=2p fall=2p
_ie99975 (net027_0 0) a2d dest="99975" vl=0.3*vdd vh=0.7*vdd timex=20n
_ie99976 (net049_5 0) d2a src="99976" val0=0.0 val1=vdd valx=vdd/2 rise=2p fall=2p
_ie99977 (net049_17 0) d2a src="99977" val0=0.0 val1=vdd valx=vdd/2 rise=2p fall=2p
_ie99978 (net049_4 0) d2a src="99978" val0=0.0 val1=vdd valx=vdd/2 rise=2p fall=2p
_ie99979 (net049_2 0) d2a src="99979" val0=0.0 val1=vdd valx=vdd/2 rise=2p fall=2p
_ie99980 (net048_1 0) a2d dest="99980" vl=0.3*vdd vh=0.7*vdd timex=20n
_ie99981 (net064_0 0) d2a src="99981" val0=0.0 val1=vdd valx=vdd/2 rise=2p fall=2p
_ie99982 (net060_11 0) d2a src="99982" val0=0.0 val1=vdd valx=vdd/2 rise=2p fall=2p
_ie99983 (net049_8 0) d2a src="99983" val0=0.0 val1=vdd valx=vdd/2 rise=2p fall=2p
_ie99984 (net44_2 0) d2a src="99984" val0=0.0 val1=vdd valx=vdd/2 rise=2p fall=2p
_ie99985 (net060_13 0) d2a src="99985" val0=0.0 val1=vdd valx=vdd/2 rise=2p fall=2p
_ie99986 (net44_1 0) d2a src="99986" val0=0.0 val1=vdd valx=vdd/2 rise=2p fall=2p
_ie99987 (net060_9 0) d2a src="99987" val0=0.0 val1=vdd valx=vdd/2 rise=2p fall=2p
_ie99988 (net036_0 0) a2d dest="99988" vl=0.3*vdd vh=0.7*vdd timex=20n
_ie99989 (net049_16 0) d2a src="99989" val0=0.0 val1=vdd valx=vdd/2 rise=2p fall=2p
_ie99990 (net049_0 0) d2a src="99990" val0=0.0 val1=vdd valx=vdd/2 rise=2p fall=2p
_ie99991 (net060_6 0) d2a src="99991" val0=0.0 val1=vdd valx=vdd/2 rise=2p fall=2p
_ie99992 (net027_3 0) a2d dest="99992" vl=0.3*vdd vh=0.7*vdd timex=20n
_ie99993 (net027_1 0) a2d dest="99993" vl=0.3*vdd vh=0.7*vdd timex=20n
_ie99994 (net060_19 0) d2a src="99994" val0=0.0 val1=vdd valx=vdd/2 rise=2p fall=2p
_ie99995 (net036_1 0) a2d dest="99995" vl=0.3*vdd vh=0.7*vdd timex=20n
_ie99996 (net045_1 0) a2d dest="99996" vl=0.3*vdd vh=0.7*vdd timex=20n
_ie99997 (net045_3 0) a2d dest="99997" vl=0.3*vdd vh=0.7*vdd timex=20n
_ie99998 (\~ReadAck 0) a2d dest="99998" vl=0.3*vdd vh=0.7*vdd timex=20n
_ie99999 (net060_7 0) d2a src="99999" val0=0.0 val1=vdd valx=vdd/2 rise=2p fall=2p
// END Hierarchical Interface Elements
ic ReadAckT=0 net055_0=0 net055_1=0 net055_2=0 net055_3=0 net055_4=0 W_Address_AckT_4=0 WriteAckT=0 R_AddressT_15=0 R_AddressT_14=0 R_AddressT_13=0 R_AddressT_12=0 R_AddressT_11=0 R_AddressT_10=0 R_AddressT_9=0 R_AddressT_8=0 R_AddressT_7=0 R_AddressT_6=0 R_AddressT_5=0 R_AddressT_4=0 R_AddressT_3=0 R_AddressT_2=0 R_AddressT_1=0 R_AddressT_0=0 W_AddressT_19=0 W_AddressT_18=0 W_AddressT_17=0 W_AddressT_16=0 W_AddressT_15=0 W_AddressT_14=0 W_AddressT_13=0 W_AddressT_12=0 W_AddressT_11=0 W_AddressT_10=0 W_AddressT_9=0 W_AddressT_8=0 W_AddressT_7=0 W_AddressT_6=0 W_AddressT_5=0 W_AddressT_4=0 W_AddressT_3=0 W_AddressT_2=0 W_AddressT_1=0 W_AddressT_0=0 AT_19=0 AT_18=0 AT_17=0 net046_0=0 net046_1=0 Acko_5=vdd Acko_4=vdd Acko_3=vdd Acko_2=vdd Acko_1=vdd Acko_0=vdd AT_16=0 AT_15=0 AT_14=0 AT_13=0 AT_12=0 AT_11=0 AT_10=0 AT_9=0 AT_8=0 AT_7=0 AT_6=0 AT_5=0 AT_4=0 AT_3=0 AT_2=0 AT_1=0 AT_0=0 RDataT_3=0 RDataT_2=0 RDataT_1=0 RDataT_0=0 WRWT_1=0 WRWT_0=0 WdataAckT_1=vdd WdataAckT_0=vdd RdataAckT_1=vdd RDataT_7=0 RDataT_6=0 RDataT_5=0 RDataT_4=0 WDataT_3=0 WDataT_2=0 WDataT_1=0 WDataT_0=0 WDataT_7=0 WDataT_6=0 WDataT_5=0 WDataT_4=0 RW_1=0 RW_0=0 S_7=0 S_6=0 S_5=0 S_4=0 S_3=0 S_2=0 S_1=0 S_0=0 ValAddr=0 Aline_63=0 Aline_62=0 Aline_61=0 Aline_60=0 Aline_59=0 Aline_58=0 Aline_57=0 Aline_56=0 Aline_55=0 Aline_54=0 Aline_53=0 Aline_52=0 Aline_51=0 Aline_50=0 Aline_49=0 Aline_48=0 Aline_47=0 Aline_46=0 Aline_45=0 Aline_44=0 Aline_43=0 Aline_42=0 Aline_41=0 Aline_40=0 Aline_39=0 Aline_38=0 Aline_37=0 Aline_36=0 Aline_35=0 Aline_34=0 Aline_33=0 Aline_32=0 Aline_31=0 Aline_30=0 Aline_29=0 Aline_28=0 Aline_27=0 Aline_26=0 Aline_25=0 Aline_24=0 Aline_23=0 Aline_22=0 Aline_21=0 Aline_20=0 Aline_19=0 Aline_18=0 Aline_17=0 Aline_16=0 Aline_15=0 Aline_14=0 Aline_13=0 Aline_12=0 Aline_11=0 Aline_10=0 Aline_9=0 Aline_8=0 Aline_7=0 Aline_6=0 Aline_5=0 Aline_4=0 Aline_3=0 Aline_2=0 Aline_1=0 Aline_0=0 G01=0 W0_1_3=0 W0_1_2=0 W0_1_1=0 W0_1_0=0 W1_1_3=0 W1_1_2=0 W1_1_1=0 W1_1_0=0 B0_1_3=0 B0_1_2=0 B0_1_1=0 B0_1_0=0 B1_1_3=0 B1_1_2=0 B1_1_1=0 B1_1_0=0 \~R0_1_3=vdd \~R0_1_2=vdd \~R0_1_1=vdd \~R0_1_0=vdd \~R1_1_3=vdd \~R1_1_2=vdd \~R1_1_1=vdd
simulatorOptions options temp=30.0
tran tran stop=6n errpreset=conservative
save
saveOptions options pwr=all currents=selected
