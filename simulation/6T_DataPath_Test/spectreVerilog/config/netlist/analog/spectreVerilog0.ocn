simulator( 'spectreVerilog )
design(	 "/net/kafka/nfs/rstdenis/Cadence/simulation/6T_DataPath_Test/spectreVerilog/config/netlist/analog/netlist")
resultsDir( "/net/kafka/nfs/rstdenis/Cadence/simulation/6T_DataPath_Test/spectreVerilog/config" )
modelFile(
    '("/software/cadence/ncsu-FreePDK15/hspice_16nm_hp.include" "")
)
analysis('tran ?stop "50n"  ?errpreset "conservative"  )
desVar(	  "vdd" .700	)
envOption(
	'mspSetupNetlistSimPrecisionUnit  "ps"
	'mspSetupNetlistSimTimeUnit  "ps"
	'mspSetupNetlistSwitchRC  t
	'analysisOrder  list("tran")
)
option(	'temp  "30.0"
)
saveOption( ?simOutputFormat "psfxl" )
save( 'i "/V1/PLUS" "/V1/MINUS" "/V0/PLUS" "/V0/MINUS" )
converge( 'ic "/WDataT<4>" "0" )
converge( 'ic "/WDataT<5>" "0" )
converge( 'ic "/WDataT<6>" "0" )
converge( 'ic "/WDataT<7>" "0" )
converge( 'ic "/WDataT<0>" "0" )
converge( 'ic "/WDataT<1>" "0" )
converge( 'ic "/WDataT<2>" "0" )
converge( 'ic "/WDataT<3>" "0" )
converge( 'ic "/RDataT<0>" "0" )
converge( 'ic "/RDataT<1>" "0" )
converge( 'ic "/RDataT<2>" "0" )
converge( 'ic "/RDataT<3>" "0" )
converge( 'ic "/RDataT<4>" "0" )
converge( 'ic "/RDataT<5>" "0" )
converge( 'ic "/RDataT<6>" "0" )
converge( 'ic "/RDataT<7>" "0" )
converge( 'ic "/RdataAckT<0>" "0" )
converge( 'ic "/RdataAckT<1>" "0" )
converge( 'ic "/W_AddressT<0>" "0" )
converge( 'ic "/W_AddressT<1>" "0" )
converge( 'ic "/W_AddressT<2>" "0" )
converge( 'ic "/W_AddressT<3>" "0" )
converge( 'ic "/W_AddressT<4>" "0" )
converge( 'ic "/W_AddressT<5>" "0" )
converge( 'ic "/W_AddressT<6>" "0" )
converge( 'ic "/W_AddressT<7>" "0" )
converge( 'ic "/W_AddressT<8>" "0" )
converge( 'ic "/W_AddressT<9>" "0" )
converge( 'ic "/W_AddressT<10>" "0" )
converge( 'ic "/W_AddressT<11>" "0" )
converge( 'ic "/W_AddressT<12>" "0" )
converge( 'ic "/W_AddressT<13>" "0" )
converge( 'ic "/W_AddressT<14>" "0" )
converge( 'ic "/W_AddressT<15>" "0" )
converge( 'ic "/W_AddressT<16>" "0" )
converge( 'ic "/W_AddressT<17>" "0" )
converge( 'ic "/W_AddressT<18>" "0" )
converge( 'ic "/W_AddressT<19>" "0" )
converge( 'ic "/WRWT<0>" "0" )
converge( 'ic "/WRWT<1>" "0" )
converge( 'ic "/WriteAckT" "0" )
converge( 'ic "/R_AddressT<0>" "0" )
converge( 'ic "/R_AddressT<1>" "0" )
converge( 'ic "/R_AddressT<2>" "0" )
converge( 'ic "/R_AddressT<3>" "0" )
converge( 'ic "/R_AddressT<4>" "0" )
converge( 'ic "/R_AddressT<5>" "0" )
converge( 'ic "/R_AddressT<6>" "0" )
converge( 'ic "/R_AddressT<7>" "0" )
converge( 'ic "/R_AddressT<8>" "0" )
converge( 'ic "/R_AddressT<9>" "0" )
converge( 'ic "/R_AddressT<10>" "0" )
converge( 'ic "/R_AddressT<11>" "0" )
converge( 'ic "/R_AddressT<12>" "0" )
converge( 'ic "/R_AddressT<13>" "0" )
converge( 'ic "/R_AddressT<14>" "0" )
converge( 'ic "/R_AddressT<15>" "0" )
converge( 'ic "/R_AddressT<16>" "0" )
converge( 'ic "/R_AddressT<17>" "0" )
converge( 'ic "/R_AddressT<18>" "0" )
converge( 'ic "/R_AddressT<19>" "0" )
converge( 'ic "/net055<4>" "0" )
converge( 'ic "/net055<3>" "0" )
converge( 'ic "/net055<2>" "0" )
converge( 'ic "/net055<1>" "0" )
converge( 'ic "/net055<0>" "0" )
converge( 'ic "/net046<1>" "0" )
converge( 'ic "/net046<0>" "0" )
converge( 'ic "/ReadAckT" "0" )
converge( 'ic "/B1_1<0>" "0" )
converge( 'ic "/B1_1<1>" "0" )
converge( 'ic "/B1_1<2>" "0" )
converge( 'ic "/B1_1<3>" "0" )
converge( 'ic "/B0_1<0>" "0" )
converge( 'ic "/B0_1<1>" "0" )
converge( 'ic "/B0_1<2>" "0" )
converge( 'ic "/B0_1<3>" "0" )
converge( 'ic "/W1_1<0>" "0" )
converge( 'ic "/W1_1<1>" "0" )
converge( 'ic "/W1_1<2>" "0" )
converge( 'ic "/W1_1<3>" "0" )
converge( 'ic "/W0_1<0>" "0" )
converge( 'ic "/W0_1<1>" "0" )
converge( 'ic "/W0_1<2>" "0" )
converge( 'ic "/W0_1<3>" "0" )
converge( 'ic "/G01" "0" )
converge( 'ic "/~R1_1<0>" "vdd" )
converge( 'ic "/~R1_1<1>" "vdd" )
converge( 'ic "/~R1_1<2>" "vdd" )
converge( 'ic "/~R1_1<3>" "vdd" )
converge( 'ic "/~R0_1<0>" "vdd" )
converge( 'ic "/~R0_1<1>" "vdd" )
converge( 'ic "/~R0_1<2>" "vdd" )
converge( 'ic "/~R0_1<3>" "vdd" )
converge( 'ic "/Aline<0>" "0" )
converge( 'ic "/Aline<1>" "0" )
converge( 'ic "/Aline<2>" "0" )
converge( 'ic "/Aline<3>" "0" )
converge( 'ic "/Aline<4>" "0" )
converge( 'ic "/Aline<5>" "0" )
converge( 'ic "/Aline<6>" "0" )
converge( 'ic "/Aline<7>" "0" )
converge( 'ic "/Aline<8>" "0" )
converge( 'ic "/Aline<9>" "0" )
converge( 'ic "/Aline<10>" "0" )
converge( 'ic "/Aline<11>" "0" )
converge( 'ic "/Aline<12>" "0" )
converge( 'ic "/Aline<13>" "0" )
converge( 'ic "/Aline<14>" "0" )
converge( 'ic "/Aline<15>" "0" )
converge( 'ic "/Aline<16>" "0" )
converge( 'ic "/Aline<17>" "0" )
converge( 'ic "/Aline<18>" "0" )
converge( 'ic "/Aline<19>" "0" )
converge( 'ic "/Aline<20>" "0" )
converge( 'ic "/Aline<21>" "0" )
converge( 'ic "/Aline<22>" "0" )
converge( 'ic "/Aline<23>" "0" )
converge( 'ic "/Aline<24>" "0" )
converge( 'ic "/Aline<25>" "0" )
converge( 'ic "/Aline<26>" "0" )
converge( 'ic "/Aline<27>" "0" )
converge( 'ic "/Aline<28>" "0" )
converge( 'ic "/Aline<29>" "0" )
converge( 'ic "/Aline<30>" "0" )
converge( 'ic "/Aline<31>" "0" )
converge( 'ic "/Aline<32>" "0" )
converge( 'ic "/Aline<33>" "0" )
converge( 'ic "/Aline<34>" "0" )
converge( 'ic "/Aline<35>" "0" )
converge( 'ic "/Aline<36>" "0" )
converge( 'ic "/Aline<37>" "0" )
converge( 'ic "/Aline<38>" "0" )
converge( 'ic "/Aline<39>" "0" )
converge( 'ic "/Aline<40>" "0" )
converge( 'ic "/Aline<41>" "0" )
converge( 'ic "/Aline<42>" "0" )
converge( 'ic "/Aline<43>" "0" )
converge( 'ic "/Aline<44>" "0" )
converge( 'ic "/Aline<45>" "0" )
converge( 'ic "/Aline<46>" "0" )
converge( 'ic "/Aline<47>" "0" )
converge( 'ic "/Aline<48>" "0" )
converge( 'ic "/Aline<49>" "0" )
converge( 'ic "/Aline<50>" "0" )
converge( 'ic "/Aline<51>" "0" )
converge( 'ic "/Aline<52>" "0" )
converge( 'ic "/Aline<53>" "0" )
converge( 'ic "/Aline<54>" "0" )
converge( 'ic "/Aline<55>" "0" )
converge( 'ic "/Aline<56>" "0" )
converge( 'ic "/Aline<57>" "0" )
converge( 'ic "/Aline<58>" "0" )
converge( 'ic "/Aline<59>" "0" )
converge( 'ic "/Aline<60>" "0" )
converge( 'ic "/Aline<61>" "0" )
converge( 'ic "/Aline<62>" "0" )
converge( 'ic "/Aline<63>" "0" )
converge( 'ic "/ValAddr" "0" )
converge( 'ic "/S<0>" "0" )
converge( 'ic "/S<1>" "0" )
converge( 'ic "/S<2>" "0" )
converge( 'ic "/S<3>" "0" )
converge( 'ic "/S<4>" "0" )
converge( 'ic "/S<5>" "0" )
converge( 'ic "/S<6>" "0" )
converge( 'ic "/S<7>" "0" )
converge( 'ic "/AT<16>" "0" )
converge( 'ic "/AT<17>" "0" )
converge( 'ic "/AT<18>" "0" )
converge( 'ic "/AT<19>" "0" )
converge( 'ic "/AT<12>" "0" )
converge( 'ic "/AT<13>" "0" )
converge( 'ic "/AT<14>" "0" )
converge( 'ic "/AT<15>" "0" )
converge( 'ic "/AT<4>" "0" )
converge( 'ic "/AT<5>" "0" )
converge( 'ic "/AT<6>" "0" )
converge( 'ic "/AT<7>" "0" )
converge( 'ic "/AT<0>" "0" )
converge( 'ic "/AT<1>" "0" )
converge( 'ic "/AT<2>" "0" )
converge( 'ic "/AT<3>" "0" )
converge( 'ic "/AT<8>" "0" )
converge( 'ic "/AT<9>" "0" )
converge( 'ic "/AT<10>" "0" )
converge( 'ic "/AT<11>" "0" )
converge( 'ic "/DataAck" "0" )
converge( 'ic "/IDATA/I84/n<3>" "0" )
converge( 'ic "/IDATA/I84/n<2>" "0" )
converge( 'ic "/IDATA/I84/n<1>" "0" )
converge( 'ic "/IDATA/I84/n<0>" "0" )
converge( 'ic "/IDATA/wack<0>" "0" )
converge( 'ic "/IDATA/wack<1>" "0" )
converge( 'ic "/IDATA/nB1<0>" "0" )
converge( 'ic "/IDATA/nB1<1>" "0" )
converge( 'ic "/IDATA/nB0<0>" "0" )
converge( 'ic "/IDATA/nB0<1>" "0" )
converge( 'ic "/IDATA/I84/net11" "vdd" )
converge( 'ic "/IDATA/I84/net12" "vdd" )
converge( 'ic "/IDATA/I84/net13" "vdd" )
converge( 'ic "/IDATA/I84/net14" "vdd" )
converge( 'ic "/IDATA/I84/nxa" "vdd" )
converge( 'ic "/ICHUNK/I0/I0/I7/I3/Q1" "0" )
converge( 'ic "/ICHUNK/I0/I0/I7/I3/Q0" "vdd" )
converge( 'ic "/IDATA/Wen" "0" )
converge( 'ic "/RW<0>" "0" )
converge( 'ic "/RW<1>" "0" )
converge( 'ic "/IDATA/nB1<2>" "0" )
converge( 'ic "/IDATA/nB1<3>" "0" )
converge( 'ic "/IDATA/wack<2>" "0" )
converge( 'ic "/IDATA/wack<3>" "0" )
converge( 'ic "/IDATA/nB0<2>" "0" )
converge( 'ic "/IDATA/nB0<3>" "0" )
converge( 'ic "/IDATA/R1<0>" "0" )
converge( 'ic "/IDATA/R1<1>" "0" )
converge( 'ic "/IDATA/R1<2>" "0" )
converge( 'ic "/IDATA/R1<3>" "0" )
converge( 'ic "/IDATA/R0<0>" "0" )
converge( 'ic "/IDATA/R0<1>" "0" )
converge( 'ic "/IDATA/R0<2>" "0" )
converge( 'ic "/IDATA/R0<3>" "0" )
converge( 'ic "/IDATA/R1q<0>" "0" )
converge( 'ic "/IDATA/R1q<1>" "0" )
converge( 'ic "/IDATA/R1q<2>" "0" )
converge( 'ic "/IDATA/R1q<3>" "0" )
converge( 'ic "/IDATA/R0q<0>" "0" )
converge( 'ic "/IDATA/R0q<1>" "0" )
converge( 'ic "/IDATA/R0q<2>" "0" )
converge( 'ic "/IDATA/R0q<3>" "0" )
converge( 'ic "/IDATA/RpAck<0>" "vdd" )
converge( 'ic "/IDATA/RpAck<1>" "vdd" )
converge( 'ic "/IDATA/RpAck<2>" "vdd" )
converge( 'ic "/IDATA/RpAck<3>" "vdd" )
converge( 'ic "/IDATA/I67<1>/n1<1>" "0" )
converge( 'ic "/IDATA/I67<1>/n0<1>" "0" )
converge( 'ic "/IDATA/I67<1>/n1<0>" "0" )
converge( 'ic "/IDATA/I67<1>/n0<0>" "0" )
converge( 'ic "/IDATA/I67<1>/m<3>" "vdd" )
converge( 'ic "/IDATA/I67<1>/m<2>" "vdd" )
converge( 'ic "/IDATA/I67<1>/m<1>" "vdd" )
converge( 'ic "/IDATA/I67<1>/m<0>" "vdd" )
converge( 'ic "/IDATA/I67<1>/net20" "vdd" )
converge( 'ic "/IDATA/I67<1>/net24" "vdd" )
converge( 'ic "/IDATA/I67<1>/net27" "vdd" )
converge( 'ic "/IDATA/I67<1>/net31" "vdd" )
converge( 'ic "/IDATA/I67<1>/outAck" "vdd" )
converge( 'ic "/I36/I3/outp<0>" "0" )
converge( 'ic "/I36/I3/outp<1>" "0" )
converge( 'ic "/Acko<0>" "vdd" )
converge( 'ic "/I36/I3/~out<0>" "vdd" )
converge( 'ic "/I36/I3/~out<1>" "vdd" )
converge( 'ic "/I36/I1/~out<0>" "vdd" )
converge( 'ic "/I36/I1/~out<1>" "vdd" )
converge( 'ic "/I36/I1/~out<2>" "vdd" )
converge( 'ic "/I36/I1/~out<3>" "vdd" )
converge( 'ic "/I36/I1/Vpass<0>" "0" )
converge( 'ic "/I36/I1/Vpass<1>" "0" )
converge( 'ic "/I36/I1/Vpass<2>" "0" )
converge( 'ic "/I36/I1/Vpass<3>" "0" )
converge( 'ic "/IDATA/I83<1>/inValid" "0" )
converge( 'ic "/IDATA/I83<1>/outValid" "0" )
converge( 'ic "/IDATA/I83<1>/net027" "vdd" )
converge( 'ic "/IDATA/I83<1>/inAck" "vdd" )
converge( 'ic "/IDATA/I83<1>/oE" "vdd" )
converge( 'ic "/IDATA/I80<3>/net030" "0" )
converge( 'ic "/IDATA/I80<3>/net031" "0" )
converge( 'ic "/IDATA/Lack<3>" "0" )
converge( 'ic "/IDATA/I80<3>/net027" "vdd" )
converge( 'ic "/IDATA/I80<3>/net022" "vdd" )
converge( 'ic "/Acko<1>" "vdd" )
converge( 'ic "/Acko<2>" "vdd" )
converge( 'ic "/Acko<3>" "vdd" )
converge( 'ic "/Acko<4>" "vdd" )
converge( 'ic "/Acko<5>" "vdd" )
converge( 'ic "/W_Address_AckT<0>" "0" )
converge( 'ic "/W_Address_AckT<1>" "0" )
converge( 'ic "/W_Address_AckT<2>" "0" )
converge( 'ic "/W_Address_AckT<3>" "0" )
converge( 'ic "/W_Address_AckT<4>" "0" )
converge( 'ic "/IDATA/I84/b1<0>" "vdd" )
converge( 'ic "/IDATA/I84/b0<0>" "vdd" )
converge( 'ic "/IDATA/I84/b1<1>" "vdd" )
converge( 'ic "/IDATA/I84/b0<1>" "vdd" )
converge( 'ic "/IDATA/Lack<2>" "0" )
converge( 'ic "/IDATA/Lack<1>" "0" )
converge( 'ic "/IDATA/Lack<0>" "0" )
converge( 'ic "/IDATA/intRack" "vdd" )
converge( 'ic "/IDATA/intWack" "vdd" )
converge( 'ic "/IDATA/I85<1>/inValid" "0" )
converge( 'ic "/IDATA/I85<1>/outValid" "0" )
converge( 'ic "/IDATA/I85<1>/inAck" "vdd" )
converge( 'ic "/IDATA/I85<1>/net027" "vdd" )
converge( 'ic "/IDATA/I85<1>/oE" "vdd" )
converge( 'ic "/IDATA/I86/n<3>" "0" )
converge( 'ic "/IDATA/I86/n<2>" "0" )
converge( 'ic "/IDATA/I86/n<1>" "0" )
converge( 'ic "/IDATA/I86/n<0>" "0" )
converge( 'ic "/IDATA/I86/b1<0>" "vdd" )
converge( 'ic "/IDATA/I86/b0<1>" "vdd" )
converge( 'ic "/IDATA/I86/b1<1>" "vdd" )
converge( 'ic "/IDATA/I86/b0<0>" "vdd" )
converge( 'ic "/IDATA/I86/net11" "vdd" )
converge( 'ic "/IDATA/I86/net12" "vdd" )
converge( 'ic "/IDATA/I86/net13" "vdd" )
converge( 'ic "/IDATA/I86/net14" "vdd" )
converge( 'ic "/IDATA/I86/nxa" "vdd" )
converge( 'ic "/I36/I1/bmid<3>" "0" )
converge( 'ic "/I36/I1/amid<0>" "0" )
converge( 'ic "/I36/I1/bmid<2>" "0" )
converge( 'ic "/I36/I1/amid<1>" "0" )
converge( 'ic "/I36/I1/bmid<1>" "0" )
converge( 'ic "/I36/I1/amid<2>" "0" )
converge( 'ic "/I36/I1/bmid<0>" "0" )
converge( 'ic "/I36/I1/amid<3>" "0" )
converge( 'ic "/I36/I3/bp<1>" "0" )
converge( 'ic "/I36/I3/bp<0>" "0" )
converge( 'ic "/I36/I3/ap<1>" "0" )
converge( 'ic "/I36/I3/ap<0>" "0" )
converge( 'ic "/I36/I0/I22/bmid<3>" "0" )
converge( 'ic "/I36/I0/I22/amid<0>" "0" )
converge( 'ic "/I36/I0/I22/bmid<2>" "0" )
converge( 'ic "/I36/I0/I22/amid<1>" "0" )
converge( 'ic "/I36/I0/I22/bmid<1>" "0" )
converge( 'ic "/I36/I0/I22/amid<2>" "0" )
converge( 'ic "/I36/I0/I22/bmid<0>" "0" )
converge( 'ic "/I36/I0/I22/amid<3>" "0" )
converge( 'ic "/I36/I0/I22/Vpass<0>" "0" )
converge( 'ic "/I36/I0/I22/Vpass<1>" "0" )
converge( 'ic "/I36/I0/I22/Vpass<2>" "0" )
converge( 'ic "/I36/I0/I22/Vpass<3>" "0" )
converge( 'ic "/WdataAckT<0>" "0" )
converge( 'ic "/WdataAckT<1>" "0" )
temp( 30.0 )
run()
selectResult( 'tran )
plot(getData("/~R1_1<3>") getData("/~R1_1<2>") getData("/~R1_1<1>") getData("/~R1_1<0>") getData("/~R0_1<3>") getData("/~R0_1<2>") getData("/~R0_1<1>") getData("/~R0_1<0>") getData("/vdd!") getData("/vcc!") getData("/WriteAckT") getData("/WriteAck") getData("/WdataAckT<1>") getData("/WdataAckT<0>") getData("/WdataAck<1:0>") getData("/W_Address_AckT<4>") getData("/W_Address_AckT<3>") getData("/W_Address_AckT<2>") getData("/W_Address_AckT<1>") getData("/W_Address_AckT<0>") getData("/W_Address<19:0>") getData("/W_AddresAck<4:0>") getData("/WRWT<1>") getData("/WRWT<0>") getData("/WRW<1:0>") getData("/WDataT<7>") getData("/WDataT<6>") getData("/WDataT<5>") getData("/WDataT<4>") getData("/WDataT<3>") getData("/WDataT<2>") getData("/WDataT<1>") getData("/WDataT<0>") getData("/WData<7:0>") getData("/W1_1<3>") getData("/W1_1<2>") getData("/W1_1<1>") getData("/W1_1<0>") getData("/W0_1<3>") getData("/W0_1<2>") getData("/W0_1<1>") getData("/W0_1<0>") getData("/ValAddr") getData("/V1/PLUS") getData("/V1/MINUS") getData("/V0/PLUS") getData("/V0/MINUS") getData("/S<7>") getData("/S<6>") getData("/S<5>") getData("/S<4>") getData("/S<3>") getData("/S<2>") getData("/S<1>") getData("/S<0>") getData("/ReadAckT") getData("/ReadAck") getData("/RdataAckT<1>") getData("/RdataAckT<0>") getData("/RdataAck<1:0>") getData("/R_AddressAck<4:0>") getData("/R_Address<19:0>") getData("/RW<1>") getData("/RW<0>") getData("/RRW<1:0>") getData("/RDataT<7>") getData("/RDataT<6>") getData("/RDataT<5>") getData("/RDataT<4>") getData("/RDataT<3>") getData("/RDataT<2>") getData("/RDataT<1>") getData("/RDataT<0>") getData("/RData<7:0>") getData("/IDATA/wack<3>") getData("/IDATA/wack<2>") getData("/IDATA/wack<1>") getData("/IDATA/wack<0>") getData("/IDATA/nB1<3>") getData("/IDATA/nB1<2>") getData("/IDATA/nB1<1>") getData("/IDATA/nB1<0>") getData("/IDATA/nB0<3>") getData("/IDATA/nB0<2>") getData("/IDATA/nB0<1>") getData("/IDATA/nB0<0>") getData("/IDATA/intWack") getData("/IDATA/intRack") getData("/IDATA/Wen") getData("/IDATA/RpAck<3>") getData("/IDATA/RpAck<2>") getData("/IDATA/RpAck<1>") getData("/IDATA/RpAck<0>") getData("/IDATA/R1q<3>") getData("/IDATA/R1q<2>") getData("/IDATA/R1q<1>") getData("/IDATA/R1q<0>") getData("/IDATA/R1<3>") getData("/IDATA/R1<2>") getData("/IDATA/R1<1>") getData("/IDATA/R1<0>") getData("/IDATA/R0q<3>") getData("/IDATA/R0q<2>") getData("/IDATA/R0q<1>") getData("/IDATA/R0q<0>") getData("/IDATA/R0<3>") getData("/IDATA/R0<2>") getData("/IDATA/R0<1>") getData("/IDATA/R0<0>") getData("/IDATA/Lack<3>") getData("/IDATA/Lack<2>") getData("/IDATA/Lack<1>") getData("/IDATA/Lack<0>") getData("/ICHUNK/I0/I0/I7/I3/Q1") getData("/ICHUNK/I0/I0/I7/I3/Q0") getData("/ICHUNK/I0/B1P1") getData("/ICHUNK/I0/B0P1") getData("/G01") getData("/DataAck") getData("/B1_1<3>") getData("/B1_1<2>") getData("/B1_1<1>") getData("/B1_1<0>") getData("/B0_1<3>") getData("/B0_1<2>") getData("/B0_1<1>") getData("/B0_1<0>") getData("/Aline<0>") getData("/Acko<5>") getData("/Acko<4>") getData("/Acko<3>") getData("/Acko<2>") getData("/Acko<1>") getData("/Acko<0>") getData("/AT<9>") getData("/AT<8>") getData("/AT<7>") getData("/AT<6>") getData("/AT<5>") getData("/AT<4>") getData("/AT<3>") getData("/AT<2>") getData("/AT<1>") getData("/AT<19>") getData("/AT<18>") getData("/AT<17>") getData("/AT<16>") getData("/AT<15>") getData("/AT<14>") getData("/AT<13>") getData("/AT<12>") getData("/AT<11>") getData("/AT<10>") getData("/AT<0>") )
modelFile(
    '("/software/cadence/ncsu-FreePDK15/hspice_16nm_hp.include" "")
)
option(	'inventory  "detailed"
	'audit  "detailed"
	'multithread  "on"
)
run()
selectResult( 'tran )
plot(getData("/~R1_1<3>") getData("/~R1_1<2>") getData("/~R1_1<1>") getData("/~R1_1<0>") getData("/~R0_1<3>") getData("/~R0_1<2>") getData("/~R0_1<1>") getData("/~R0_1<0>") getData("/vdd!") getData("/vcc!") getData("/WriteAckT") getData("/WriteAck") getData("/WdataAckT<1>") getData("/WdataAckT<0>") getData("/WdataAck<1:0>") getData("/W_Address_AckT<4>") getData("/W_Address_AckT<3>") getData("/W_Address_AckT<2>") getData("/W_Address_AckT<1>") getData("/W_Address_AckT<0>") getData("/W_Address<19:0>") getData("/W_AddresAck<4:0>") getData("/WRWT<1>") getData("/WRWT<0>") getData("/WRW<1:0>") getData("/WDataT<7>") getData("/WDataT<6>") getData("/WDataT<5>") getData("/WDataT<4>") getData("/WDataT<3>") getData("/WDataT<2>") getData("/WDataT<1>") getData("/WDataT<0>") getData("/WData<7:0>") getData("/W1_1<3>") getData("/W1_1<2>") getData("/W1_1<1>") getData("/W1_1<0>") getData("/W0_1<3>") getData("/W0_1<2>") getData("/W0_1<1>") getData("/W0_1<0>") getData("/ValAddr") getData("/V1/PLUS") getData("/V1/MINUS") getData("/V0/PLUS") getData("/V0/MINUS") getData("/S<7>") getData("/S<6>") getData("/S<5>") getData("/S<4>") getData("/S<3>") getData("/S<2>") getData("/S<1>") getData("/S<0>") getData("/ReadAckT") getData("/ReadAck") getData("/RdataAckT<1>") getData("/RdataAckT<0>") getData("/RdataAck<1:0>") getData("/R_AddressAck<4:0>") getData("/R_Address<19:0>") getData("/RW<1>") getData("/RW<0>") getData("/RRW<1:0>") getData("/RDataT<7>") getData("/RDataT<6>") getData("/RDataT<5>") getData("/RDataT<4>") getData("/RDataT<3>") getData("/RDataT<2>") getData("/RDataT<1>") getData("/RDataT<0>") getData("/RData<7:0>") getData("/IDATA/wack<3>") getData("/IDATA/wack<2>") getData("/IDATA/wack<1>") getData("/IDATA/wack<0>") getData("/IDATA/nB1<3>") getData("/IDATA/nB1<2>") getData("/IDATA/nB1<1>") getData("/IDATA/nB1<0>") getData("/IDATA/nB0<3>") getData("/IDATA/nB0<2>") getData("/IDATA/nB0<1>") getData("/IDATA/nB0<0>") getData("/IDATA/intWack") getData("/IDATA/intRack") getData("/IDATA/Wen") getData("/IDATA/RpAck<3>") getData("/IDATA/RpAck<2>") getData("/IDATA/RpAck<1>") getData("/IDATA/RpAck<0>") getData("/IDATA/R1q<3>") getData("/IDATA/R1q<2>") getData("/IDATA/R1q<1>") getData("/IDATA/R1q<0>") getData("/IDATA/R1<3>") getData("/IDATA/R1<2>") getData("/IDATA/R1<1>") getData("/IDATA/R1<0>") getData("/IDATA/R0q<3>") getData("/IDATA/R0q<2>") getData("/IDATA/R0q<1>") getData("/IDATA/R0q<0>") getData("/IDATA/R0<3>") getData("/IDATA/R0<2>") getData("/IDATA/R0<1>") getData("/IDATA/R0<0>") getData("/IDATA/Lack<3>") getData("/IDATA/Lack<2>") getData("/IDATA/Lack<1>") getData("/IDATA/Lack<0>") getData("/ICHUNK/I0/I0/I7/I3/Q1") getData("/ICHUNK/I0/I0/I7/I3/Q0") getData("/ICHUNK/I0/B1P1") getData("/ICHUNK/I0/B0P1") getData("/G01") getData("/DataAck") getData("/B1_1<3>") getData("/B1_1<2>") getData("/B1_1<1>") getData("/B1_1<0>") getData("/B0_1<3>") getData("/B0_1<2>") getData("/B0_1<1>") getData("/B0_1<0>") getData("/Aline<0>") getData("/Acko<5>") getData("/Acko<4>") getData("/Acko<3>") getData("/Acko<2>") getData("/Acko<1>") getData("/Acko<0>") getData("/AT<9>") getData("/AT<8>") getData("/AT<7>") getData("/AT<6>") getData("/AT<5>") getData("/AT<4>") getData("/AT<3>") getData("/AT<2>") getData("/AT<1>") getData("/AT<19>") getData("/AT<18>") getData("/AT<17>") getData("/AT<16>") getData("/AT<15>") getData("/AT<14>") getData("/AT<13>") getData("/AT<12>") getData("/AT<11>") getData("/AT<10>") getData("/AT<0>") )
modelFile(
    '("/software/cadence/ncsu-FreePDK15/hspice_16nm_hp.include" "")
)
analysis('tran
		?readns "/net/kafka/nfs/rstdenis/Cadence/simulation/6T_DataPathSimple_Test/spectreVerilog/config/netlist/spectre.ic"
		)
run()
selectResult( 'tran )
plot(getData("/~R1_1<3>") getData("/~R1_1<2>") getData("/~R1_1<1>") getData("/~R1_1<0>") getData("/~R0_1<3>") getData("/~R0_1<2>") getData("/~R0_1<1>") getData("/~R0_1<0>") getData("/vdd!") getData("/vcc!") getData("/WriteAckT") getData("/WriteAck") getData("/WdataAckT<1>") getData("/WdataAckT<0>") getData("/WdataAck<1:0>") getData("/W_Address_AckT<4>") getData("/W_Address_AckT<3>") getData("/W_Address_AckT<2>") getData("/W_Address_AckT<1>") getData("/W_Address_AckT<0>") getData("/W_Address<19:0>") getData("/W_AddresAck<4:0>") getData("/WRWT<1>") getData("/WRWT<0>") getData("/WRW<1:0>") getData("/WDataT<7>") getData("/WDataT<6>") getData("/WDataT<5>") getData("/WDataT<4>") getData("/WDataT<3>") getData("/WDataT<2>") getData("/WDataT<1>") getData("/WDataT<0>") getData("/WData<7:0>") getData("/W1_1<3>") getData("/W1_1<2>") getData("/W1_1<1>") getData("/W1_1<0>") getData("/W0_1<3>") getData("/W0_1<2>") getData("/W0_1<1>") getData("/W0_1<0>") getData("/ValAddr") getData("/V1/PLUS") getData("/V1/MINUS") getData("/V0/PLUS") getData("/V0/MINUS") getData("/S<7>") getData("/S<6>") getData("/S<5>") getData("/S<4>") getData("/S<3>") getData("/S<2>") getData("/S<1>") getData("/S<0>") getData("/ReadAckT") getData("/ReadAck") getData("/RdataAckT<1>") getData("/RdataAckT<0>") getData("/RdataAck<1:0>") getData("/R_AddressAck<4:0>") getData("/R_Address<19:0>") getData("/RW<1>") getData("/RW<0>") getData("/RRW<1:0>") getData("/RDataT<7>") getData("/RDataT<6>") getData("/RDataT<5>") getData("/RDataT<4>") getData("/RDataT<3>") getData("/RDataT<2>") getData("/RDataT<1>") getData("/RDataT<0>") getData("/RData<7:0>") getData("/IDATA/wack<3>") getData("/IDATA/wack<2>") getData("/IDATA/wack<1>") getData("/IDATA/wack<0>") getData("/IDATA/nB1<3>") getData("/IDATA/nB1<2>") getData("/IDATA/nB1<1>") getData("/IDATA/nB1<0>") getData("/IDATA/nB0<3>") getData("/IDATA/nB0<2>") getData("/IDATA/nB0<1>") getData("/IDATA/nB0<0>") getData("/IDATA/intWack") getData("/IDATA/intRack") getData("/IDATA/Wen") getData("/IDATA/RpAck<3>") getData("/IDATA/RpAck<2>") getData("/IDATA/RpAck<1>") getData("/IDATA/RpAck<0>") getData("/IDATA/R1q<3>") getData("/IDATA/R1q<2>") getData("/IDATA/R1q<1>") getData("/IDATA/R1q<0>") getData("/IDATA/R1<3>") getData("/IDATA/R1<2>") getData("/IDATA/R1<1>") getData("/IDATA/R1<0>") getData("/IDATA/R0q<3>") getData("/IDATA/R0q<2>") getData("/IDATA/R0q<1>") getData("/IDATA/R0q<0>") getData("/IDATA/R0<3>") getData("/IDATA/R0<2>") getData("/IDATA/R0<1>") getData("/IDATA/R0<0>") getData("/IDATA/Lack<3>") getData("/IDATA/Lack<2>") getData("/IDATA/Lack<1>") getData("/IDATA/Lack<0>") getData("/ICHUNK/I0/I0/I7/I3/Q1") getData("/ICHUNK/I0/I0/I7/I3/Q0") getData("/ICHUNK/I0/B1P1") getData("/ICHUNK/I0/B0P1") getData("/G01") getData("/DataAck") getData("/B1_1<3>") getData("/B1_1<2>") getData("/B1_1<1>") getData("/B1_1<0>") getData("/B0_1<3>") getData("/B0_1<2>") getData("/B0_1<1>") getData("/B0_1<0>") getData("/Aline<0>") getData("/Acko<5>") getData("/Acko<4>") getData("/Acko<3>") getData("/Acko<2>") getData("/Acko<1>") getData("/Acko<0>") getData("/AT<9>") getData("/AT<8>") getData("/AT<7>") getData("/AT<6>") getData("/AT<5>") getData("/AT<4>") getData("/AT<3>") getData("/AT<2>") getData("/AT<1>") getData("/AT<19>") getData("/AT<18>") getData("/AT<17>") getData("/AT<16>") getData("/AT<15>") getData("/AT<14>") getData("/AT<13>") getData("/AT<12>") getData("/AT<11>") getData("/AT<10>") getData("/AT<0>") )
modelFile(
    '("/software/cadence/ncsu-FreePDK15/hspice_16nm_hp.include" "")
)
analysis('tran
		?readns "/net/kafka/nfs/rstdenis/Cadence/simulation/6T_DataPath_Test/spectreVerilog/config/netlist/spectre.ic"
		)
converge( 'ic "/I36/I3/net19" "vdd" )
converge( 'ic "/I36/I3/net20" "vdd" )
converge( 'ic "/I36/I3/net13" "vdd" )
converge( 'ic "/IDATA/I10/n<3>" "0" )
converge( 'ic "/IDATA/I10/n<2>" "0" )
converge( 'ic "/IDATA/I10/n<1>" "0" )
converge( 'ic "/IDATA/I10/n<0>" "0" )
converge( 'ic "/IDATA/I10/b1<0>" "vdd" )
converge( 'ic "/IDATA/I10/b0<1>" "vdd" )
converge( 'ic "/IDATA/I10/b0<0>" "vdd" )
converge( 'ic "/IDATA/I10/b1<1>" "vdd" )
converge( 'ic "/IDATA/I10/net11" "vdd" )
converge( 'ic "/IDATA/I10/net12" "vdd" )
converge( 'ic "/IDATA/I10/net13" "vdd" )
converge( 'ic "/IDATA/I10/net14" "vdd" )
converge( 'ic "/IDATA/I10/nxa" "vdd" )
converge( 'ic "/IDATA/I12<1>/net027" "vdd" )
converge( 'ic "/IDATA/I12<1>/inAck" "vdd" )
converge( 'ic "/IDATA/I12<1>/oE" "vdd" )
converge( 'ic "/IDATA/I3<1>/n1<1>" "0" )
converge( 'ic "/IDATA/I3<1>/n0<1>" "0" )
converge( 'ic "/IDATA/I3<1>/n1<0>" "0" )
converge( 'ic "/IDATA/I3<1>/n0<0>" "0" )
converge( 'ic "/IDATA/I3<1>/m<2>" "vdd" )
converge( 'ic "/IDATA/I3<1>/m<1>" "vdd" )
converge( 'ic "/IDATA/I3<1>/m<0>" "vdd" )
converge( 'ic "/IDATA/I3<1>/m<3>" "vdd" )
converge( 'ic "/IDATA/I3<1>/net20" "vdd" )
converge( 'ic "/IDATA/I3<1>/net24" "vdd" )
converge( 'ic "/IDATA/I3<1>/net27" "vdd" )
converge( 'ic "/IDATA/I3<1>/net31" "vdd" )
converge( 'ic "/IDATA/I3<1>/outAck" "vdd" )
run()
selectResult( 'tran )
plot(getData("/~R1_1<3>") getData("/~R1_1<2>") getData("/~R1_1<1>") getData("/~R1_1<0>") getData("/~R0_1<3>") getData("/~R0_1<2>") getData("/~R0_1<1>") getData("/~R0_1<0>") getData("/vdd!") getData("/vcc!") getData("/WriteAckT") getData("/WriteAck") getData("/WdataAckT<1>") getData("/WdataAckT<0>") getData("/WdataAck<1:0>") getData("/W_Address_AckT<4>") getData("/W_Address_AckT<3>") getData("/W_Address_AckT<2>") getData("/W_Address_AckT<1>") getData("/W_Address_AckT<0>") getData("/W_Address<19:0>") getData("/W_AddresAck<4:0>") getData("/WRWT<1>") getData("/WRWT<0>") getData("/WRW<1:0>") getData("/WDataT<7>") getData("/WDataT<6>") getData("/WDataT<5>") getData("/WDataT<4>") getData("/WDataT<3>") getData("/WDataT<2>") getData("/WDataT<1>") getData("/WDataT<0>") getData("/WData<7:0>") getData("/W1_1<3>") getData("/W1_1<2>") getData("/W1_1<1>") getData("/W1_1<0>") getData("/W0_1<3>") getData("/W0_1<2>") getData("/W0_1<1>") getData("/W0_1<0>") getData("/ValAddr") getData("/V1/PLUS") getData("/V1/MINUS") getData("/V0/PLUS") getData("/V0/MINUS") getData("/S<7>") getData("/S<6>") getData("/S<5>") getData("/S<4>") getData("/S<3>") getData("/S<2>") getData("/S<1>") getData("/S<0>") getData("/ReadAckT") getData("/ReadAck") getData("/RdataAckT<1>") getData("/RdataAckT<0>") getData("/RdataAck<1:0>") getData("/R_AddressAck<4:0>") getData("/R_Address<19:0>") getData("/RW<1>") getData("/RW<0>") getData("/RRW<1:0>") getData("/RDataT<7>") getData("/RDataT<6>") getData("/RDataT<5>") getData("/RDataT<4>") getData("/RDataT<3>") getData("/RDataT<2>") getData("/RDataT<1>") getData("/RDataT<0>") getData("/RData<7:0>") getData("/IDATA/wack<3>") getData("/IDATA/wack<2>") getData("/IDATA/wack<1>") getData("/IDATA/wack<0>") getData("/IDATA/nB1<3>") getData("/IDATA/nB1<2>") getData("/IDATA/nB1<1>") getData("/IDATA/nB1<0>") getData("/IDATA/nB0<3>") getData("/IDATA/nB0<2>") getData("/IDATA/nB0<1>") getData("/IDATA/nB0<0>") getData("/IDATA/intWack") getData("/IDATA/intRack") getData("/IDATA/Wen") getData("/IDATA/RpAck<3>") getData("/IDATA/RpAck<2>") getData("/IDATA/RpAck<1>") getData("/IDATA/RpAck<0>") getData("/IDATA/R1q<3>") getData("/IDATA/R1q<2>") getData("/IDATA/R1q<1>") getData("/IDATA/R1q<0>") getData("/IDATA/R1<3>") getData("/IDATA/R1<2>") getData("/IDATA/R1<1>") getData("/IDATA/R1<0>") getData("/IDATA/R0q<3>") getData("/IDATA/R0q<2>") getData("/IDATA/R0q<1>") getData("/IDATA/R0q<0>") getData("/IDATA/R0<3>") getData("/IDATA/R0<2>") getData("/IDATA/R0<1>") getData("/IDATA/R0<0>") getData("/IDATA/Lack<3>") getData("/IDATA/Lack<2>") getData("/IDATA/Lack<1>") getData("/IDATA/Lack<0>") getData("/ICHUNK/I0/I0/I7/I3/Q1") getData("/ICHUNK/I0/I0/I7/I3/Q0") getData("/ICHUNK/I0/B1P1") getData("/ICHUNK/I0/B0P1") getData("/G01") getData("/DataAck") getData("/B1_1<3>") getData("/B1_1<2>") getData("/B1_1<1>") getData("/B1_1<0>") getData("/B0_1<3>") getData("/B0_1<2>") getData("/B0_1<1>") getData("/B0_1<0>") getData("/Aline<0>") getData("/Acko<5>") getData("/Acko<4>") getData("/Acko<3>") getData("/Acko<2>") getData("/Acko<1>") getData("/Acko<0>") getData("/AT<9>") getData("/AT<8>") getData("/AT<7>") getData("/AT<6>") getData("/AT<5>") getData("/AT<4>") getData("/AT<3>") getData("/AT<2>") getData("/AT<1>") getData("/AT<19>") getData("/AT<18>") getData("/AT<17>") getData("/AT<16>") getData("/AT<15>") getData("/AT<14>") getData("/AT<13>") getData("/AT<12>") getData("/AT<11>") getData("/AT<10>") getData("/AT<0>") )
