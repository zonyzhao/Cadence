simulator( 'spectreVerilog )
design(	 "/net/kafka/nfs/rstdenis/Cadence/simulation/6T_DataPath_Test/spectreVerilog/config/netlist/analog/netlist")
resultsDir( "/net/kafka/nfs/rstdenis/Cadence/simulation/6T_DataPath_Test/spectreVerilog/config" )
modelFile(
    '("/software/cadence/ncsu-FreePDK15/hspice_16nm_hp.include" "")
)
analysis('tran ?stop "6n"  ?errpreset "conservative"  )
desVar(	  "vdd" 0.850	)
envOption(
	'mspSetupNetlistSimPrecisionUnit  "ps"
	'mspSetupNetlistSimTimeUnit  "ps"
	'mspSetupNetlistSwitchRC  t
)
option(	'multithread  "on"
)
saveOption( ?simOutputFormat "psfxl" )
temp( 27 )
run()
selectResult( 'tran )
plot(getData("/WData<7:0>") getData("/En") getData("/ValAddr") getData("/RWT<1>") getData("/RWT<0>") getData("/RAckT<1>") getData("/RAckT<0>") getData("/WAckT<1>") getData("/WAckT<0>") getData("/WDataT<7>") getData("/WDataT<6>") getData("/WDataT<5>") getData("/WDataT<4>") getData("/WDataT<3>") getData("/WDataT<2>") getData("/WDataT<1>") getData("/WDataT<0>") getData("/RDataT<3>") getData("/RDataT<2>") getData("/RDataT<1>") getData("/RDataT<0>") getData("/RDataT<7>") getData("/RDataT<6>") getData("/RDataT<5>") getData("/RDataT<4>") getData("/AT<3>") getData("/AT<2>") getData("/AT<1>") getData("/AT<0>") getData("/AT<15>") getData("/AT<14>") getData("/AT<13>") getData("/AT<12>") getData("/AT<11>") getData("/AT<10>") getData("/AT<9>") getData("/AT<8>") getData("/AT<7>") getData("/AT<6>") getData("/AT<5>") getData("/AT<4>") getData("/AckT") )
modelFile(
    '("/software/cadence/ncsu-FreePDK15/hspice_16nm_hp.include" "")
)
run()
selectResult( 'tran )
plot(getData("/WData<7:0>") getData("/En") getData("/ValAddr") getData("/RWT<1>") getData("/RWT<0>") getData("/RAckT<1>") getData("/RAckT<0>") getData("/WAckT<1>") getData("/WAckT<0>") getData("/WDataT<7>") getData("/WDataT<6>") getData("/WDataT<5>") getData("/WDataT<4>") getData("/WDataT<3>") getData("/WDataT<2>") getData("/WDataT<1>") getData("/WDataT<0>") getData("/RDataT<3>") getData("/RDataT<2>") getData("/RDataT<1>") getData("/RDataT<0>") getData("/RDataT<7>") getData("/RDataT<6>") getData("/RDataT<5>") getData("/RDataT<4>") getData("/AT<3>") getData("/AT<2>") getData("/AT<1>") getData("/AT<0>") getData("/AT<15>") getData("/AT<14>") getData("/AT<13>") getData("/AT<12>") getData("/AT<11>") getData("/AT<10>") getData("/AT<9>") getData("/AT<8>") getData("/AT<7>") getData("/AT<6>") getData("/AT<5>") getData("/AT<4>") getData("/AckT") )
modelFile(
    '("/software/cadence/ncsu-FreePDK15/hspice_16nm_hp.include" "")
)
run()
selectResult( 'tran )
plot(getData("/WData<7:0>") getData("/En") getData("/ValAddr") getData("/RWT<1>") getData("/RWT<0>") getData("/RAckT<1>") getData("/RAckT<0>") getData("/WAckT<1>") getData("/WAckT<0>") getData("/WDataT<7>") getData("/WDataT<6>") getData("/WDataT<5>") getData("/WDataT<4>") getData("/WDataT<3>") getData("/WDataT<2>") getData("/WDataT<1>") getData("/WDataT<0>") getData("/RDataT<3>") getData("/RDataT<2>") getData("/RDataT<1>") getData("/RDataT<0>") getData("/RDataT<7>") getData("/RDataT<6>") getData("/RDataT<5>") getData("/RDataT<4>") getData("/AT<3>") getData("/AT<2>") getData("/AT<1>") getData("/AT<0>") getData("/AT<15>") getData("/AT<14>") getData("/AT<13>") getData("/AT<12>") getData("/AT<11>") getData("/AT<10>") getData("/AT<9>") getData("/AT<8>") getData("/AT<7>") getData("/AT<6>") getData("/AT<5>") getData("/AT<4>") getData("/AckT") )
modelFile(
    '("/software/cadence/ncsu-FreePDK15/hspice_16nm_hp.include" "")
)
converge( 'ic "/WDataT<4>" "0" )
converge( 'ic "/WDataT<5>" "0" )
converge( 'ic "/WDataT<6>" "0" )
converge( 'ic "/WDataT<7>" "0" )
converge( 'ic "/WDataT<0>" "0" )
converge( 'ic "/WDataT<1>" "0" )
converge( 'ic "/WDataT<2>" "0" )
converge( 'ic "/WDataT<3>" "0" )
converge( 'ic "/RDataT<0>" "0" )
converge( 'ic "/RDataT<1>" "0" )
converge( 'ic "/RDataT<2>" "0" )
converge( 'ic "/RDataT<3>" "0" )
converge( 'ic "/RDataT<4>" "0" )
converge( 'ic "/RDataT<5>" "0" )
converge( 'ic "/RDataT<6>" "0" )
converge( 'ic "/RDataT<7>" "0" )
converge( 'ic "/RWT<0>" "0" )
converge( 'ic "/RWT<1>" "0" )
converge( 'ic "/ValAddr" "0" )
converge( 'ic "/G01" "0" )
converge( 'ic "/W0_1<0>" "0" )
converge( 'ic "/W0_1<1>" "0" )
converge( 'ic "/W0_1<2>" "0" )
converge( 'ic "/W0_1<3>" "0" )
converge( 'ic "/W1_1<0>" "0" )
converge( 'ic "/W1_1<1>" "0" )
converge( 'ic "/W1_1<2>" "0" )
converge( 'ic "/W1_1<3>" "0" )
converge( 'ic "/B0_1<0>" "0" )
converge( 'ic "/B0_1<1>" "0" )
converge( 'ic "/B0_1<2>" "0" )
converge( 'ic "/B0_1<3>" "0" )
converge( 'ic "/B1_1<0>" "0" )
converge( 'ic "/B1_1<1>" "0" )
converge( 'ic "/B1_1<2>" "0" )
converge( 'ic "/B1_1<3>" "0" )
converge( 'ic "/net54<63>" "0" )
converge( 'ic "/net54<62>" "0" )
converge( 'ic "/net54<61>" "0" )
converge( 'ic "/net54<60>" "0" )
converge( 'ic "/net54<59>" "0" )
converge( 'ic "/net54<58>" "0" )
converge( 'ic "/net54<57>" "0" )
converge( 'ic "/net54<56>" "0" )
converge( 'ic "/net54<55>" "0" )
converge( 'ic "/net54<54>" "0" )
converge( 'ic "/net54<53>" "0" )
converge( 'ic "/net54<52>" "0" )
converge( 'ic "/net54<51>" "0" )
converge( 'ic "/net54<50>" "0" )
converge( 'ic "/net54<49>" "0" )
converge( 'ic "/net54<48>" "0" )
converge( 'ic "/net54<47>" "0" )
converge( 'ic "/net54<46>" "0" )
converge( 'ic "/net54<45>" "0" )
converge( 'ic "/net54<44>" "0" )
converge( 'ic "/net54<43>" "0" )
converge( 'ic "/net54<42>" "0" )
converge( 'ic "/net54<41>" "0" )
converge( 'ic "/net54<40>" "0" )
converge( 'ic "/net54<39>" "0" )
converge( 'ic "/net54<38>" "0" )
converge( 'ic "/net54<37>" "0" )
converge( 'ic "/net54<36>" "0" )
converge( 'ic "/net54<35>" "0" )
converge( 'ic "/net54<34>" "0" )
converge( 'ic "/net54<33>" "0" )
converge( 'ic "/net54<32>" "0" )
converge( 'ic "/net54<31>" "0" )
converge( 'ic "/net54<30>" "0" )
converge( 'ic "/net54<29>" "0" )
converge( 'ic "/net54<28>" "0" )
converge( 'ic "/net54<27>" "0" )
converge( 'ic "/net54<26>" "0" )
converge( 'ic "/net54<25>" "0" )
converge( 'ic "/net54<24>" "0" )
converge( 'ic "/net54<23>" "0" )
converge( 'ic "/net54<22>" "0" )
converge( 'ic "/net54<21>" "0" )
converge( 'ic "/net54<20>" "0" )
converge( 'ic "/net54<19>" "0" )
converge( 'ic "/net54<18>" "0" )
converge( 'ic "/net54<17>" "0" )
converge( 'ic "/net54<16>" "0" )
converge( 'ic "/net54<15>" "0" )
converge( 'ic "/net54<14>" "0" )
converge( 'ic "/net54<13>" "0" )
converge( 'ic "/net54<12>" "0" )
converge( 'ic "/net54<11>" "0" )
converge( 'ic "/net54<10>" "0" )
converge( 'ic "/net54<9>" "0" )
converge( 'ic "/net54<8>" "0" )
converge( 'ic "/net54<7>" "0" )
converge( 'ic "/net54<6>" "0" )
converge( 'ic "/net54<5>" "0" )
converge( 'ic "/net54<4>" "0" )
converge( 'ic "/net54<3>" "0" )
converge( 'ic "/net54<2>" "0" )
converge( 'ic "/net54<1>" "0" )
converge( 'ic "/net54<0>" "0" )
converge( 'ic "/net55<7>" "0" )
converge( 'ic "/net55<6>" "0" )
converge( 'ic "/net55<5>" "0" )
converge( 'ic "/net55<4>" "0" )
converge( 'ic "/net55<3>" "0" )
converge( 'ic "/net55<2>" "0" )
converge( 'ic "/net55<1>" "0" )
converge( 'ic "/net55<0>" "0" )
converge( 'ic "/ICHUNK/I0/I0/I7/I3/Q0" "0" )
converge( 'ic "/WAckT<0>" "vdd" )
converge( 'ic "/WAckT<1>" "vdd" )
converge( 'ic "/RAckT<0>" "vdd" )
converge( 'ic "/RAckT<1>" "vdd" )
converge( 'ic "/AckT" "vdd" )
run()
selectResult( 'tran )
plot(getData("/ICHUNK/I0/B0P1") getData("/ICHUNK/I0/B1P1") getData("/ICHUNK/I0/I0/I7/I3/Q0") getData("/ICHUNK/I0/I0/I7/I3/Q1") getData("/net55<7>") getData("/net54<63>") getData("/IDATA/WLAck<0>") getData("/IDATA/Out0<0>") getData("/IDATA/Out1<0>") getData("/IDATA/RpAck<0>") getData("/IDATA/R0q<0>") getData("/IDATA/R1q<0>") getData("/IDATA/Lack<0>") getData("/IDATA/R0<0>") getData("/IDATA/R1<0>") getData("/~R0_1<0>") getData("/~R1_1<0>") getData("/IDATA/intRack") getData("/IDATA/intWack") getData("/G01") getData("/IDATA/Wen") getData("/B0_1<0>") getData("/B1_1<0>") getData("/W1_1<0>") getData("/W0_1<0>") getData("/IDATA/B1q<0>") getData("/IDATA/B0q<0>") getData("/IDATA/B0p<0>") getData("/IDATA/B1p<0>") getData("/IDATA/I73/inAck") getData("/IDATA/wack<0>") getData("/IDATA/I73/~oE") getData("/IDATA/I73/oE") getData("/IDATA/I73/outValid") getData("/IDATA/I73/inValid") getData("/WData<7:0>") getData("/En") getData("/ValAddr") getData("/RWT<1>") getData("/RWT<0>") getData("/RAckT<1>") getData("/RAckT<0>") getData("/WAckT<1>") getData("/WAckT<0>") getData("/WDataT<7>") getData("/WDataT<6>") getData("/WDataT<5>") getData("/WDataT<4>") getData("/WDataT<3>") getData("/WDataT<2>") getData("/WDataT<1>") getData("/WDataT<0>") getData("/RDataT<3>") getData("/RDataT<2>") getData("/RDataT<1>") getData("/RDataT<0>") getData("/RDataT<7>") getData("/RDataT<6>") getData("/RDataT<5>") getData("/RDataT<4>") getData("/AT<3>") getData("/AT<2>") getData("/AT<1>") getData("/AT<0>") getData("/AT<15>") getData("/AT<14>") getData("/AT<13>") getData("/AT<12>") getData("/AT<11>") getData("/AT<10>") getData("/AT<9>") getData("/AT<8>") getData("/AT<7>") getData("/AT<6>") getData("/AT<5>") getData("/AT<4>") getData("/AckT") )
modelFile(
    '("/software/cadence/ncsu-FreePDK15/hspice_16nm_hp.include" "")
)
run()
selectResult( 'tran )
plot(getData("/AT<0>") getData("/AT<10>") getData("/AT<11>") getData("/AT<12>") getData("/AT<13>") getData("/AT<14>") getData("/AT<15>") getData("/AT<1>") getData("/AT<2>") getData("/AT<3>") getData("/AT<4>") getData("/AT<5>") getData("/AT<6>") getData("/AT<7>") getData("/AT<8>") getData("/AT<9>") getData("/AckT") getData("/B0_1<0>") getData("/B1_1<0>") getData("/En") getData("/G01") getData("/ICHUNK/I0/B0P1") getData("/ICHUNK/I0/B1P1") getData("/ICHUNK/I0/I0/I7/I3/Q0") getData("/ICHUNK/I0/I0/I7/I3/Q1") getData("/IDATA/B0p<0>") getData("/IDATA/B0q<0>") getData("/IDATA/B1p<0>") getData("/IDATA/B1q<0>") getData("/IDATA/I73/inAck") getData("/IDATA/I73/inValid") getData("/IDATA/I73/oE") getData("/IDATA/I73/outValid") getData("/IDATA/Lack<0>") getData("/IDATA/Out0<0>") getData("/IDATA/Out1<0>") getData("/IDATA/R0<0>") getData("/IDATA/R0q<0>") getData("/IDATA/R1<0>") getData("/IDATA/R1q<0>") getData("/IDATA/RpAck<0>") getData("/IDATA/WLAck<0>") getData("/IDATA/Wen") getData("/IDATA/intRack") getData("/IDATA/intWack") getData("/IDATA/wack<0>") getData("/RAckT<0>") getData("/RAckT<1>") getData("/RDataT<0>") getData("/RDataT<1>") getData("/RDataT<2>") getData("/RDataT<3>") getData("/RDataT<4>") getData("/RDataT<5>") getData("/RDataT<6>") getData("/RDataT<7>") getData("/RWT<0>") getData("/RWT<1>") getData("/ValAddr") getData("/WAckT<0>") getData("/W0_1<0>") getData("/W1_1<0>") getData("/WAckT<1>") getData("/WData<7:0>") getData("/WDataT<0>") getData("/WDataT<1>") getData("/WDataT<2>") getData("/WDataT<3>") getData("/WDataT<4>") getData("/WDataT<5>") getData("/WDataT<6>") getData("/WDataT<7>") getData("/~R0_1<0>") getData("/~R1_1<0>") getData("/IDATA/wack<3>") )
modelFile(
    '("/software/cadence/ncsu-FreePDK15/hspice_16nm_hp.include" "")
)
run()
selectResult( 'tran )
plot(getData("/AT<0>") getData("/AT<10>") getData("/AT<11>") getData("/AT<12>") getData("/AT<13>") getData("/AT<14>") getData("/AT<15>") getData("/AT<1>") getData("/AT<2>") getData("/AT<3>") getData("/AT<4>") getData("/AT<5>") getData("/AT<6>") getData("/AT<7>") getData("/AT<8>") getData("/AT<9>") getData("/AckT") getData("/B0_1<0>") getData("/B1_1<0>") getData("/En") getData("/G01") getData("/ICHUNK/I0/B0P1") getData("/ICHUNK/I0/B1P1") getData("/ICHUNK/I0/I0/I7/I3/Q0") getData("/ICHUNK/I0/I0/I7/I3/Q1") getData("/IDATA/B0p<0>") getData("/IDATA/B0q<0>") getData("/IDATA/B1p<0>") getData("/IDATA/B1q<0>") getData("/IDATA/I73/inAck") getData("/IDATA/I73/inValid") getData("/IDATA/I73/oE") getData("/IDATA/I73/outValid") getData("/IDATA/Lack<0>") getData("/IDATA/Out0<0>") getData("/IDATA/Out1<0>") getData("/IDATA/R0<0>") getData("/IDATA/R0q<0>") getData("/IDATA/R1<0>") getData("/IDATA/R1q<0>") getData("/IDATA/RpAck<0>") getData("/IDATA/WLAck<0>") getData("/IDATA/Wen") getData("/IDATA/intRack") getData("/IDATA/intWack") getData("/IDATA/wack<0>") getData("/RAckT<0>") getData("/RAckT<1>") getData("/RDataT<0>") getData("/RDataT<1>") getData("/RDataT<2>") getData("/RDataT<3>") getData("/RDataT<4>") getData("/RDataT<5>") getData("/RDataT<6>") getData("/RDataT<7>") getData("/RWT<0>") getData("/RWT<1>") getData("/ValAddr") getData("/WAckT<0>") getData("/W0_1<0>") getData("/W1_1<0>") getData("/WAckT<1>") getData("/WData<7:0>") getData("/WDataT<0>") getData("/WDataT<1>") getData("/WDataT<2>") getData("/WDataT<3>") getData("/WDataT<4>") getData("/WDataT<5>") getData("/WDataT<6>") getData("/WDataT<7>") getData("/~R0_1<0>") getData("/~R1_1<0>") )
modelFile(
    '("/software/cadence/ncsu-FreePDK15/hspice_16nm_hp.include" "")
)
run()
selectResult( 'tran )
plot(getData("/AT<0>") getData("/AT<10>") getData("/AT<11>") getData("/AT<12>") getData("/AT<13>") getData("/AT<14>") getData("/AT<15>") getData("/AT<1>") getData("/AT<2>") getData("/AT<3>") getData("/AT<4>") getData("/AT<5>") getData("/AT<6>") getData("/AT<7>") getData("/AT<8>") getData("/AT<9>") getData("/AckT") getData("/B0_1<0>") getData("/B1_1<0>") getData("/En") getData("/G01") getData("/ICHUNK/I0/B0P1") getData("/ICHUNK/I0/B1P1") getData("/ICHUNK/I0/I0/I7/I3/Q0") getData("/ICHUNK/I0/I0/I7/I3/Q1") getData("/IDATA/B0p<0>") getData("/IDATA/B0q<0>") getData("/IDATA/B1p<0>") getData("/IDATA/B1q<0>") getData("/IDATA/I73/inAck") getData("/IDATA/I73/inValid") getData("/IDATA/I73/oE") getData("/IDATA/I73/outValid") getData("/IDATA/Lack<0>") getData("/IDATA/Out0<0>") getData("/IDATA/Out1<0>") getData("/IDATA/R0<0>") getData("/IDATA/R0q<0>") getData("/IDATA/R1<0>") getData("/IDATA/R1q<0>") getData("/IDATA/RpAck<0>") getData("/IDATA/WLAck<0>") getData("/IDATA/Wen") getData("/IDATA/intRack") getData("/IDATA/intWack") getData("/IDATA/wack<0>") getData("/RAckT<0>") getData("/RAckT<1>") getData("/RDataT<0>") getData("/RDataT<1>") getData("/RDataT<2>") getData("/RDataT<3>") getData("/RDataT<4>") getData("/RDataT<5>") getData("/RDataT<6>") getData("/RDataT<7>") getData("/RWT<0>") getData("/RWT<1>") getData("/ValAddr") getData("/WAckT<0>") getData("/W0_1<0>") getData("/W1_1<0>") getData("/WAckT<1>") getData("/WData<7:0>") getData("/WDataT<0>") getData("/WDataT<1>") getData("/WDataT<2>") getData("/WDataT<3>") getData("/WDataT<4>") getData("/WDataT<5>") getData("/WDataT<6>") getData("/WDataT<7>") getData("/~R0_1<0>") getData("/~R1_1<0>") )
