simulator( 'spectreVerilog )
design(	 "/net/kafka/nfs/rstdenis/Cadence/simulation/6T_DataPath_Test/spectreVerilog/config/netlist/analog/netlist")
resultsDir( "/net/kafka/nfs/rstdenis/Cadence/simulation/6T_DataPath_Test/spectreVerilog/config" )
modelFile(
    '("/software/cadence/ncsu-FreePDK15/hspice_16nm_hp.include" "")
)
analysis('tran ?stop "6n"  ?errpreset "conservative"  )
desVar(	  "vdd" 0.500	)
envOption(
	'mspSetupNetlistSimPrecisionUnit  "ps"
	'mspSetupNetlistSimTimeUnit  "ps"
	'mspSetupNetlistSwitchRC  t
	'analysisOrder  list("tran")
)
option(	'temp  "30.0"
)
saveOption( ?simOutputFormat "psfxl" )
save( 'i "/V0/MINUS" "/V1/MINUS" )
converge( 'ic "/IDATA/R0q<3>" "0" )
converge( 'ic "/IDATA/R1q<3>" "0" )
converge( 'ic "/WDataT<0>" "0" )
converge( 'ic "/WDataT<1>" "0" )
converge( 'ic "/WDataT<2>" "0" )
converge( 'ic "/WDataT<3>" "0" )
converge( 'ic "/WDataT<4>" "0" )
converge( 'ic "/WDataT<5>" "0" )
converge( 'ic "/WDataT<6>" "0" )
converge( 'ic "/WDataT<7>" "0" )
converge( 'ic "/RDataT<0>" "0" )
converge( 'ic "/RDataT<1>" "0" )
converge( 'ic "/RDataT<2>" "0" )
converge( 'ic "/RDataT<3>" "0" )
converge( 'ic "/RDataT<4>" "0" )
converge( 'ic "/RDataT<5>" "0" )
converge( 'ic "/RDataT<6>" "0" )
converge( 'ic "/RDataT<7>" "0" )
converge( 'ic "/RWT<0>" "0" )
converge( 'ic "/RWT<1>" "0" )
converge( 'ic "/AT<0>" "0" )
converge( 'ic "/AT<1>" "0" )
converge( 'ic "/AT<2>" "0" )
converge( 'ic "/AT<3>" "0" )
converge( 'ic "/AT<4>" "0" )
converge( 'ic "/AT<5>" "0" )
converge( 'ic "/AT<6>" "0" )
converge( 'ic "/AT<7>" "0" )
converge( 'ic "/AT<8>" "0" )
converge( 'ic "/AT<9>" "0" )
converge( 'ic "/AT<10>" "0" )
converge( 'ic "/AT<11>" "0" )
converge( 'ic "/AT<12>" "0" )
converge( 'ic "/AT<13>" "0" )
converge( 'ic "/AT<14>" "0" )
converge( 'ic "/AT<15>" "0" )
converge( 'ic "/En" "0" )
converge( 'ic "/ValAddr" "0" )
converge( 'ic "/Aline<0>" "0" )
converge( 'ic "/Aline<1>" "0" )
converge( 'ic "/Aline<2>" "0" )
converge( 'ic "/Aline<3>" "0" )
converge( 'ic "/Aline<4>" "0" )
converge( 'ic "/Aline<5>" "0" )
converge( 'ic "/Aline<6>" "0" )
converge( 'ic "/Aline<7>" "0" )
converge( 'ic "/Aline<8>" "0" )
converge( 'ic "/Aline<9>" "0" )
converge( 'ic "/Aline<10>" "0" )
converge( 'ic "/Aline<11>" "0" )
converge( 'ic "/Aline<12>" "0" )
converge( 'ic "/Aline<13>" "0" )
converge( 'ic "/Aline<14>" "0" )
converge( 'ic "/Aline<15>" "0" )
converge( 'ic "/Aline<16>" "0" )
converge( 'ic "/Aline<17>" "0" )
converge( 'ic "/Aline<18>" "0" )
converge( 'ic "/Aline<19>" "0" )
converge( 'ic "/Aline<20>" "0" )
converge( 'ic "/Aline<21>" "0" )
converge( 'ic "/Aline<22>" "0" )
converge( 'ic "/Aline<23>" "0" )
converge( 'ic "/Aline<24>" "0" )
converge( 'ic "/Aline<25>" "0" )
converge( 'ic "/Aline<26>" "0" )
converge( 'ic "/Aline<27>" "0" )
converge( 'ic "/Aline<28>" "0" )
converge( 'ic "/Aline<29>" "0" )
converge( 'ic "/Aline<30>" "0" )
converge( 'ic "/Aline<31>" "0" )
converge( 'ic "/Aline<32>" "0" )
converge( 'ic "/Aline<33>" "0" )
converge( 'ic "/Aline<34>" "0" )
converge( 'ic "/Aline<35>" "0" )
converge( 'ic "/Aline<36>" "0" )
converge( 'ic "/Aline<37>" "0" )
converge( 'ic "/Aline<38>" "0" )
converge( 'ic "/Aline<39>" "0" )
converge( 'ic "/Aline<40>" "0" )
converge( 'ic "/Aline<41>" "0" )
converge( 'ic "/Aline<42>" "0" )
converge( 'ic "/Aline<43>" "0" )
converge( 'ic "/Aline<44>" "0" )
converge( 'ic "/Aline<45>" "0" )
converge( 'ic "/Aline<46>" "0" )
converge( 'ic "/Aline<47>" "0" )
converge( 'ic "/Aline<48>" "0" )
converge( 'ic "/Aline<49>" "0" )
converge( 'ic "/Aline<50>" "0" )
converge( 'ic "/Aline<51>" "0" )
converge( 'ic "/Aline<52>" "0" )
converge( 'ic "/Aline<53>" "0" )
converge( 'ic "/Aline<54>" "0" )
converge( 'ic "/Aline<55>" "0" )
converge( 'ic "/Aline<56>" "0" )
converge( 'ic "/Aline<57>" "0" )
converge( 'ic "/Aline<58>" "0" )
converge( 'ic "/Aline<59>" "0" )
converge( 'ic "/Aline<60>" "0" )
converge( 'ic "/Aline<61>" "0" )
converge( 'ic "/Aline<62>" "0" )
converge( 'ic "/Aline<63>" "0" )
converge( 'ic "/S<0>" "0" )
converge( 'ic "/S<1>" "0" )
converge( 'ic "/S<2>" "0" )
converge( 'ic "/S<3>" "0" )
converge( 'ic "/S<4>" "0" )
converge( 'ic "/S<5>" "0" )
converge( 'ic "/S<6>" "0" )
converge( 'ic "/S<7>" "0" )
converge( 'ic "/B1_1<0>" "0" )
converge( 'ic "/B1_1<1>" "0" )
converge( 'ic "/B1_1<2>" "0" )
converge( 'ic "/B1_1<3>" "0" )
converge( 'ic "/B0_1<0>" "0" )
converge( 'ic "/B0_1<1>" "0" )
converge( 'ic "/B0_1<2>" "0" )
converge( 'ic "/B0_1<3>" "0" )
converge( 'ic "/W1_1<0>" "0" )
converge( 'ic "/W1_1<1>" "0" )
converge( 'ic "/W1_1<2>" "0" )
converge( 'ic "/W1_1<3>" "0" )
converge( 'ic "/W0_1<0>" "0" )
converge( 'ic "/W0_1<1>" "0" )
converge( 'ic "/W0_1<2>" "0" )
converge( 'ic "/W0_1<3>" "0" )
converge( 'ic "/G01" "0" )
converge( 'ic "/~R1_1<0>" "vdd" )
converge( 'ic "/~R1_1<1>" "vdd" )
converge( 'ic "/~R1_1<2>" "vdd" )
converge( 'ic "/~R1_1<3>" "vdd" )
converge( 'ic "/~R0_1<0>" "vdd" )
converge( 'ic "/~R0_1<1>" "vdd" )
converge( 'ic "/~R0_1<2>" "vdd" )
converge( 'ic "/~R0_1<3>" "vdd" )
converge( 'ic "/WAckT<0>" "vdd" )
converge( 'ic "/WAckT<1>" "vdd" )
converge( 'ic "/RAckT<0>" "vdd" )
converge( 'ic "/RAckT<1>" "vdd" )
temp( 30.0 )
run()
selectResult( 'tran )
plot(getData("/AckT") getData("/B0_1<0>") getData("/B1_1<0>") getData("/En") getData("/ICHUNK/I0/B0P1") getData("/ICHUNK/I0/B1P1") getData("/ICHUNK/I0/I0/I7/I3/Q0") getData("/ICHUNK/I0/I0/I7/I3/Q1") getData("/IDATA/Wen") getData("/IDATA/wack<0>") getData("/G01") getData("/IDATA/Lack<0>") getData("/~R1_1<0>") getData("/~R0_1<0>") getData("/IDATA/R0<0>") getData("/IDATA/R1<0>") getData("/IDATA/R0q<0>") getData("/IDATA/R1q<0>") getData("/IDATA/RpAck<0>") getData("/IDATA/intRack") getData("/ICHUNK/SM0_0_bit0") getData("/RAckT<0>") getData("/RAckT<1>") getData("/RDataT<0>") getData("/RWT<0>") getData("/RWT<1>") getData("/ICHUNK/SM1_0_bit0") getData("/ValAddr") getData("/WAckT<0>") getData("/W0_1<0>") getData("/W1_1<0>") getData("/WAckT<1>") getData("/WData<7:0>") getData("/WDataT<0>") getData("/WAck<1:0>") getData("/RData<7:0>") getData("/RAck<1:0>") getData("/RW<1:0>") getData("/Ack") getData("/A<15:0>") getData("/S<0>") getData("/Aline<0>") getData("/V0/MINUS") getData("/V1/MINUS") getData("/vdd!") )
modelFile(
    '("/software/cadence/ncsu-FreePDK15/hspice_16nm_hp.include" "")
)
run()
selectResult( 'tran )
plot(getData("/AckT") getData("/B0_1<0>") getData("/B1_1<0>") getData("/En") getData("/ICHUNK/I0/B0P1") getData("/ICHUNK/I0/B1P1") getData("/ICHUNK/I0/I0/I7/I3/Q0") getData("/ICHUNK/I0/I0/I7/I3/Q1") getData("/IDATA/Wen") getData("/IDATA/wack<0>") getData("/G01") getData("/IDATA/Lack<0>") getData("/~R1_1<0>") getData("/~R0_1<0>") getData("/IDATA/R0<0>") getData("/IDATA/R1<0>") getData("/IDATA/R0q<0>") getData("/IDATA/R1q<0>") getData("/IDATA/RpAck<0>") getData("/IDATA/intRack") getData("/ICHUNK/SM0_0_bit0") getData("/RAckT<0>") getData("/RAckT<1>") getData("/RDataT<0>") getData("/RWT<0>") getData("/RWT<1>") getData("/ICHUNK/SM1_0_bit0") getData("/ValAddr") getData("/WAckT<0>") getData("/W0_1<0>") getData("/W1_1<0>") getData("/WAckT<1>") getData("/WData<7:0>") getData("/WDataT<0>") getData("/WAck<1:0>") getData("/RData<7:0>") getData("/RAck<1:0>") getData("/RW<1:0>") getData("/Ack") getData("/A<15:0>") getData("/S<0>") getData("/Aline<0>") getData("/V0/MINUS") getData("/V1/MINUS") getData("/vdd!") )
modelFile(
    '("/software/cadence/ncsu-FreePDK15/hspice_16nm_hp.include" "")
)
run()
selectResult( 'tran )
plot(getData("/IDATA/R0q<2>") getData("/RDataT<4>") getData("/IDATA/I67<1>/net19") getData("/IDATA/I67<1>/n0<0>") getData("/IDATA/I84/n<0>") getData("/IDATA/I84/b1<0>") getData("/IDATA/nB0<0>") getData("/IDATA/nB1<0>") getData("/AckT") getData("/B0_1<0>") getData("/B1_1<0>") getData("/En") getData("/ICHUNK/I0/B0P1") getData("/ICHUNK/I0/B1P1") getData("/ICHUNK/I0/I0/I7/I3/Q0") getData("/ICHUNK/I0/I0/I7/I3/Q1") getData("/IDATA/Wen") getData("/IDATA/wack<0>") getData("/G01") getData("/IDATA/Lack<0>") getData("/~R1_1<0>") getData("/~R0_1<0>") getData("/IDATA/R0<0>") getData("/IDATA/R1<0>") getData("/IDATA/R0q<0>") getData("/IDATA/R1q<0>") getData("/IDATA/RpAck<0>") getData("/IDATA/intRack") getData("/ICHUNK/SM0_0_bit0") getData("/RAckT<0>") getData("/RAckT<1>") getData("/RDataT<0>") getData("/RWT<0>") getData("/RWT<1>") getData("/ICHUNK/SM1_0_bit0") getData("/ValAddr") getData("/WAckT<0>") getData("/W0_1<0>") getData("/W1_1<0>") getData("/WAckT<1>") getData("/WData<7:0>") getData("/WDataT<0>") getData("/WAck<1:0>") getData("/RData<7:0>") getData("/RAck<1:0>") getData("/RW<1:0>") getData("/Ack") getData("/A<15:0>") getData("/S<0>") getData("/Aline<0>") getData("/V0/MINUS") getData("/V1/MINUS") getData("/vdd!") )
modelFile(
    '("/software/cadence/ncsu-FreePDK15/hspice_16nm_hp.include" "")
)
run()
selectResult( 'tran )
plot(getData("/AckT") getData("/B0_1<0>") getData("/B1_1<0>") getData("/En") getData("/ICHUNK/I0/B0P1") getData("/ICHUNK/I0/B1P1") getData("/ICHUNK/I0/I0/I7/I3/Q0") getData("/ICHUNK/I0/I0/I7/I3/Q1") getData("/IDATA/Wen") getData("/IDATA/wack<0>") getData("/G01") getData("/IDATA/Lack<0>") getData("/~R1_1<0>") getData("/~R0_1<0>") getData("/IDATA/R0<0>") getData("/IDATA/R1<0>") getData("/IDATA/R0q<0>") getData("/IDATA/R1q<0>") getData("/IDATA/RpAck<0>") getData("/IDATA/intRack") getData("/ICHUNK/SM0_0_bit0") getData("/RAckT<0>") getData("/RAckT<1>") getData("/RDataT<0>") getData("/RWT<0>") getData("/RWT<1>") getData("/ICHUNK/SM1_0_bit0") getData("/ValAddr") getData("/WAckT<0>") getData("/W0_1<0>") getData("/W1_1<0>") getData("/WAckT<1>") getData("/WData<7:0>") getData("/WDataT<0>") getData("/WAck<1:0>") getData("/RData<7:0>") getData("/RAck<1:0>") getData("/RW<1:0>") getData("/Ack") getData("/A<15:0>") getData("/S<0>") getData("/Aline<0>") getData("/V0/MINUS") getData("/V1/MINUS") getData("/vdd!") getData("/IDATA/nB1<0>") getData("/IDATA/nB0<0>") getData("/IDATA/I84/b1<0>") getData("/IDATA/I84/n<0>") getData("/IDATA/I67<1>/n0<0>") getData("/IDATA/I67<1>/net19") getData("/RDataT<4>") getData("/IDATA/R0q<2>") )
modelFile(
    '("/software/cadence/ncsu-FreePDK15/hspice_16nm_hp.include" "")
)
run()
selectResult( 'tran )
plot(getData("/IDATA/I67<1>/m<0>") getData("/IDATA/I67<1>/n0<0>") getData("/IDATA/I84/b1<0>") getData("/IDATA/I84/n<0>") getData("/AckT") getData("/B0_1<0>") getData("/B1_1<0>") getData("/En") getData("/ICHUNK/I0/B0P1") getData("/ICHUNK/I0/B1P1") getData("/ICHUNK/I0/I0/I7/I3/Q0") getData("/ICHUNK/I0/I0/I7/I3/Q1") getData("/IDATA/Wen") getData("/IDATA/wack<0>") getData("/G01") getData("/IDATA/Lack<0>") getData("/~R1_1<0>") getData("/~R0_1<0>") getData("/IDATA/R0<0>") getData("/IDATA/R1<0>") getData("/IDATA/R0q<0>") getData("/IDATA/R1q<0>") getData("/IDATA/RpAck<0>") getData("/IDATA/intRack") getData("/ICHUNK/SM0_0_bit0") getData("/RAckT<0>") getData("/RAckT<1>") getData("/RDataT<0>") getData("/RWT<0>") getData("/RWT<1>") getData("/ICHUNK/SM1_0_bit0") getData("/ValAddr") getData("/WAckT<0>") getData("/W0_1<0>") getData("/W1_1<0>") getData("/WAckT<1>") getData("/WData<7:0>") getData("/WDataT<0>") getData("/WAck<1:0>") getData("/RData<7:0>") getData("/RAck<1:0>") getData("/RW<1:0>") getData("/Ack") getData("/A<15:0>") getData("/S<0>") getData("/Aline<0>") getData("/V0/MINUS") getData("/V1/MINUS") getData("/vdd!") getData("/IDATA/nB1<0>") getData("/IDATA/nB0<0>") )
modelFile(
    '("/software/cadence/ncsu-FreePDK15/hspice_16nm_hp.include" "")
)
converge( 'ic "/IDATA/nB1<0>" "0" )
converge( 'ic "/IDATA/nB1<1>" "0" )
converge( 'ic "/IDATA/nB0<0>" "0" )
converge( 'ic "/IDATA/nB0<1>" "0" )
converge( 'ic "/IDATA/nB1<2>" "0" )
converge( 'ic "/IDATA/nB1<3>" "0" )
converge( 'ic "/IDATA/nB0<2>" "0" )
converge( 'ic "/IDATA/nB0<3>" "0" )
converge( 'ic "/IDATA/R1<0>" "0" )
converge( 'ic "/IDATA/R1<1>" "0" )
converge( 'ic "/IDATA/R1<2>" "0" )
converge( 'ic "/IDATA/R1<3>" "0" )
converge( 'ic "/IDATA/R0<0>" "0" )
converge( 'ic "/IDATA/R0<1>" "0" )
converge( 'ic "/IDATA/R0<2>" "0" )
converge( 'ic "/IDATA/R0<3>" "0" )
converge( 'ic "/IDATA/wack<0>" "vdd" )
converge( 'ic "/IDATA/wack<1>" "vdd" )
converge( 'ic "/IDATA/wack<2>" "vdd" )
converge( 'ic "/IDATA/wack<3>" "vdd" )
converge( 'ic "/IDATA/I84/n<0>" "0" )
converge( 'ic "/IDATA/I84/n<1>" "0" )
converge( 'ic "/IDATA/I84/n<2>" "0" )
converge( 'ic "/IDATA/I84/n<3>" "0" )
converge( 'ic "/IDATA/I84/b1<0>" "vdd" )
converge( 'ic "/IDATA/I84/b0<0>" "vdd" )
converge( 'ic "/IDATA/I84/b1<1>" "vdd" )
converge( 'ic "/IDATA/I84/b0<1>" "vdd" )
converge( 'ic "/IDATA/I84/nxa" "vdd" )
run()
selectResult( 'tran )
plot(getData("/AckT") getData("/B0_1<0>") getData("/B1_1<0>") getData("/En") getData("/ICHUNK/I0/B0P1") getData("/ICHUNK/I0/B1P1") getData("/ICHUNK/I0/I0/I7/I3/Q0") getData("/ICHUNK/I0/I0/I7/I3/Q1") getData("/IDATA/Wen") getData("/IDATA/wack<0>") getData("/G01") getData("/IDATA/Lack<0>") getData("/~R1_1<0>") getData("/~R0_1<0>") getData("/IDATA/R0<0>") getData("/IDATA/R1<0>") getData("/IDATA/R0q<0>") getData("/IDATA/R1q<0>") getData("/IDATA/RpAck<0>") getData("/IDATA/intRack") getData("/ICHUNK/SM0_0_bit0") getData("/RAckT<0>") getData("/RAckT<1>") getData("/RDataT<0>") getData("/RWT<0>") getData("/RWT<1>") getData("/ICHUNK/SM1_0_bit0") getData("/ValAddr") getData("/WAckT<0>") getData("/W0_1<0>") getData("/W1_1<0>") getData("/WAckT<1>") getData("/WData<7:0>") getData("/WDataT<0>") getData("/WAck<1:0>") getData("/RData<7:0>") getData("/RAck<1:0>") getData("/RW<1:0>") getData("/Ack") getData("/A<15:0>") getData("/S<0>") getData("/Aline<0>") getData("/V0/MINUS") getData("/V1/MINUS") getData("/vdd!") getData("/IDATA/nB1<0>") getData("/IDATA/nB0<0>") getData("/IDATA/I84/n<0>") getData("/IDATA/I84/b1<0>") getData("/IDATA/I67<1>/n0<0>") getData("/IDATA/I67<1>/m<0>") )
modelFile(
    '("/software/cadence/ncsu-FreePDK15/hspice_16nm_hp.include" "")
)
run()
selectResult( 'tran )
plot(getData("/AckT") getData("/B0_1<0>") getData("/B1_1<0>") getData("/En") getData("/ICHUNK/I0/B0P1") getData("/ICHUNK/I0/B1P1") getData("/ICHUNK/I0/I0/I7/I3/Q0") getData("/ICHUNK/I0/I0/I7/I3/Q1") getData("/IDATA/Wen") getData("/IDATA/wack<0>") getData("/G01") getData("/IDATA/Lack<0>") getData("/~R1_1<0>") getData("/~R0_1<0>") getData("/IDATA/R0<0>") getData("/IDATA/R1<0>") getData("/IDATA/R0q<0>") getData("/IDATA/R1q<0>") getData("/IDATA/RpAck<0>") getData("/IDATA/intRack") getData("/ICHUNK/SM0_0_bit0") getData("/RAckT<0>") getData("/RAckT<1>") getData("/RDataT<0>") getData("/RWT<0>") getData("/RWT<1>") getData("/ICHUNK/SM1_0_bit0") getData("/ValAddr") getData("/WAckT<0>") getData("/W0_1<0>") getData("/W1_1<0>") getData("/WAckT<1>") getData("/WData<7:0>") getData("/WDataT<0>") getData("/WAck<1:0>") getData("/RData<7:0>") getData("/RAck<1:0>") getData("/RW<1:0>") getData("/Ack") getData("/A<15:0>") getData("/S<0>") getData("/Aline<0>") getData("/V0/MINUS") getData("/V1/MINUS") getData("/vdd!") getData("/IDATA/nB1<0>") getData("/IDATA/nB0<0>") getData("/IDATA/I84/n<0>") getData("/IDATA/I84/b1<0>") getData("/IDATA/I67<1>/n0<0>") getData("/IDATA/I67<1>/m<0>") )
modelFile(
    '("/software/cadence/ncsu-FreePDK15/hspice_16nm_hp.include" "")
)
run()
selectResult( 'tran )
plot(getData("/AckT") getData("/B0_1<0>") getData("/B1_1<0>") getData("/En") getData("/ICHUNK/I0/B0P1") getData("/ICHUNK/I0/B1P1") getData("/ICHUNK/I0/I0/I7/I3/Q0") getData("/ICHUNK/I0/I0/I7/I3/Q1") getData("/IDATA/Wen") getData("/IDATA/wack<0>") getData("/G01") getData("/IDATA/Lack<0>") getData("/~R1_1<0>") getData("/~R0_1<0>") getData("/IDATA/R0<0>") getData("/IDATA/R1<0>") getData("/IDATA/R0q<0>") getData("/IDATA/R1q<0>") getData("/IDATA/RpAck<0>") getData("/IDATA/intRack") getData("/ICHUNK/SM0_0_bit0") getData("/RAckT<0>") getData("/RAckT<1>") getData("/RDataT<0>") getData("/RWT<0>") getData("/RWT<1>") getData("/ICHUNK/SM1_0_bit0") getData("/ValAddr") getData("/WAckT<0>") getData("/W0_1<0>") getData("/W1_1<0>") getData("/WAckT<1>") getData("/WData<7:0>") getData("/WDataT<0>") getData("/WAck<1:0>") getData("/RData<7:0>") getData("/RAck<1:0>") getData("/RW<1:0>") getData("/Ack") getData("/A<15:0>") getData("/S<0>") getData("/Aline<0>") getData("/V0/MINUS") getData("/V1/MINUS") getData("/vdd!") getData("/IDATA/nB1<0>") getData("/IDATA/nB0<0>") getData("/IDATA/I84/n<0>") getData("/IDATA/I84/b1<0>") getData("/IDATA/I67<1>/n0<0>") getData("/IDATA/I67<1>/m<0>") )
modelFile(
    '("/software/cadence/ncsu-FreePDK15/hspice_16nm_hp.include" "")
)
run()
selectResult( 'tran )
plot(getData("/AckT") getData("/B0_1<0>") getData("/B1_1<0>") getData("/En") getData("/ICHUNK/I0/B0P1") getData("/ICHUNK/I0/B1P1") getData("/ICHUNK/I0/I0/I7/I3/Q0") getData("/ICHUNK/I0/I0/I7/I3/Q1") getData("/IDATA/Wen") getData("/IDATA/wack<0>") getData("/G01") getData("/IDATA/Lack<0>") getData("/~R1_1<0>") getData("/~R0_1<0>") getData("/IDATA/R0<0>") getData("/IDATA/R1<0>") getData("/IDATA/R0q<0>") getData("/IDATA/R1q<0>") getData("/IDATA/RpAck<0>") getData("/IDATA/intRack") getData("/ICHUNK/SM0_0_bit0") getData("/RAckT<0>") getData("/RAckT<1>") getData("/RDataT<0>") getData("/RWT<0>") getData("/RWT<1>") getData("/ICHUNK/SM1_0_bit0") getData("/ValAddr") getData("/WAckT<0>") getData("/W0_1<0>") getData("/W1_1<0>") getData("/WAckT<1>") getData("/WData<7:0>") getData("/WDataT<0>") getData("/WAck<1:0>") getData("/RData<7:0>") getData("/RAck<1:0>") getData("/RW<1:0>") getData("/Ack") getData("/A<15:0>") getData("/S<0>") getData("/Aline<0>") getData("/V0/MINUS") getData("/V1/MINUS") getData("/vdd!") getData("/IDATA/nB1<0>") getData("/IDATA/nB0<0>") getData("/IDATA/I84/n<0>") getData("/IDATA/I84/b1<0>") getData("/IDATA/I67<1>/n0<0>") getData("/IDATA/I67<1>/m<0>") )
modelFile(
    '("/software/cadence/ncsu-FreePDK15/hspice_16nm_hp.include" "")
)
delete( 'converge 'ic "/RWT<0>" )
delete( 'converge 'ic "/En" )
run()
selectResult( 'tran )
plot(getData("/B0_1<0>") getData("/B1_1<0>") getData("/ICHUNK/I0/B0P1") getData("/ICHUNK/I0/B1P1") getData("/ICHUNK/I0/I0/I7/I3/Q0") getData("/ICHUNK/I0/I0/I7/I3/Q1") getData("/IDATA/Wen") getData("/IDATA/wack<0>") getData("/G01") getData("/IDATA/Lack<0>") getData("/~R1_1<0>") getData("/~R0_1<0>") getData("/IDATA/R0<0>") getData("/IDATA/R1<0>") getData("/IDATA/R0q<0>") getData("/IDATA/R1q<0>") getData("/IDATA/RpAck<0>") getData("/IDATA/intRack") getData("/ICHUNK/SM0_0_bit0") getData("/RAckT<0>") getData("/RAckT<1>") getData("/RDataT<0>") getData("/ICHUNK/SM1_0_bit0") getData("/ValAddr") getData("/WAckT<0>") getData("/W0_1<0>") getData("/W1_1<0>") getData("/WAckT<1>") getData("/WData<7:0>") getData("/WDataT<0>") getData("/WAck<1:0>") getData("/RData<7:0>") getData("/RAck<1:0>") getData("/S<0>") getData("/Aline<0>") getData("/V0/MINUS") getData("/V1/MINUS") getData("/vdd!") getData("/IDATA/nB1<0>") getData("/IDATA/nB0<0>") getData("/IDATA/I84/n<0>") getData("/IDATA/I84/b1<0>") getData("/IDATA/I67<1>/n0<0>") getData("/IDATA/I67<1>/m<0>") )
modelFile(
    '("/software/cadence/ncsu-FreePDK15/hspice_16nm_hp.include" "")
)
delete( 'converge 'ic "/RWT<1>" )
run()
selectResult( 'tran )
plot(getData("/B0_1<0>") getData("/B1_1<0>") getData("/ICHUNK/I0/B0P1") getData("/ICHUNK/I0/B1P1") getData("/ICHUNK/I0/I0/I7/I3/Q0") getData("/ICHUNK/I0/I0/I7/I3/Q1") getData("/IDATA/Wen") getData("/IDATA/wack<0>") getData("/G01") getData("/IDATA/Lack<0>") getData("/~R1_1<0>") getData("/~R0_1<0>") getData("/IDATA/R0<0>") getData("/IDATA/R1<0>") getData("/IDATA/R0q<0>") getData("/IDATA/R1q<0>") getData("/IDATA/RpAck<0>") getData("/IDATA/intRack") getData("/ICHUNK/SM0_0_bit0") getData("/RAckT<0>") getData("/RAckT<1>") getData("/RDataT<0>") getData("/ICHUNK/SM1_0_bit0") getData("/ValAddr") getData("/WAckT<0>") getData("/W0_1<0>") getData("/W1_1<0>") getData("/WAckT<1>") getData("/WData<7:0>") getData("/WDataT<0>") getData("/WAck<1:0>") getData("/RData<7:0>") getData("/RAck<1:0>") getData("/S<0>") getData("/Aline<0>") getData("/V0/MINUS") getData("/V1/MINUS") getData("/vdd!") getData("/IDATA/nB1<0>") getData("/IDATA/nB0<0>") getData("/IDATA/I84/n<0>") getData("/IDATA/I84/b1<0>") getData("/IDATA/I67<1>/n0<0>") getData("/IDATA/I67<1>/m<0>") )
modelFile(
    '("/software/cadence/ncsu-FreePDK15/hspice_16nm_hp.include" "")
)
run()
selectResult( 'tran )
plot(getData("/B0_1<0>") getData("/B1_1<0>") getData("/ICHUNK/I0/B0P1") getData("/ICHUNK/I0/B1P1") getData("/ICHUNK/I0/I0/I7/I3/Q0") getData("/ICHUNK/I0/I0/I7/I3/Q1") getData("/IDATA/Wen") getData("/IDATA/wack<0>") getData("/G01") getData("/IDATA/Lack<0>") getData("/~R1_1<0>") getData("/~R0_1<0>") getData("/IDATA/R0<0>") getData("/IDATA/R1<0>") getData("/IDATA/R0q<0>") getData("/IDATA/R1q<0>") getData("/IDATA/RpAck<0>") getData("/IDATA/intRack") getData("/ICHUNK/SM0_0_bit0") getData("/RAckT<0>") getData("/RAckT<1>") getData("/RDataT<0>") getData("/ICHUNK/SM1_0_bit0") getData("/ValAddr") getData("/WAckT<0>") getData("/W0_1<0>") getData("/W1_1<0>") getData("/WAckT<1>") getData("/WData<7:0>") getData("/WDataT<0>") getData("/WAck<1:0>") getData("/RData<7:0>") getData("/RAck<1:0>") getData("/S<0>") getData("/Aline<0>") getData("/V0/MINUS") getData("/V1/MINUS") getData("/vdd!") getData("/IDATA/nB1<0>") getData("/IDATA/nB0<0>") getData("/IDATA/I84/n<0>") getData("/IDATA/I84/b1<0>") getData("/IDATA/I67<1>/n0<0>") getData("/IDATA/I67<1>/m<0>") )
modelFile(
    '("/software/cadence/ncsu-FreePDK15/hspice_16nm_hp.include" "")
)
save( 'i "/V1/PLUS" "/V0/PLUS" )
converge( 'ic "/DataAck" "0" )
delete( 'converge 'ic "/IDATA/R0q<3>" )
delete( 'converge 'ic "/IDATA/R1q<3>" )
delete( 'converge 'ic "/ValAddr" )
delete( 'converge 'ic "/~R1_1<0>" )
delete( 'converge 'ic "/~R1_1<1>" )
delete( 'converge 'ic "/~R1_1<2>" )
delete( 'converge 'ic "/~R1_1<3>" )
delete( 'converge 'ic "/~R0_1<0>" )
delete( 'converge 'ic "/~R0_1<1>" )
delete( 'converge 'ic "/~R0_1<2>" )
delete( 'converge 'ic "/~R0_1<3>" )
delete( 'converge 'ic "/WAckT<0>" )
delete( 'converge 'ic "/WAckT<1>" )
delete( 'converge 'ic "/RAckT<0>" )
delete( 'converge 'ic "/RAckT<1>" )
delete( 'converge 'ic "/IDATA/nB1<0>" )
delete( 'converge 'ic "/IDATA/nB1<1>" )
delete( 'converge 'ic "/IDATA/nB0<0>" )
delete( 'converge 'ic "/IDATA/nB0<1>" )
delete( 'converge 'ic "/IDATA/nB1<2>" )
delete( 'converge 'ic "/IDATA/nB1<3>" )
delete( 'converge 'ic "/IDATA/nB0<2>" )
delete( 'converge 'ic "/IDATA/nB0<3>" )
delete( 'converge 'ic "/IDATA/R1<0>" )
delete( 'converge 'ic "/IDATA/R1<1>" )
delete( 'converge 'ic "/IDATA/R1<2>" )
delete( 'converge 'ic "/IDATA/R1<3>" )
delete( 'converge 'ic "/IDATA/R0<0>" )
delete( 'converge 'ic "/IDATA/R0<1>" )
delete( 'converge 'ic "/IDATA/R0<2>" )
delete( 'converge 'ic "/IDATA/R0<3>" )
delete( 'converge 'ic "/IDATA/wack<0>" )
delete( 'converge 'ic "/IDATA/wack<1>" )
delete( 'converge 'ic "/IDATA/wack<2>" )
delete( 'converge 'ic "/IDATA/wack<3>" )
delete( 'converge 'ic "/IDATA/I84/n<0>" )
delete( 'converge 'ic "/IDATA/I84/n<1>" )
delete( 'converge 'ic "/IDATA/I84/n<2>" )
delete( 'converge 'ic "/IDATA/I84/n<3>" )
delete( 'converge 'ic "/IDATA/I84/b1<0>" )
delete( 'converge 'ic "/IDATA/I84/b0<0>" )
delete( 'converge 'ic "/IDATA/I84/b1<1>" )
delete( 'converge 'ic "/IDATA/I84/b0<1>" )
delete( 'converge 'ic "/IDATA/I84/nxa" )
run()
selectResult( 'tran )
plot(getData("/WData<7:0>") getData("/RData<7:0>") getData("/WAck<1:0>") getData("/RAck<1:0>") getData("/W_Address<15:0>") getData("/WA_Ack<3:0>") getData("/WRW<1:0>") getData("/WriteAck") getData("/R_Address<15:0>") getData("/RA_Ack<3:0>") getData("/RRW<1:0>") getData("/ReadAck") getData("/S<0>") getData("/Aline<0>") getData("/B1_1<0>") getData("/B0_1<0>") getData("/W1_1<0>") getData("/W0_1<0>") getData("/G01") getData("/~R1_1<0>") getData("/~R0_1<0>") getData("/IDATA/nB1<0>") getData("/IDATA/nB0<0>") getData("/IDATA/wack<0>") getData("/IDATA/Wen") getData("/WDataT<0>") getData("/IDATA/I84/n<0>") getData("/IDATA/I84/b0<0>") getData("/IDATA/I84/b1<0>") getData("/IDATA/R0q<2>") getData("/IDATA/R0q<3>") getData("/IDATA/I67<1>/n0<0>") getData("/IDATA/I67<1>/n1<0>") getData("/IDATA/I67<1>/m<0>") getData("/RDataT<4>") getData("/RAckT<1>") getData("/IDATA/RpAck<2>") getData("/IDATA/R1<0>") getData("/IDATA/R0<0>") getData("/IDATA/R1q<0>") getData("/IDATA/R0q<0>") getData("/RDataT<3>") getData("/RDataT<2>") getData("/RDataT<1>") getData("/RDataT<0>") getData("/V0/MINUS") getData("/V1/MINUS") getData("/V1/PLUS") getData("/V0/PLUS") getData("/vdd!") getData("/vcc!") )
modelFile(
    '("/software/cadence/ncsu-FreePDK15/hspice_16nm_hp.include" "")
)
converge( 'ic "/ICHUNK/I0/I0/I7/I3/Q0" "0" )
converge( 'ic "/ICHUNK/I0/I0/I7/I3/Q1" "vdd" )
run()
selectResult( 'tran )
plot(getData("/ICHUNK/I0/B0P1") getData("/ICHUNK/I0/B1P1") getData("/ICHUNK/I0/I0/I7/I3/Q1") getData("/ICHUNK/I0/I0/I7/I3/Q0") getData("/WData<7:0>") getData("/RData<7:0>") getData("/WAck<1:0>") getData("/RAck<1:0>") getData("/W_Address<15:0>") getData("/WA_Ack<3:0>") getData("/WRW<1:0>") getData("/WriteAck") getData("/R_Address<15:0>") getData("/RA_Ack<3:0>") getData("/RRW<1:0>") getData("/ReadAck") getData("/S<0>") getData("/Aline<0>") getData("/B1_1<0>") getData("/B0_1<0>") getData("/W1_1<0>") getData("/W0_1<0>") getData("/G01") getData("/~R1_1<0>") getData("/~R0_1<0>") getData("/IDATA/nB1<0>") getData("/IDATA/nB0<0>") getData("/IDATA/wack<0>") getData("/IDATA/Wen") getData("/WDataT<0>") getData("/IDATA/I84/n<0>") getData("/IDATA/I84/b0<0>") getData("/IDATA/I84/b1<0>") getData("/IDATA/R0q<2>") getData("/IDATA/R0q<3>") getData("/IDATA/I67<1>/n0<0>") getData("/IDATA/I67<1>/n1<0>") getData("/IDATA/I67<1>/m<0>") getData("/RDataT<4>") getData("/RAckT<1>") getData("/IDATA/RpAck<2>") getData("/IDATA/R1<0>") getData("/IDATA/R0<0>") getData("/IDATA/R1q<0>") getData("/IDATA/R0q<0>") getData("/RDataT<3>") getData("/RDataT<2>") getData("/RDataT<1>") getData("/RDataT<0>") getData("/V0/MINUS") getData("/V1/MINUS") getData("/V1/PLUS") getData("/V0/PLUS") getData("/vdd!") getData("/vcc!") )
modelFile(
    '("/software/cadence/ncsu-FreePDK15/hspice_16nm_hp.include" "")
)
delete( 'converge 'ic "/WDataT<0>" )
delete( 'converge 'ic "/WDataT<1>" )
delete( 'converge 'ic "/WDataT<2>" )
delete( 'converge 'ic "/WDataT<3>" )
delete( 'converge 'ic "/WDataT<4>" )
delete( 'converge 'ic "/WDataT<5>" )
delete( 'converge 'ic "/WDataT<6>" )
delete( 'converge 'ic "/WDataT<7>" )
delete( 'converge 'ic "/RDataT<0>" )
delete( 'converge 'ic "/RDataT<1>" )
delete( 'converge 'ic "/RDataT<2>" )
delete( 'converge 'ic "/RDataT<3>" )
delete( 'converge 'ic "/RDataT<4>" )
delete( 'converge 'ic "/RDataT<5>" )
delete( 'converge 'ic "/RDataT<6>" )
delete( 'converge 'ic "/RDataT<7>" )
delete( 'converge 'ic "/DataAck" )
delete( 'converge 'ic "/G01" )
delete( 'converge 'ic "/B1_1<0>" )
delete( 'converge 'ic "/B1_1<1>" )
delete( 'converge 'ic "/B1_1<2>" )
delete( 'converge 'ic "/B1_1<3>" )
delete( 'converge 'ic "/W0_1<0>" )
delete( 'converge 'ic "/W0_1<1>" )
delete( 'converge 'ic "/W0_1<2>" )
delete( 'converge 'ic "/W0_1<3>" )
delete( 'converge 'ic "/W1_1<0>" )
delete( 'converge 'ic "/W1_1<1>" )
delete( 'converge 'ic "/W1_1<2>" )
delete( 'converge 'ic "/W1_1<3>" )
delete( 'converge 'ic "/B0_1<0>" )
delete( 'converge 'ic "/B0_1<1>" )
delete( 'converge 'ic "/B0_1<2>" )
delete( 'converge 'ic "/B0_1<3>" )
delete( 'converge 'ic "/Aline<0>" )
delete( 'converge 'ic "/Aline<1>" )
delete( 'converge 'ic "/Aline<2>" )
delete( 'converge 'ic "/Aline<3>" )
delete( 'converge 'ic "/Aline<4>" )
delete( 'converge 'ic "/Aline<5>" )
delete( 'converge 'ic "/Aline<6>" )
delete( 'converge 'ic "/Aline<7>" )
delete( 'converge 'ic "/Aline<8>" )
delete( 'converge 'ic "/Aline<9>" )
delete( 'converge 'ic "/Aline<10>" )
delete( 'converge 'ic "/Aline<11>" )
delete( 'converge 'ic "/Aline<12>" )
delete( 'converge 'ic "/Aline<13>" )
delete( 'converge 'ic "/Aline<14>" )
delete( 'converge 'ic "/Aline<15>" )
delete( 'converge 'ic "/Aline<16>" )
delete( 'converge 'ic "/Aline<17>" )
delete( 'converge 'ic "/Aline<18>" )
delete( 'converge 'ic "/Aline<19>" )
delete( 'converge 'ic "/Aline<20>" )
delete( 'converge 'ic "/Aline<21>" )
delete( 'converge 'ic "/Aline<22>" )
delete( 'converge 'ic "/Aline<23>" )
delete( 'converge 'ic "/Aline<24>" )
delete( 'converge 'ic "/Aline<25>" )
delete( 'converge 'ic "/Aline<26>" )
delete( 'converge 'ic "/Aline<27>" )
delete( 'converge 'ic "/Aline<28>" )
delete( 'converge 'ic "/Aline<29>" )
delete( 'converge 'ic "/Aline<30>" )
delete( 'converge 'ic "/Aline<31>" )
delete( 'converge 'ic "/Aline<32>" )
delete( 'converge 'ic "/Aline<33>" )
delete( 'converge 'ic "/Aline<34>" )
delete( 'converge 'ic "/Aline<35>" )
delete( 'converge 'ic "/Aline<36>" )
delete( 'converge 'ic "/Aline<37>" )
delete( 'converge 'ic "/Aline<38>" )
delete( 'converge 'ic "/Aline<39>" )
delete( 'converge 'ic "/Aline<40>" )
delete( 'converge 'ic "/Aline<41>" )
delete( 'converge 'ic "/Aline<42>" )
delete( 'converge 'ic "/Aline<43>" )
delete( 'converge 'ic "/Aline<44>" )
delete( 'converge 'ic "/Aline<45>" )
delete( 'converge 'ic "/Aline<46>" )
delete( 'converge 'ic "/Aline<47>" )
delete( 'converge 'ic "/Aline<48>" )
delete( 'converge 'ic "/Aline<49>" )
delete( 'converge 'ic "/Aline<50>" )
delete( 'converge 'ic "/Aline<51>" )
delete( 'converge 'ic "/Aline<52>" )
delete( 'converge 'ic "/Aline<53>" )
delete( 'converge 'ic "/Aline<54>" )
delete( 'converge 'ic "/Aline<55>" )
delete( 'converge 'ic "/Aline<56>" )
delete( 'converge 'ic "/Aline<57>" )
delete( 'converge 'ic "/Aline<58>" )
delete( 'converge 'ic "/Aline<59>" )
delete( 'converge 'ic "/Aline<60>" )
delete( 'converge 'ic "/Aline<61>" )
delete( 'converge 'ic "/Aline<62>" )
delete( 'converge 'ic "/Aline<63>" )
delete( 'converge 'ic "/S<0>" )
delete( 'converge 'ic "/S<1>" )
delete( 'converge 'ic "/S<2>" )
delete( 'converge 'ic "/S<3>" )
delete( 'converge 'ic "/S<4>" )
delete( 'converge 'ic "/S<5>" )
delete( 'converge 'ic "/S<6>" )
delete( 'converge 'ic "/S<7>" )
delete( 'converge 'ic "/AT<12>" )
delete( 'converge 'ic "/AT<13>" )
delete( 'converge 'ic "/AT<14>" )
delete( 'converge 'ic "/AT<15>" )
delete( 'converge 'ic "/AT<8>" )
delete( 'converge 'ic "/AT<9>" )
delete( 'converge 'ic "/AT<10>" )
delete( 'converge 'ic "/AT<11>" )
delete( 'converge 'ic "/AT<4>" )
delete( 'converge 'ic "/AT<5>" )
delete( 'converge 'ic "/AT<6>" )
delete( 'converge 'ic "/AT<7>" )
delete( 'converge 'ic "/AT<0>" )
delete( 'converge 'ic "/AT<1>" )
delete( 'converge 'ic "/AT<2>" )
delete( 'converge 'ic "/AT<3>" )
run()
selectResult( 'tran )
plot(getData("/ICHUNK/I0/B0P1") getData("/ICHUNK/I0/B1P1") getData("/ICHUNK/I0/I0/I7/I3/Q1") getData("/ICHUNK/I0/I0/I7/I3/Q0") getData("/WData<7:0>") getData("/RData<7:0>") getData("/WAck<1:0>") getData("/RAck<1:0>") getData("/W_Address<15:0>") getData("/WA_Ack<3:0>") getData("/WRW<1:0>") getData("/WriteAck") getData("/R_Address<15:0>") getData("/RA_Ack<3:0>") getData("/RRW<1:0>") getData("/ReadAck") getData("/S<0>") getData("/Aline<0>") getData("/B1_1<0>") getData("/B0_1<0>") getData("/W1_1<0>") getData("/W0_1<0>") getData("/G01") getData("/~R1_1<0>") getData("/~R0_1<0>") getData("/IDATA/nB1<0>") getData("/IDATA/nB0<0>") getData("/IDATA/wack<0>") getData("/IDATA/Wen") getData("/WDataT<0>") getData("/IDATA/I84/n<0>") getData("/IDATA/I84/b0<0>") getData("/IDATA/I84/b1<0>") getData("/IDATA/R0q<2>") getData("/IDATA/R0q<3>") getData("/IDATA/I67<1>/n0<0>") getData("/IDATA/I67<1>/n1<0>") getData("/IDATA/I67<1>/m<0>") getData("/RDataT<4>") getData("/RAckT<1>") getData("/IDATA/RpAck<2>") getData("/IDATA/R1<0>") getData("/IDATA/R0<0>") getData("/IDATA/R1q<0>") getData("/IDATA/R0q<0>") getData("/RDataT<3>") getData("/RDataT<2>") getData("/RDataT<1>") getData("/RDataT<0>") getData("/V0/MINUS") getData("/V1/MINUS") getData("/V1/PLUS") getData("/V0/PLUS") getData("/vdd!") getData("/vcc!") )
modelFile(
    '("/software/cadence/ncsu-FreePDK15/hspice_16nm_hp.include" "")
)
converge( 'ic "/WDataT<0>" "0" )
converge( 'ic "/WDataT<1>" "0" )
converge( 'ic "/WDataT<2>" "0" )
converge( 'ic "/WDataT<3>" "0" )
converge( 'ic "/WDataT<4>" "0" )
converge( 'ic "/WDataT<5>" "0" )
converge( 'ic "/WDataT<6>" "0" )
converge( 'ic "/WDataT<7>" "0" )
converge( 'ic "/RDataT<0>" "0" )
converge( 'ic "/RDataT<1>" "0" )
converge( 'ic "/RDataT<2>" "0" )
converge( 'ic "/RDataT<3>" "0" )
converge( 'ic "/RDataT<4>" "0" )
converge( 'ic "/RDataT<5>" "0" )
converge( 'ic "/RDataT<6>" "0" )
converge( 'ic "/RDataT<7>" "0" )
converge( 'ic "/G01" "0" )
converge( 'ic "/B1_1<0>" "0" )
converge( 'ic "/B1_1<1>" "0" )
converge( 'ic "/B1_1<2>" "0" )
converge( 'ic "/B1_1<3>" "0" )
converge( 'ic "/W0_1<0>" "0" )
converge( 'ic "/W0_1<1>" "0" )
converge( 'ic "/W0_1<2>" "0" )
converge( 'ic "/W0_1<3>" "0" )
converge( 'ic "/W1_1<0>" "0" )
converge( 'ic "/W1_1<1>" "0" )
converge( 'ic "/W1_1<2>" "0" )
converge( 'ic "/W1_1<3>" "0" )
converge( 'ic "/B0_1<0>" "0" )
converge( 'ic "/B0_1<1>" "0" )
converge( 'ic "/B0_1<2>" "0" )
converge( 'ic "/B0_1<3>" "0" )
converge( 'ic "/DataAck" "0" )
converge( 'ic "/Aline<0>" "0" )
converge( 'ic "/Aline<1>" "0" )
converge( 'ic "/Aline<2>" "0" )
converge( 'ic "/Aline<3>" "0" )
converge( 'ic "/Aline<4>" "0" )
converge( 'ic "/Aline<5>" "0" )
converge( 'ic "/Aline<6>" "0" )
converge( 'ic "/Aline<7>" "0" )
converge( 'ic "/Aline<8>" "0" )
converge( 'ic "/Aline<9>" "0" )
converge( 'ic "/Aline<10>" "0" )
converge( 'ic "/Aline<11>" "0" )
converge( 'ic "/Aline<12>" "0" )
converge( 'ic "/Aline<13>" "0" )
converge( 'ic "/Aline<14>" "0" )
converge( 'ic "/Aline<15>" "0" )
converge( 'ic "/Aline<16>" "0" )
converge( 'ic "/Aline<17>" "0" )
converge( 'ic "/Aline<18>" "0" )
converge( 'ic "/Aline<19>" "0" )
converge( 'ic "/Aline<20>" "0" )
converge( 'ic "/Aline<21>" "0" )
converge( 'ic "/Aline<22>" "0" )
converge( 'ic "/Aline<23>" "0" )
converge( 'ic "/Aline<24>" "0" )
converge( 'ic "/Aline<25>" "0" )
converge( 'ic "/Aline<26>" "0" )
converge( 'ic "/Aline<27>" "0" )
converge( 'ic "/Aline<28>" "0" )
converge( 'ic "/Aline<29>" "0" )
converge( 'ic "/Aline<30>" "0" )
converge( 'ic "/Aline<31>" "0" )
converge( 'ic "/Aline<32>" "0" )
converge( 'ic "/Aline<33>" "0" )
converge( 'ic "/Aline<34>" "0" )
converge( 'ic "/Aline<35>" "0" )
converge( 'ic "/Aline<36>" "0" )
converge( 'ic "/Aline<37>" "0" )
converge( 'ic "/Aline<38>" "0" )
converge( 'ic "/Aline<39>" "0" )
converge( 'ic "/Aline<40>" "0" )
converge( 'ic "/Aline<41>" "0" )
converge( 'ic "/Aline<42>" "0" )
converge( 'ic "/Aline<43>" "0" )
converge( 'ic "/Aline<44>" "0" )
converge( 'ic "/Aline<45>" "0" )
converge( 'ic "/Aline<46>" "0" )
converge( 'ic "/Aline<47>" "0" )
converge( 'ic "/Aline<48>" "0" )
converge( 'ic "/Aline<49>" "0" )
converge( 'ic "/Aline<50>" "0" )
converge( 'ic "/Aline<51>" "0" )
converge( 'ic "/Aline<52>" "0" )
converge( 'ic "/Aline<53>" "0" )
converge( 'ic "/Aline<54>" "0" )
converge( 'ic "/Aline<55>" "0" )
converge( 'ic "/Aline<56>" "0" )
converge( 'ic "/Aline<57>" "0" )
converge( 'ic "/Aline<58>" "0" )
converge( 'ic "/Aline<59>" "0" )
converge( 'ic "/Aline<60>" "0" )
converge( 'ic "/Aline<61>" "0" )
converge( 'ic "/Aline<62>" "0" )
converge( 'ic "/Aline<63>" "0" )
converge( 'ic "/S<0>" "0" )
converge( 'ic "/S<1>" "0" )
converge( 'ic "/S<2>" "0" )
converge( 'ic "/S<3>" "0" )
converge( 'ic "/S<4>" "0" )
converge( 'ic "/S<5>" "0" )
converge( 'ic "/S<6>" "0" )
converge( 'ic "/S<7>" "0" )
converge( 'ic "/net026" "0" )
run()
selectResult( 'tran )
plot(getData("/ICHUNK/I0/B0P1") getData("/ICHUNK/I0/B1P1") getData("/ICHUNK/I0/I0/I7/I3/Q1") getData("/ICHUNK/I0/I0/I7/I3/Q0") getData("/WData<7:0>") getData("/RData<7:0>") getData("/WAck<1:0>") getData("/RAck<1:0>") getData("/W_Address<15:0>") getData("/WA_Ack<3:0>") getData("/WRW<1:0>") getData("/WriteAck") getData("/R_Address<15:0>") getData("/RA_Ack<3:0>") getData("/RRW<1:0>") getData("/ReadAck") getData("/S<0>") getData("/Aline<0>") getData("/B1_1<0>") getData("/B0_1<0>") getData("/W1_1<0>") getData("/W0_1<0>") getData("/G01") getData("/~R1_1<0>") getData("/~R0_1<0>") getData("/IDATA/nB1<0>") getData("/IDATA/nB0<0>") getData("/IDATA/wack<0>") getData("/IDATA/Wen") getData("/WDataT<0>") getData("/IDATA/I84/n<0>") getData("/IDATA/I84/b0<0>") getData("/IDATA/I84/b1<0>") getData("/IDATA/R0q<2>") getData("/IDATA/R0q<3>") getData("/IDATA/I67<1>/n0<0>") getData("/IDATA/I67<1>/n1<0>") getData("/IDATA/I67<1>/m<0>") getData("/RDataT<4>") getData("/RAckT<1>") getData("/IDATA/RpAck<2>") getData("/IDATA/R1<0>") getData("/IDATA/R0<0>") getData("/IDATA/R1q<0>") getData("/IDATA/R0q<0>") getData("/RDataT<3>") getData("/RDataT<2>") getData("/RDataT<1>") getData("/RDataT<0>") getData("/V0/MINUS") getData("/V1/MINUS") getData("/V1/PLUS") getData("/V0/PLUS") getData("/vdd!") getData("/vcc!") )
