simulator( 'spectre )
design(	 "/net/kafka/nfs/rstdenis/Cadence/simulation/LC_MIT/spectre/schematic/netlist/netlist")
resultsDir( "/net/kafka/nfs/rstdenis/Cadence/simulation/LC_MIT/spectre/schematic" )
analysis('tran ?stop "10n"  ?errpreset "conservative"  )
desVar(	  "vddL" .500	)
desVar(	  "vddH" .850	)
envOption(
	'analysisOrder  list("tran")
)
temp( 27 )
run()
selectResult( 'tran )
plot(getData("/Y") getData("/B") getData("/A") getData("/~X") getData("/X") )
modelFile(
    '("/root/Desktop/Cadence/ncsu-FreePDK15/hspice_16nm_hp.include" "")
)
run()
selectResult( 'tran )
plot(getData("/Y") getData("/B") getData("/A") getData("/~X") getData("/X") )
modelFile(
    '("/root/Desktop/Cadence/ncsu-FreePDK15/hspice_16nm_hp.include" "")
)
desVar(	  "time3" 6n	)
desVar(	  "time2" 5n	)
run()
selectResult( 'tran )
plot(getData("/X") getData("/~X") getData("/A") getData("/B") getData("/Y") )
modelFile(
    '("/root/Desktop/Cadence/ncsu-FreePDK15/hspice_16nm_hp.include" "")
)
run()
selectResult( 'tran )
plot(getData("/X") getData("/~X") getData("/A") getData("/B") getData("/Y") )
modelFile(
    '("/root/Desktop/Cadence/ncsu-FreePDK15/hspice_16nm_hp.include" "")
)
run()
selectResult( 'tran )
plot(getData("/X") getData("/~X") getData("/A") getData("/B") getData("/Y") )
modelFile(
    '("/root/Desktop/Cadence/ncsu-FreePDK15/hspice_16nm_hp.include" "")
)
desVar(	  "vddH" 950m	)
run()
selectResult( 'tran )
plot(getData("/X") getData("/~X") getData("/A") getData("/B") getData("/Y") )
modelFile(
    '("/root/Desktop/Cadence/ncsu-FreePDK15/hspice_16nm_hp.include" "")
)
run()
selectResult( 'tran )
plot(getData("/X") getData("/~X") getData("/A") getData("/B") getData("/Y") )
modelFile(
    '("/root/Desktop/Cadence/ncsu-FreePDK15/hspice_16nm_hp.include" "")
)
run()
selectResult( 'tran )
plot(getData("/X") getData("/~X") getData("/A") getData("/B") getData("/Y") )
modelFile(
    '("/root/Desktop/Cadence/ncsu-FreePDK15/hspice_16nm_hp.include" "")
)
run()
selectResult( 'tran )
plot(getData("/C") getData("/X") getData("/~X") getData("/A") getData("/B") getData("/Y") )
modelFile(
    '("/root/Desktop/Cadence/ncsu-FreePDK15/hspice_16nm_hp.include" "")
)
desVar(	  "vddL" .850	)
desVar(	  "vddH" .850	)
save( 'i "/V2/MINUS" "/V2/PLUS" )
run()
selectResult( 'tran )
plot(getData("/X") getData("/~X") getData("/A") getData("/B") getData("/Y") getData("/C") getData("/V2/MINUS") getData("/V2/PLUS") )
modelFile(
    '("/root/Desktop/Cadence/ncsu-FreePDK15/hspice_16nm_hp.include" "")
)
run()
selectResult( 'tran )
plot(getData("/X") getData("/~X") getData("/A") getData("/B") getData("/Y") getData("/C") getData("/V2/MINUS") getData("/V2/PLUS") )
modelFile(
    '("/root/Desktop/Cadence/ncsu-FreePDK15/hspice_16nm_hp.include" "")
)
run()
selectResult( 'tran )
plot(getData("/X") getData("/~X") getData("/A") getData("/B") getData("/Y") getData("/C") getData("/V2/MINUS") getData("/V2/PLUS") )
