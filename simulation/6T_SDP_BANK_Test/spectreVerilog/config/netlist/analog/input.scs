// Design: 16nm_Tests/6T_SDP_BANK_Test
simulator lang=spectre
global 0 vdd! vcc!
parameters vdd=.500 vcc=vdd
include "/software/cadence/ncsu-FreePDK15/hspice_16nm_hp.include"

// 16nm/6T/schematic
//system verilogNetlist schematic cmos.sch cmos_sch veriloga ahdl
subckt _sub75 A B0 B1
    M5 (Q0 Q1 0 0) nfet w=120n l=20n nfin=2 m=1 degradation=no
    M4 (Q1 Q0 0 0) nfet w=120n l=20n nfin=2 m=1 degradation=no
    M1 (Q1 A B1 0) nfet w=120n l=20n nfin=2 m=1 degradation=no
    M0 (Q0 A B0 0) nfet w=120n l=20n nfin=2 m=1 degradation=no
    M3 (Q0 Q1 vdd! vdd!) pfet w=100n l=20n nfin=1 m=1 degradation=yes
    M2 (Q1 Q0 vdd! vdd!) pfet w=100n l=20n nfin=1 m=1 degradation=yes
ends _sub75

// 16nm/6T_4x/schematic
//system verilogNetlist schematic cmos.sch cmos_sch veriloga ahdl
subckt _sub76 A_3 A_2 A_1 A_0 B0 B1
    I3 (A_0 B0 B1) _sub75
    I2 (A_1 B0 B1) _sub75
    I1 (A_2 B0 B1) _sub75
    I0 (A_3 B0 B1) _sub75
ends _sub76

// 16nm/6T_32x/schematic
//system verilogNetlist schematic cmos.sch cmos_sch veriloga ahdl
subckt _sub77 A_31 A_30 A_29 A_28 A_27 A_26 A_25 A_24 A_23 A_22 A_21 A_20 A_19 A_18 A_17 A_16 A_15 A_14 A_13 A_12 A_11 A_10 A_9 A_8 A_7 A_6 A_5 A_4 A_3 A_2 A_1 A_0 B0 B1
    I7 (A_3 A_2 A_1 A_0 B0 B1) _sub76
    I6 (A_7 A_6 A_5 A_4 B0 B1) _sub76
    I5 (A_11 A_10 A_9 A_8 B0 B1) _sub76
    I4 (A_15 A_14 A_13 A_12 B0 B1) _sub76
    I3 (A_19 A_18 A_17 A_16 B0 B1) _sub76
    I2 (A_23 A_22 A_21 A_20 B0 B1) _sub76
    I1 (A_27 A_26 A_25 A_24 B0 B1) _sub76
    I0 (A_31 A_30 A_29 A_28 B0 B1) _sub76
ends _sub77

// 16nm/6T_32x_CTRL/schematic
//system verilogNetlist schematic cmos.sch cmos_sch veriloga ahdl
subckt _sub78 B0 B1 S W0 W1
    M10 (B1 B0 net22 vdd!) pfet w=100n l=20n nfin=1 m=1 degradation=yes
    M9 (net22 W0 vdd! vdd!) pfet w=100n l=20n nfin=1 m=1 degradation=yes
    M8 (B0 B1 net23 vdd!) pfet w=100n l=20n nfin=1 m=1 degradation=yes
    M7 (net23 W1 vdd! vdd!) pfet w=100n l=20n nfin=1 m=1 degradation=yes
    M2 (B1 S vdd! vdd!) pfet w=100n l=20n nfin=1 m=1 degradation=yes
    M0 (B0 S vdd! vdd!) pfet w=100n l=20n nfin=1 m=1 degradation=yes
    M6 (B1 W0 net24 0) nfet w=60n l=20n nfin=1 m=1 degradation=no
    M5 (net24 S 0 0) nfet w=60n l=20n nfin=1 m=1 degradation=no
    M4 (net25 S 0 0) nfet w=60n l=20n nfin=1 m=1 degradation=no
    M3 (B0 W1 net25 0) nfet w=60n l=20n nfin=1 m=1 degradation=no
ends _sub78

// 16nm/nand4_1x/schematic
//system verilogNetlist schematic cmos.sch cmos_sch veriloga ahdl
subckt nand4_1x A B C D Y
    M5 (Y D vdd! vdd!) pfet w=100n l=20n nfin=1 m=1 degradation=no
    M4 (Y C vdd! vdd!) pfet w=100n l=20n nfin=1 m=1 degradation=no
    M1 (Y B vdd! vdd!) pfet w=100n l=20n nfin=1 m=1 degradation=no
    M0 (Y A vdd! vdd!) pfet w=100n l=20n nfin=1 m=1 degradation=no
    M7 (net23 D 0 0) nfet w=240n l=20n nfin=1 m=1 degradation=no
    M6 (net25 C net23 0) nfet w=240n l=20n nfin=1 m=1 degradation=no
    M3 (net24 B net25 0) nfet w=240n l=20n nfin=1 m=1 degradation=no
    M2 (Y A net24 0) nfet w=240n l=20n nfin=1 m=1 degradation=no
ends nand4_1x

// 16nm/6T_32x4/schematic
//system verilogNetlist schematic cmos.sch cmos_sch veriloga ahdl
subckt _sub79 A_31 A_30 A_29 A_28 A_27 A_26 A_25 A_24 A_23 A_22 A_21 A_20 A_19 A_18 A_17 A_16 A_15 A_14 A_13 A_12 A_11 A_10 A_9 A_8 A_7 A_6 A_5 A_4 A_3 A_2 A_1 A_0 B0 B1 S_3 S_2 S_1 S_0 W0 W1 SM0 SM1
    I3 (A_31 A_30 A_29 A_28 A_27 A_26 A_25 A_24 A_23 A_22 A_21 A_20 A_19 A_18 A_17 A_16 A_15 A_14 A_13 A_12 A_11 A_10 A_9 A_8 A_7 A_6 A_5 A_4 A_3 A_2 A_1 A_0 B0P4 B1P4) _sub77
    I1 (A_31 A_30 A_29 A_28 A_27 A_26 A_25 A_24 A_23 A_22 A_21 A_20 A_19 A_18 A_17 A_16 A_15 A_14 A_13 A_12 A_11 A_10 A_9 A_8 A_7 A_6 A_5 A_4 A_3 A_2 A_1 A_0 B0P2 B1P2) _sub77
    I2 (A_31 A_30 A_29 A_28 A_27 A_26 A_25 A_24 A_23 A_22 A_21 A_20 A_19 A_18 A_17 A_16 A_15 A_14 A_13 A_12 A_11 A_10 A_9 A_8 A_7 A_6 A_5 A_4 A_3 A_2 A_1 A_0 B0P3 B1P3) _sub77
    I0 (A_31 A_30 A_29 A_28 A_27 A_26 A_25 A_24 A_23 A_22 A_21 A_20 A_19 A_18 A_17 A_16 A_15 A_14 A_13 A_12 A_11 A_10 A_9 A_8 A_7 A_6 A_5 A_4 A_3 A_2 A_1 A_0 B0P1 B1P1) _sub77
    M0 (B0P1 B0 net67 0) nfet w=60n l=20n nfin=1 m=1 degradation=no
    M1 (net67 S_0 0 0) nfet w=60n l=20n nfin=1 m=1 degradation=no
    M2 (net66 S_0 0 0) nfet w=60n l=20n nfin=1 m=1 degradation=no
    M8 (B1P2 B1 net65 0) nfet w=60n l=20n nfin=1 m=1 degradation=no
    M9 (net65 S_1 0 0) nfet w=60n l=20n nfin=1 m=1 degradation=no
    M10 (net64 S_1 0 0) nfet w=60n l=20n nfin=1 m=1 degradation=no
    M11 (B0P2 B0 net64 0) nfet w=60n l=20n nfin=1 m=1 degradation=no
    M12 (B0P3 B0 net63 0) nfet w=60n l=20n nfin=1 m=1 degradation=no
    M13 (net63 S_2 0 0) nfet w=60n l=20n nfin=1 m=1 degradation=no
    M14 (net62 S_2 0 0) nfet w=60n l=20n nfin=1 m=1 degradation=no
    M15 (B1P3 B1 net62 0) nfet w=60n l=20n nfin=1 m=1 degradation=no
    M16 (B1P4 B1 net61 0) nfet w=60n l=20n nfin=1 m=1 degradation=no
    M17 (net61 S_3 0 0) nfet w=60n l=20n nfin=1 m=1 degradation=no
    M18 (net60 S_3 0 0) nfet w=60n l=20n nfin=1 m=1 degradation=no
    M19 (B0P4 B0 net60 0) nfet w=60n l=20n nfin=1 m=1 degradation=no
    M3 (B1P1 B1 net66 0) nfet w=60n l=20n nfin=1 m=1 degradation=no
    I4 (B0P1 B1P1 S_0 W0 W1) _sub78
    I5 (B0P2 B1P2 S_1 W0 W1) _sub78
    I6 (B0P3 B1P3 S_2 W0 W1) _sub78
    I7 (B0P4 B1P4 S_3 W0 W1) _sub78
    I11 (B1P1 B1P2 B1P3 B1P4 SM1) nand4_1x
    I10 (B0P1 B0P2 B0P3 B0P4 SM0) nand4_1x
    C7 (B1P4 0) capacitor c=1.2822f m=1
    C6 (B1P2 0) capacitor c=1.2822f m=1
    C5 (B1P3 0) capacitor c=1.2822f m=1
    C4 (B0P4 0) capacitor c=1.2822f m=1
    C3 (B0P3 0) capacitor c=1.2822f m=1
    C2 (B0P2 0) capacitor c=1.2822f m=1
    C1 (B1P1 0) capacitor c=1.2822f m=1
    C0 (B0P1 0) capacitor c=1.2822f m=1
    M23 (B1P4 S_3 vdd! vdd!) pfet w=100n l=20n nfin=1 m=1 degradation=no
    M22 (B0P4 S_3 vdd! vdd!) pfet w=100n l=20n nfin=1 m=1 degradation=no
    M21 (B0P3 S_2 vdd! vdd!) pfet w=100n l=20n nfin=1 m=1 degradation=no
    M20 (B1P3 S_2 vdd! vdd!) pfet w=100n l=20n nfin=1 m=1 degradation=no
    M7 (B1P2 S_1 vdd! vdd!) pfet w=100n l=20n nfin=1 m=1 degradation=no
    M6 (B0P2 S_1 vdd! vdd!) pfet w=100n l=20n nfin=1 m=1 degradation=no
    M5 (B1P1 S_0 vdd! vdd!) pfet w=100n l=20n nfin=1 m=1 degradation=no
    M4 (B0P1 S_0 vdd! vdd!) pfet w=100n l=20n nfin=1 m=1 degradation=no
ends _sub79

// 16nm/6T_SetRead/schematic
//system verilogNetlist schematic cmos.sch cmos_sch veriloga ahdl
subckt _sub80 Go SM0_0 SM0_1 SM1_0 SM1_1 \~R0 \~R1
    M5 (\~R0 SM0_0 net18 0) nfet w=60n l=20n nfin=1 m=1 degradation=no
    M3 (\~R0 SM0_1 net18 0) nfet w=60n l=20n nfin=1 m=1 degradation=no
    M2 (net18 Go 0 0) nfet w=120n l=20n nfin=2 m=1 degradation=no
    M1 (\~R1 SM1_1 net18 0) nfet w=60n l=20n nfin=1 m=1 degradation=no
    M0 (\~R1 SM1_0 net18 0) nfet w=60n l=20n nfin=1 m=1 degradation=no
ends _sub80

// 16nm/6T_CHUNK/schematic
//system verilogNetlist schematic cmos.sch cmos_sch veriloga ahdl
subckt _sub81 A_63 A_62 A_61 A_60 A_59 A_58 A_57 A_56 A_55 A_54 A_53 A_52 A_51 A_50 A_49 A_48 A_47 A_46 A_45 A_44 A_43 A_42 A_41 A_40 A_39 A_38 A_37 A_36 A_35 A_34 A_33 A_32 A_31 A_30 A_29 A_28 A_27 A_26 A_25 A_24 A_23 A_22 A_21 A_20 A_19 A_18 A_17 A_16 A_15 A_14 A_13 A_12 A_11 A_10 A_9 A_8 A_7 A_6 A_5 A_4 A_3 A_2 A_1 A_0 B0_3 B0_2 B0_1 B0_0 B1_3 B1_2 B1_1 B1_0 Go S_7 S_6 S_5 S_4 S_3 S_2 S_1 S_0 W0_3 W0_2 W0_1 W0_0 W1_3 W1_2 W1_1 W1_0 \~R0_3 \~R0_2 \~R0_1 \~R0_0 \~R1_3 \~R1_2 \~R1_1 \~R1_0
    I11 (A_63 A_62 A_61 A_60 A_59 A_58 A_57 A_56 A_55 A_54 A_53 A_52 A_51 A_50 A_49 A_48 A_47 A_46 A_45 A_44 A_43 A_42 A_41 A_40 A_39 A_38 A_37 A_36 A_35 A_34 A_33 A_32 B0_3 B1_3 S_7 S_6 S_5 S_4 W0_3 W1_3 SM0_1_bit3 SM1_1_bit3) _sub79
    I10 (A_63 A_62 A_61 A_60 A_59 A_58 A_57 A_56 A_55 A_54 A_53 A_52 A_51 A_50 A_49 A_48 A_47 A_46 A_45 A_44 A_43 A_42 A_41 A_40 A_39 A_38 A_37 A_36 A_35 A_34 A_33 A_32 B0_2 B1_2 S_7 S_6 S_5 S_4 W0_2 W1_2 SM0_1_bit2 SM1_1_bit2) _sub79
    I9 (A_63 A_62 A_61 A_60 A_59 A_58 A_57 A_56 A_55 A_54 A_53 A_52 A_51 A_50 A_49 A_48 A_47 A_46 A_45 A_44 A_43 A_42 A_41 A_40 A_39 A_38 A_37 A_36 A_35 A_34 A_33 A_32 B0_1 B1_1 S_7 S_6 S_5 S_4 W0_1 W1_1 SM0_1_bit1 SM1_1_bit1) _sub79
    I8 (A_63 A_62 A_61 A_60 A_59 A_58 A_57 A_56 A_55 A_54 A_53 A_52 A_51 A_50 A_49 A_48 A_47 A_46 A_45 A_44 A_43 A_42 A_41 A_40 A_39 A_38 A_37 A_36 A_35 A_34 A_33 A_32 B0_0 B1_0 S_7 S_6 S_5 S_4 W0_0 W1_0 SM0_1_bit0 SM1_1_bit0) _sub79
    I3 (A_31 A_30 A_29 A_28 A_27 A_26 A_25 A_24 A_23 A_22 A_21 A_20 A_19 A_18 A_17 A_16 A_15 A_14 A_13 A_12 A_11 A_10 A_9 A_8 A_7 A_6 A_5 A_4 A_3 A_2 A_1 A_0 B0_3 B1_3 S_3 S_2 S_1 S_0 W0_3 W1_3 SM0_0_bit3 SM1_0_bit3) _sub79
    I2 (A_31 A_30 A_29 A_28 A_27 A_26 A_25 A_24 A_23 A_22 A_21 A_20 A_19 A_18 A_17 A_16 A_15 A_14 A_13 A_12 A_11 A_10 A_9 A_8 A_7 A_6 A_5 A_4 A_3 A_2 A_1 A_0 B0_2 B1_2 S_3 S_2 S_1 S_0 W0_2 W1_2 SM0_0_bit2 SM1_0_bit2) _sub79
    I1 (A_31 A_30 A_29 A_28 A_27 A_26 A_25 A_24 A_23 A_22 A_21 A_20 A_19 A_18 A_17 A_16 A_15 A_14 A_13 A_12 A_11 A_10 A_9 A_8 A_7 A_6 A_5 A_4 A_3 A_2 A_1 A_0 B0_1 B1_1 S_3 S_2 S_1 S_0 W0_1 W1_1 SM0_0_bit1 SM1_0_bit1) _sub79
    I0 (A_31 A_30 A_29 A_28 A_27 A_26 A_25 A_24 A_23 A_22 A_21 A_20 A_19 A_18 A_17 A_16 A_15 A_14 A_13 A_12 A_11 A_10 A_9 A_8 A_7 A_6 A_5 A_4 A_3 A_2 A_1 A_0 B0_0 B1_0 S_3 S_2 S_1 S_0 W0_0 W1_0 SM0_0_bit0 SM1_0_bit0) _sub79
    I7 (Go SM0_0_bit3 SM0_1_bit3 SM1_0_bit3 SM1_1_bit3 \~R0_3 \~R1_3) _sub80
    I6 (Go SM0_0_bit2 SM0_1_bit2 SM1_0_bit2 SM1_1_bit2 \~R0_2 \~R1_2) _sub80
    I5 (Go SM0_0_bit1 SM0_1_bit1 SM1_0_bit1 SM1_1_bit1 \~R0_1 \~R1_1) _sub80
    I4 (Go SM0_0_bit0 SM0_1_bit0 SM1_0_bit0 SM1_1_bit0 \~R0_0 \~R1_0) _sub80
ends _sub81

// 16nm/inv_1x/schematic
//system verilogNetlist schematic cmos.sch cmos_sch veriloga ahdl
subckt inv_1x A Y
    M0 (Y A 0 0) nfet w=60n l=20n nfin=1 m=1 degradation=no
    M1 (Y A vdd! vdd!) pfet w=100n l=20n nfin=1 m=1 degradation=no
ends inv_1x

// 16nm/TH22~/schematic
//system verilogNetlist schematic cmos.sch cmos_sch veriloga ahdl
subckt _sub82 A B Y
    I6 (net010 Y) inv_1x
    M5 (net010 net5 0 0) nfet w=48n l=16n nfin=1 m=1 degradation=no
    M4 (net5 net010 net9 0) nfet w=48n l=16n nfin=1 m=1 degradation=no
    M3 (net9 B 0 0) nfet w=48n l=16n nfin=1 m=1 degradation=no
    M2 (net9 A 0 0) nfet w=48n l=16n nfin=1 m=1 degradation=no
    M1 (net5 B net17 0) nfet w=80n l=16n nfin=1 m=1 degradation=no
    M0 (net17 A 0 0) nfet w=80n l=16n nfin=1 m=1 degradation=no
    M11 (net010 net5 vdd! vdd!) pfet w=80n l=16n nfin=1 m=1 degradation=yes
    M10 (net5 B net032 vdd!) pfet w=160n l=16n nfin=1 m=1 degradation=yes
    M9 (net032 A vdd! vdd!) pfet w=160n l=16n nfin=1 m=1 degradation=yes
    M8 (net037 B vdd! vdd!) pfet w=80n l=16n nfin=1 m=1 degradation=yes
    M7 (net037 A vdd! vdd!) pfet w=80n l=16n nfin=1 m=1 degradation=yes
    M6 (net5 net010 net037 vdd!) pfet w=80n l=16n nfin=1 m=1 degradation=yes
ends _sub82

// 16nm/nand_1x/schematic
//system verilogNetlist schematic cmos.sch cmos_sch veriloga ahdl
subckt nand_1x A B Y
    M1 (Y B vdd! vdd!) pfet w=100n l=20n nfin=1 m=1 degradation=no
    M0 (Y A vdd! vdd!) pfet w=100n l=20n nfin=1 m=1 degradation=no
    M3 (net22 B 0 0) nfet w=120n l=20n nfin=1 m=1 degradation=no
    M2 (Y A net22 0) nfet w=120n l=20n nfin=1 m=1 degradation=no
ends nand_1x

// 16nm/nor_1x/schematic
//system verilogNetlist schematic cmos.sch cmos_sch veriloga ahdl
subckt nor_1x A B Y
    M3 (Y B or_pd_ps vdd!) pfet w=200n l=20n nfin=1 m=1 degradation=yes
    M2 (or_pd_ps A vdd! vdd!) pfet w=200n l=20n nfin=1 m=1 degradation=yes
    M1 (Y B 0 0) nfet w=60n l=20n nfin=1 m=1 degradation=no
    M0 (Y A 0 0) nfet w=60n l=20n nfin=1 m=1 degradation=no
ends nor_1x

// 16nm/or_1x/schematic
//system verilogNetlist schematic cmos.sch cmos_sch veriloga ahdl
subckt or_1x A B Y
    I6 (A B AnorB) nor_1x
    I7 (AnorB Y) inv_1x
ends or_1x

// 16nm/inv_weak_1x/schematic
//system verilogNetlist schematic cmos.sch cmos_sch veriloga ahdl
subckt inv_weak_1x A Y
    M2 (net13 vdd! 0 0) nfet w=60n l=20n nfin=1 ls=105n m=1 degradation=no
    M0 (Y A net13 0) nfet w=60n l=20n nfin=1 ls=105n m=1 degradation=no
    M3 (net14 0 vdd! vdd!) pfet w=100n l=20n nfin=1 m=1 degradation=yes
    M1 (Y A net14 vdd!) pfet w=100n l=20n nfin=1 m=1 degradation=yes
ends inv_weak_1x

// 16nm/TH22/schematic
//system verilogNetlist schematic cmos.sch cmos_sch veriloga ahdl
subckt TH22 A B Y
    M5 (Y net5 0 0) nfet w=60n l=20n nfin=1 m=1 degradation=no
    M4 (net5 Y net9 0) nfet w=120n l=20n nfin=1 m=1 degradation=no
    M3 (net9 B 0 0) nfet w=120n l=20n nfin=1 m=1 degradation=no
    M2 (net9 A 0 0) nfet w=120n l=20n nfin=1 m=1 degradation=no
    M1 (net5 B net17 0) nfet w=120n l=20n nfin=1 m=1 degradation=no
    M0 (net17 A 0 0) nfet w=120n l=20n nfin=1 m=1 degradation=no
    M11 (Y net5 vdd! vdd!) pfet w=100n l=20n nfin=1 m=1 degradation=yes
    M10 (net5 B net032 vdd!) pfet w=200n l=20n nfin=1 m=1 degradation=yes
    M9 (net032 A vdd! vdd!) pfet w=200n l=20n nfin=1 m=1 degradation=yes
    M8 (net037 B vdd! vdd!) pfet w=200n l=20n nfin=1 m=1 degradation=yes
    M7 (net037 A vdd! vdd!) pfet w=200n l=20n nfin=1 m=1 degradation=yes
    M6 (net5 Y net037 vdd!) pfet w=200n l=20n nfin=1 m=1 degradation=yes
ends TH22

// 16nm/PCHBd/schematic
//system verilogNetlist schematic cmos.sch cmos_sch veriloga ahdl
subckt PCHBd Ai Ai\+1 R0i R0i\+1 R1i R1i\+1
    I32 (net019 R0i\+1) inv_1x
    I5 (net032 R1i\+1) inv_1x
    I12 (net031 net030 Ai) _sub82
    M16 (net019 R0i net034 0) nfet w=60n l=20n nfin=1 m=1 degradation=no
    M3 (net032 R1i net033 0) nfet w=60n l=20n nfin=1 m=1 degradation=no
    M4 (net034 net022 0 0) nfet w=60n l=20n nfin=1 m=1 degradation=no
    M5 (net033 net022 0 0) nfet w=60n l=20n nfin=1 m=1 degradation=no
    M10 (net019 net022 vdd! vdd!) pfet w=200n l=20n nfin=1 m=1 degradation=yes
    M1 (net032 net022 vdd! vdd!) pfet w=200n l=20n nfin=1 m=1 degradation=yes
    I6 (net032 net019 net031) nand_1x
    I9 (R0i R1i net030) or_1x
    I2 (R0i\+1 net019) inv_weak_1x
    I33 (R1i\+1 net032) inv_weak_1x
    I30 (Ai Ai\+1 net022) TH22
ends PCHBd

// 16nm/WCHB/schematic
//system verilogNetlist schematic cmos.sch cmos_sch veriloga ahdl
subckt WCHB L0 L1 Lack R0 R1 Rack
    I1 (Rack L1 R1) TH22
    I0 (L0 Rack R0) TH22
    I6 (R1 R0 Lack) nor_1x
ends WCHB

// 16nm/TH44/schematic
//system verilogNetlist schematic cmos.sch cmos_sch veriloga ahdl
subckt TH44 A B C D Y
    M19 (net13 A 0 0) nfet w=120n l=20n nfin=1 m=1 degradation=no
    M18 (net13 B 0 0) nfet w=120n l=20n nfin=1 m=1 degradation=no
    M17 (net13 C 0 0) nfet w=120n l=20n nfin=1 m=1 degradation=no
    M16 (net13 D 0 0) nfet w=120n l=20n nfin=1 m=1 degradation=no
    M15 (Y net19 0 0) nfet w=60n l=20n nfin=1 m=1 degradation=no
    M14 (net42 A 0 0) nfet w=240n l=20n nfin=1 m=1 degradation=no
    M13 (net43 B net42 0) nfet w=240n l=20n nfin=1 m=1 degradation=no
    M12 (net44 C net43 0) nfet w=240n l=20n nfin=1 m=1 degradation=no
    M11 (net19 D net44 0) nfet w=240n l=20n nfin=1 m=1 degradation=no
    M10 (net19 Y net13 0) nfet w=120n l=20n nfin=1 m=1 degradation=no
    M9 (Y net19 vdd! vdd!) pfet w=100n l=20n nfin=1 m=1 degradation=yes
    M8 (net19 Y net15 vdd!) pfet w=200n l=20n nfin=1 m=1 degradation=yes
    M7 (net15 D vdd! vdd!) pfet w=200n l=20n nfin=1 m=1 degradation=yes
    M6 (net15 C vdd! vdd!) pfet w=200n l=20n nfin=1 m=1 degradation=yes
    M5 (net15 B vdd! vdd!) pfet w=200n l=20n nfin=1 m=1 degradation=yes
    M4 (net15 A vdd! vdd!) pfet w=200n l=20n nfin=1 m=1 degradation=yes
    M3 (net19 D net45 vdd!) pfet w=320n l=20n nfin=1 m=1 degradation=yes
    M2 (net45 C net46 vdd!) pfet w=320n l=20n nfin=1 m=1 degradation=yes
    M1 (net46 B net47 vdd!) pfet w=320n l=20n nfin=1 m=1 degradation=yes
    M0 (net47 A vdd! vdd!) pfet w=320n l=20n nfin=1 m=1 degradation=yes
ends TH44

// 16nm/and_1x/schematic
//system verilogNetlist schematic cmos.sch cmos_sch veriloga ahdl
subckt and_1x A B Y
    I7 (A B ntYbar) nand_1x
    I6 (ntYbar Y) inv_1x
ends and_1x

// 16nm/THaC/schematic
//system verilogNetlist schematic cmos.sch cmos_sch veriloga ahdl
subckt THaC A B\+ C\- Y
    M8 (net11 A 0 A) nfet w=120n l=20n nfin=1 m=1 degradation=no
    M5 (net7 A net33 A) nfet w=120n l=20n nfin=1 m=1 degradation=no
    M6 (net7 net021 net11 net021) nfet w=120n l=20n nfin=1 m=1 degradation=no
    M9 (net11 C\- 0 C\-) nfet w=120n l=20n nfin=1 m=1 degradation=no
    M7 (net33 \~B\+ 0 \~B\+) nfet w=120n l=20n nfin=1 m=1 degradation=no
    I2 (net7 net021) inv_1x
    I9 (B\+ \~B\+) inv_1x
    I8 (net021 Y) inv_1x
    M4 (net7 net021 net17 net021) pfet w=100n l=20n nfin=1 m=1 degradation=yes
    M3 (net7 C\- net32 C\-) pfet w=100n l=20n nfin=1 m=1 degradation=yes
    M0 (net32 A vdd! A) pfet w=100n l=20n nfin=1 m=1 degradation=yes
    M2 (net17 \~B\+ vdd! \~B\+) pfet w=100n l=20n nfin=1 m=1 degradation=yes
    M1 (net17 A vdd! A) pfet w=100n l=20n nfin=1 m=1 degradation=yes
ends THaC

// 16nm/PCHB_FIFO/schematic
//system verilogNetlist schematic cmos.sch cmos_sch veriloga ahdl
subckt PCHB_FIFO outAck R0i R0i\+1 R1i R1i\+1 W0 W1
    I5 (net029 R1i\+1) inv_1x
    I4 (net18 R0i\+1) inv_1x
    I12 (inValid inAck outValid outAck) THaC
    M5 (net026 oE 0 0) nfet w=60n l=20n nfin=1 m=1 degradation=no
    M4 (net22 oE 0 0) nfet w=60n l=20n nfin=1 m=1 degradation=no
    M3 (net029 R1i net026 0) nfet w=60n l=20n nfin=1 m=1 degradation=no
    M2 (net18 R0i net22 0) nfet w=60n l=20n nfin=1 m=1 degradation=no
    M1 (net029 oE vdd! vdd!) pfet w=200n l=20n nfin=1 m=1 degradation=yes
    M0 (net18 oE vdd! vdd!) pfet w=200n l=20n nfin=1 m=1 degradation=yes
    I6 (net029 net18 outValid) nand_1x
    I9 (R0i R1i inValid) or_1x
    I2 (R0i\+1 net18) inv_weak_1x
    I3 (R1i\+1 net029) inv_weak_1x
    I11 (outAck inAck oE) TH22
    I31 (W1 W0 inAck) nor_1x
ends PCHB_FIFO

// 16nm/WCHB~/schematic
//system verilogNetlist schematic cmos.sch cmos_sch veriloga ahdl
subckt _sub83 L0 L1 Lack Rack \~R0 \~R1
    I18 (Rack L1 net9) TH22
    I0 (L0 Rack net10) TH22
    I2 (net9 net10 Lack) nor_1x
    I20 (net9 \~R1) inv_1x
    I19 (net10 \~R0) inv_1x
ends _sub83

// 16nm/6T_DATA/schematic
//system verilogNetlist schematic cmos.sch cmos_sch veriloga ahdl
subckt _sub84 Ack B0_3 B0_2 B0_1 B0_0 B1_3 B1_2 B1_1 B1_0 Go R1_1of4_3 R1_1of4_2 R1_1of4_1 R1_1of4_0 R2_1of4_3 R2_1of4_2 R2_1of4_1 R2_1of4_0 RW_1 RW_0 Reset ValAddr W0_3 W0_2 W0_1 W0_0 W1_3 W1_2 W1_1 W1_0 W1_1of4_3 W1_1of4_2 W1_1of4_1 W1_1of4_0 W2_1of4_3 W2_1of4_2 W2_1of4_1 W2_1of4_0 AckThruBot AckThruTop RAck_1 RAck_0 WAck_1 WAck_0 \~R0_3 \~R0_2 \~R0_1 \~R0_0 \~R1_3 \~R1_2 \~R1_1 \~R1_0
    I80_3 (Lack_3 RpAck_3 R0_3 R0q_3 R1_3 R1q_3) PCHBd
    I80_2 (Lack_2 RpAck_2 R0_2 R0q_2 R1_2 R1q_2) PCHBd
    I80_1 (Lack_1 RpAck_1 R0_1 R0q_1 R1_1 R1q_1) PCHBd
    I80_0 (Lack_0 RpAck_0 R0_0 R0q_0 R1_0 R1q_0) PCHBd
    I54 (Out0_2 Out1_3 R2_1of4_2) nor_1x
    I53 (Out0_3 Out0_2 R2_1of4_3) nor_1x
    I52 (Out0_3 Out1_2 R2_1of4_1) nor_1x
    I51 (Out1_3 Out1_2 R2_1of4_0) nor_1x
    I50 (Out0_1 Out0_0 R1_1of4_3) nor_1x
    I49 (Out1_1 Out0_0 R1_1of4_2) nor_1x
    I47 (Out1_1 Out1_0 R1_1of4_0) nor_1x
    I48 (Out1_0 Out0_1 R1_1of4_1) nor_1x
    I21 (B0p_0 B1p_0 WLAck_0 B0q_0 B1q_0 wack_0) WCHB
    I24 (B0p_3 B1p_3 WLAck_3 B0q_3 B1q_3 wack_3) WCHB
    I23 (B0p_2 B1p_2 WLAck_2 B0q_2 B1q_2 wack_2) WCHB
    I22 (B0p_1 B1p_1 WLAck_1 B0q_1 B1q_1 wack_1) WCHB
    I43 (Lack_3 Lack_2 Lack_1 Lack_0 intRack) TH44
    I29 (wack_3 wack_2 wack_1 wack_0 intWack) TH44
    I18 (W2_1of4_2 W2_1of4_3 B0p_3) or_1x
    I17 (W2_1of4_0 W2_1of4_1 B1p_3) or_1x
    I11 (W1_1of4_2 W1_1of4_3 B0p_1) or_1x
    I10 (W1_1of4_0 W1_1of4_1 B1p_1) or_1x
    I16 (W2_1of4_1 W2_1of4_3 B0p_2) or_1x
    I15 (W2_1of4_0 W2_1of4_2 B1p_2) or_1x
    I1 (W1_1of4_1 W1_1of4_3 B0p_0) or_1x
    I0 (W1_1of4_0 W1_1of4_2 B1p_0) or_1x
    I78_3 (Wen B0_3 W0_3) and_1x
    I78_2 (Wen B0_2 W0_2) and_1x
    I78_1 (Wen B0_1 W0_1) and_1x
    I78_0 (Wen B0_0 W0_0) and_1x
    I77_3 (Wen B1_3 W1_3) and_1x
    I77_2 (Wen B1_2 W1_2) and_1x
    I77_1 (Wen B1_1 W1_1) and_1x
    I77_0 (Wen B1_0 W1_0) and_1x
    M1_3 (\~R1_3 Go vdd! vdd!) pfet w=100n l=20n nfin=1 m=1 degradation=yes
    M1_2 (\~R1_2 Go vdd! vdd!) pfet w=100n l=20n nfin=1 m=1 degradation=yes
    M1_1 (\~R1_1 Go vdd! vdd!) pfet w=100n l=20n nfin=1 m=1 degradation=yes
    M1_0 (\~R1_0 Go vdd! vdd!) pfet w=100n l=20n nfin=1 m=1 degradation=yes
    M0_3 (\~R0_3 Go vdd! vdd!) pfet w=100n l=20n nfin=1 m=1 degradation=yes
    M0_2 (\~R0_2 Go vdd! vdd!) pfet w=100n l=20n nfin=1 m=1 degradation=yes
    M0_1 (\~R0_1 Go vdd! vdd!) pfet w=100n l=20n nfin=1 m=1 degradation=yes
    M0_0 (\~R0_0 Go vdd! vdd!) pfet w=100n l=20n nfin=1 m=1 degradation=yes
    I35_3 (\~R1_3 R1_3) inv_1x
    I35_2 (\~R1_2 R1_2) inv_1x
    I35_1 (\~R1_1 R1_1) inv_1x
    I35_0 (\~R1_0 R1_0) inv_1x
    I34_3 (\~R0_3 R0_3) inv_1x
    I34_2 (\~R0_2 R0_2) inv_1x
    I34_1 (\~R0_1 R0_1) inv_1x
    I34_0 (\~R0_0 R0_0) inv_1x
    I64 (RAck_0 Rack_0) iprobe
    I63 (RAck_0 Rack_1) iprobe
    I62 (RAck_1 Rack_2) iprobe
    I56 (AckThruBot AckThruTop) iprobe
    I61 (RAck_1 Rack_3) iprobe
    I65 (ValAddr RW_0 Wen) TH22
    I58 (WLAck_1 WLAck_0 WAck_0) TH22
    I38 (ValAddr RW_1 Go) TH22
    I57 (WLAck_3 WLAck_2 WAck_1) TH22
    I73 (wack_0 B0q_0 B0_0 B1q_0 B1_0 W0_0 W1_0) PCHB_FIFO
    I74 (wack_1 B0q_1 B0_1 B1q_1 B1_1 W0_1 W1_1) PCHB_FIFO
    I75 (wack_2 B0q_2 B0_2 B1q_2 B1_2 W0_2 W1_2) PCHB_FIFO
    I76 (wack_3 B0q_3 B0_3 B1q_3 B1_3 W0_3 W1_3) PCHB_FIFO
    I82 (intRack intWack Ack) nand_1x
    I67_3 (R0q_3 R1q_3 RpAck_3 Rack_3 Out0_3 Out1_3) _sub83
    I67_2 (R0q_2 R1q_2 RpAck_2 Rack_2 Out0_2 Out1_2) _sub83
    I67_1 (R0q_1 R1q_1 RpAck_1 Rack_1 Out0_1 Out1_1) _sub83
    I67_0 (R0q_0 R1q_0 RpAck_0 Rack_0 Out0_0 Out1_0) _sub83
ends _sub84

// 16nm/6T_CONTROL/schematic
//system verilogNetlist schematic cmos.sch cmos_sch veriloga ahdl
subckt _sub85 _1of4_1_3 _1of4_1_2 _1of4_1_1 _1of4_1_0 _1of4_2_3 _1of4_2_2 _1of4_2_1 _1of4_2_0 _1of4_3_3 _1of4_3_2 _1of4_3_1 _1of4_3_0 _1of4_4_3 _1of4_4_2 _1of4_4_1 _1of4_4_0 _1of4_5_3 _1of4_5_2 _1of4_5_1 _1of4_5_0 AddrAck_3 AddrAck_2 AddrAck_1 AddrAck_0 InAck_1 InAck_0 InAck_3 InAck_2 OutAck RW_1 RW_0 Reset ValAddr
    I18 (pV_0 pV_1 pV_2 pV_3 ValAddr) nand4_1x
    I14 (InAck_0 InAck_1 InAck_2 InAck_3 OutAck) TH44
    I19_3 (AddrAck_3 _1of4_5_3 pV_3) nand_1x
    I19_2 (AddrAck_2 _1of4_5_2 pV_2) nand_1x
    I19_1 (AddrAck_1 _1of4_5_1 pV_1) nand_1x
    I19_0 (AddrAck_0 _1of4_5_0 pV_0) nand_1x
ends _sub85

// 16nm/and4_1x/schematic
//system verilogNetlist schematic cmos.sch cmos_sch veriloga ahdl
subckt and4_1x A B C D Y
    I15 (A B C D net1) nand4_1x
    I16 (net1 Y) inv_1x
ends and4_1x

// 16nm/Demux_2e1of4/schematic
//system verilogNetlist schematic cmos.sch cmos_sch veriloga ahdl
subckt Demux_2e1of4 _1of4_1_3 _1of4_1_2 _1of4_1_1 _1of4_1_0 _1of4_2_3 _1of4_2_2 _1of4_2_1 _1of4_2_0 A_15 A_14 A_13 A_12 A_11 A_10 A_9 A_8 A_7 A_6 A_5 A_4 A_3 A_2 A_1 A_0 En EnOut
    I15 (_1of4_1_3 _1of4_2_3 EnOut En A_15) and4_1x
    I14 (_1of4_1_2 _1of4_2_3 EnOut En A_14) and4_1x
    I13 (_1of4_1_1 _1of4_2_3 EnOut En A_13) and4_1x
    I12 (_1of4_1_0 _1of4_2_3 EnOut En A_12) and4_1x
    I11 (_1of4_1_3 _1of4_2_2 EnOut En A_11) and4_1x
    I10 (_1of4_1_2 _1of4_2_2 EnOut En A_10) and4_1x
    I9 (_1of4_1_1 _1of4_2_2 EnOut En A_9) and4_1x
    I8 (_1of4_1_0 _1of4_2_2 EnOut En A_8) and4_1x
    I7 (_1of4_1_3 _1of4_2_1 EnOut En A_7) and4_1x
    I6 (_1of4_1_2 _1of4_2_1 EnOut En A_6) and4_1x
    I5 (_1of4_1_1 _1of4_2_1 EnOut En A_5) and4_1x
    I4 (_1of4_1_0 _1of4_2_1 EnOut En A_4) and4_1x
    I3 (_1of4_1_3 _1of4_2_0 EnOut En A_3) and4_1x
    I2 (_1of4_1_2 _1of4_2_0 EnOut En A_2) and4_1x
    I1 (_1of4_1_1 _1of4_2_0 EnOut En A_1) and4_1x
    I0 (_1of4_1_0 _1of4_2_0 EnOut En A_0) and4_1x
ends Demux_2e1of4

// 16nm/nor4_1x/schematic
//system verilogNetlist schematic cmos.sch cmos_sch veriloga ahdl
subckt nor4_1x A B C D Y
    M5 (net017 C net21 vdd!) pfet w=400n l=20n nfin=1 m=1 degradation=yes
    M4 (Y D net017 vdd!) pfet w=400n l=20n nfin=1 m=1 degradation=yes
    M3 (net21 B net018 vdd!) pfet w=400n l=20n nfin=1 m=1 degradation=yes
    M2 (net018 A vdd! vdd!) pfet w=400n l=20n nfin=1 m=1 degradation=yes
    M7 (Y D 0 0) nfet w=60n l=20n nfin=1 m=1 degradation=no
    M6 (Y C 0 0) nfet w=60n l=20n nfin=1 m=1 degradation=no
    M1 (Y A 0 0) nfet w=60n l=20n nfin=1 m=1 degradation=no
    M0 (Y B 0 0) nfet w=60n l=20n nfin=1 m=1 degradation=no
ends nor4_1x

// 16nm/or16_1x/schematic
//system verilogNetlist schematic cmos.sch cmos_sch veriloga ahdl
subckt or16_1x Y X_15 X_14 X_13 X_12 X_11 X_10 X_9 X_8 X_7 X_6 X_5 X_4 X_3 X_2 X_1 X_0
    I2 (nX30 nX74 nX118 nX1512 Y) nand4_1x
    I0 (X_0 X_1 X_2 X_3 nX30) nor4_1x
    I1 (X_4 X_5 X_6 X_7 nX74) nor4_1x
    I3 (X_8 X_9 X_10 X_11 nX118) nor4_1x
    I4 (X_12 X_13 X_14 X_15 nX1512) nor4_1x
ends or16_1x

// 16nm/or4_1x/schematic
//system verilogNetlist schematic cmos.sch cmos_sch veriloga ahdl
subckt or4_1x A B C D Y
    I0 (A B C D net11) nor4_1x
    I1 (net11 Y) inv_1x
ends or4_1x

// 16nm/Demux_3e1of4/schematic
//system verilogNetlist schematic cmos.sch cmos_sch veriloga ahdl
subckt Demux_3e1of4 _1of4_1_3 _1of4_1_2 _1of4_1_1 _1of4_1_0 _1of4_2_3 _1of4_2_2 _1of4_2_1 _1of4_2_0 _1of4_3_3 _1of4_3_2 _1of4_3_1 _1of4_3_0 A_63 A_62 A_61 A_60 A_59 A_58 A_57 A_56 A_55 A_54 A_53 A_52 A_51 A_50 A_49 A_48 A_47 A_46 A_45 A_44 A_43 A_42 A_41 A_40 A_39 A_38 A_37 A_36 A_35 A_34 A_33 A_32 A_31 A_30 A_29 A_28 A_27 A_26 A_25 A_24 A_23 A_22 A_21 A_20 A_19 A_18 A_17 A_16 A_15 A_14 A_13 A_12 A_11 A_10 A_9 A_8 A_7 A_6 A_5 A_4 A_3 A_2 A_1 A_0 En AddrValid
    I3 (_1of4_1_3 _1of4_1_2 _1of4_1_1 _1of4_1_0 _1of4_2_3 _1of4_2_2 _1of4_2_1 _1of4_2_0 A_63 A_62 A_61 A_60 A_59 A_58 A_57 A_56 A_55 A_54 A_53 A_52 A_51 A_50 A_49 A_48 En _1of4_3_3) Demux_2e1of4
    I2 (_1of4_1_3 _1of4_1_2 _1of4_1_1 _1of4_1_0 _1of4_2_3 _1of4_2_2 _1of4_2_1 _1of4_2_0 A_47 A_46 A_45 A_44 A_43 A_42 A_41 A_40 A_39 A_38 A_37 A_36 A_35 A_34 A_33 A_32 En _1of4_3_2) Demux_2e1of4
    I1 (_1of4_1_3 _1of4_1_2 _1of4_1_1 _1of4_1_0 _1of4_2_3 _1of4_2_2 _1of4_2_1 _1of4_2_0 A_31 A_30 A_29 A_28 A_27 A_26 A_25 A_24 A_23 A_22 A_21 A_20 A_19 A_18 A_17 A_16 En _1of4_3_1) Demux_2e1of4
    I0 (_1of4_1_3 _1of4_1_2 _1of4_1_1 _1of4_1_0 _1of4_2_3 _1of4_2_2 _1of4_2_1 _1of4_2_0 A_15 A_14 A_13 A_12 A_11 A_10 A_9 A_8 A_7 A_6 A_5 A_4 A_3 A_2 A_1 A_0 En _1of4_3_0) Demux_2e1of4
    I8 (net22 A_63 A_62 A_61 A_60 A_59 A_58 A_57 A_56 A_55 A_54 A_53 A_52 A_51 A_50 A_49 A_48) or16_1x
    I7 (net23 A_47 A_46 A_45 A_44 A_43 A_42 A_41 A_40 A_39 A_38 A_37 A_36 A_35 A_34 A_33 A_32) or16_1x
    I6 (net24 A_31 A_30 A_29 A_28 A_27 A_26 A_25 A_24 A_23 A_22 A_21 A_20 A_19 A_18 A_17 A_16) or16_1x
    I17 (net25 A_15 A_14 A_13 A_12 A_11 A_10 A_9 A_8 A_7 A_6 A_5 A_4 A_3 A_2 A_1 A_0) or16_1x
    I11 (net25 net24 net23 net22 AddrValid) or4_1x
ends Demux_3e1of4

// 16nm/nor3_1x/schematic
//system verilogNetlist schematic cmos.sch cmos_sch veriloga ahdl
subckt nor3_1x A B C Y
    M5 (Y C net21 vdd!) pfet w=300n l=20n nfin=1 m=1 degradation=yes
    M3 (net21 B net018 vdd!) pfet w=300n l=20n nfin=1 m=1 degradation=yes
    M2 (net018 A vdd! vdd!) pfet w=300n l=20n nfin=1 m=1 degradation=yes
    M6 (Y C 0 0) nfet w=60n l=20n nfin=1 m=1 degradation=no
    M1 (Y A 0 0) nfet w=60n l=20n nfin=1 m=1 degradation=no
    M0 (Y B 0 0) nfet w=60n l=20n nfin=1 m=1 degradation=no
ends nor3_1x

// 16nm/6T_DEMUX_/schematic
//system verilogNetlist schematic cmos.sch cmos_sch veriloga ahdl
subckt _sub86 _1of4_1_3 _1of4_1_2 _1of4_1_1 _1of4_1_0 _1of4_2_3 _1of4_2_2 _1of4_2_1 _1of4_2_0 _1of4_3_3 _1of4_3_2 _1of4_3_1 _1of4_3_0 _1of4_4_3 _1of4_4_2 _1of4_4_1 _1of4_4_0 A_63 A_62 A_61 A_60 A_59 A_58 A_57 A_56 A_55 A_54 A_53 A_52 A_51 A_50 A_49 A_48 A_47 A_46 A_45 A_44 A_43 A_42 A_41 A_40 A_39 A_38 A_37 A_36 A_35 A_34 A_33 A_32 A_31 A_30 A_29 A_28 A_27 A_26 A_25 A_24 A_23 A_22 A_21 A_20 A_19 A_18 A_17 A_16 A_15 A_14 A_13 A_12 A_11 A_10 A_9 A_8 A_7 A_6 A_5 A_4 A_3 A_2 A_1 A_0 En S_7 S_6 S_5 S_4 S_3 S_2 S_1 S_0 Ack
    I0 (_1of4_1_3 _1of4_1_2 _1of4_1_1 _1of4_1_0 _1of4_2_3 _1of4_2_2 _1of4_2_1 _1of4_2_0 _1of4_3_3 _1of4_3_2 _1of4_3_1 _1of4_3_0 A_63 A_62 A_61 A_60 A_59 A_58 A_57 A_56 A_55 A_54 A_53 A_52 A_51 A_50 A_49 A_48 A_47 A_46 A_45 A_44 A_43 A_42 A_41 A_40 A_39 A_38 A_37 A_36 A_35 A_34 A_33 A_32 A_31 A_30 A_29 A_28 A_27 A_26 A_25 A_24 A_23 A_22 A_21 A_20 A_19 A_18 A_17 A_16 A_15 A_14 A_13 A_12 A_11 A_10 A_9 A_8 A_7 A_6 A_5 A_4 A_3 A_2 A_1 A_0 En Ack) Demux_3e1of4
    I10_3 (_1of4_4_3 net020_0) inv_1x
    I10_2 (_1of4_4_2 net020_1) inv_1x
    I10_1 (_1of4_4_1 net020_2) inv_1x
    I10_0 (_1of4_4_0 net020_3) inv_1x
    I9 (En net015) inv_1x
    I6 (En net016) inv_1x
    I4 (_1of4_3_0 _1of4_3_1 net23) nor_1x
    I5 (_1of4_3_2 _1of4_3_3 net22) nor_1x
    I1_3 (net020_0 net23 net016 S_3) nor3_1x
    I1_2 (net020_1 net23 net016 S_2) nor3_1x
    I1_1 (net020_2 net23 net016 S_1) nor3_1x
    I1_0 (net020_3 net23 net016 S_0) nor3_1x
    I2_3 (net020_0 net22 net015 S_7) nor3_1x
    I2_2 (net020_1 net22 net015 S_6) nor3_1x
    I2_1 (net020_2 net22 net015 S_5) nor3_1x
    I2_0 (net020_3 net22 net015 S_4) nor3_1x
ends _sub86

// 16nm/6T_BANK/schematic
//system verilogNetlist schematic cmos.sch cmos_sch veriloga ahdl
subckt _sub87 A_19 A_18 A_17 A_16 A_15 A_14 A_13 A_12 A_11 A_10 A_9 A_8 A_7 A_6 A_5 A_4 A_3 A_2 A_1 A_0 Ack Ctrl_Ack_4 Ctrl_Ack_3 Ctrl_Ack_2 Ctrl_Ack_1 Ctrl_Ack_0 RD_8of32_31 RD_8of32_30 RD_8of32_29 RD_8of32_28 RD_8of32_27 RD_8of32_26 RD_8of32_25 RD_8of32_24 RD_8of32_23 RD_8of32_22 RD_8of32_21 RD_8of32_20 RD_8of32_19 RD_8of32_18 RD_8of32_17 RD_8of32_16 RD_8of32_15 RD_8of32_14 RD_8of32_13 RD_8of32_12 RD_8of32_11 RD_8of32_10 RD_8of32_9 RD_8of32_8 RD_8of32_7 RD_8of32_6 RD_8of32_5 RD_8of32_4 RD_8of32_3 RD_8of32_2 RD_8of32_1 RD_8of32_0 RD_Ack_7 RD_Ack_6 RD_Ack_5 RD_Ack_4 RD_Ack_3 RD_Ack_2 RD_Ack_1 RD_Ack_0 RW_1 RW_0 WD_8of32_31 WD_8of32_30 WD_8of32_29 WD_8of32_28 WD_8of32_27 WD_8of32_26 WD_8of32_25 WD_8of32_24 WD_8of32_23 WD_8of32_22 WD_8of32_21 WD_8of32_20 WD_8of32_19 WD_8of32_18 WD_8of32_17 WD_8of32_16 WD_8of32_15 WD_8of32_14 WD_8of32_13 WD_8of32_12 WD_8of32_11 WD_8of32_10 WD_8of32_9 WD_8of32_8 WD_8of32_7 WD_8of32_6 WD_8of32_5 WD_8of32_4 WD_8of32_3 WD_8of32_2 WD_8of32_1 WD_8of32_0 WD_Ack_7 WD_Ack_6 WD_Ack_5 WD_Ack_4 WD_Ack_3 WD_Ack_2 WD_Ack_1 WD_Ack_0
    I15 (net096_0 net096_1 net096_2 net096_3 net096_4 net096_5 net096_6 net096_7 net096_8 net096_9 net096_10 net096_11 net096_12 net096_13 net096_14 net096_15 net096_16 net096_17 net096_18 net096_19 net096_20 net096_21 net096_22 net096_23 net096_24 net096_25 net096_26 net096_27 net096_28 net096_29 net096_30 net096_31 net096_32 net096_33 net096_34 net096_35 net096_36 net096_37 net096_38 net096_39 net096_40 net096_41 net096_42 net096_43 net096_44 net096_45 net096_46 net096_47 net096_48 net096_49 net096_50 net096_51 net096_52 net096_53 net096_54 net096_55 net096_56 net096_57 net096_58 net096_59 net096_60 net096_61 net096_62 net096_63 B0_4_3 B0_4_2 B0_4_1 B0_4_0 B1_4_3 B1_4_2 B1_4_1 B1_4_0 G04 net068_0 net068_1 net068_2 net068_3 net068_4 net068_5 net068_6 net068_7 W0_4_3 W0_4_2 W0_4_1 W0_4_0 W1_4_3 W1_4_2 W1_4_1 W1_4_0 \~R0_4_3 \~R0_4_2 \~R0_4_1 \~R0_4_0 \~R1_4_3 \~R1_4_2 \~R1_4_1 \~R1_4_0) _sub81
    I14 (net0157_0 net0157_1 net0157_2 net0157_3 net0157_4 net0157_5 net0157_6 net0157_7 net0157_8 net0157_9 net0157_10 net0157_11 net0157_12 net0157_13 net0157_14 net0157_15 net0157_16 net0157_17 net0157_18 net0157_19 net0157_20 net0157_21 net0157_22 net0157_23 net0157_24 net0157_25 net0157_26 net0157_27 net0157_28 net0157_29 net0157_30 net0157_31 net0157_32 net0157_33 net0157_34 net0157_35 net0157_36 net0157_37 net0157_38 net0157_39 net0157_40 net0157_41 net0157_42 net0157_43 net0157_44 net0157_45 net0157_46 net0157_47 net0157_48 net0157_49 net0157_50 net0157_51 net0157_52 net0157_53 net0157_54 net0157_55 net0157_56 net0157_57 net0157_58 net0157_59 net0157_60 net0157_61 net0157_62 net0157_63 B0_4_3 B0_4_2 B0_4_1 B0_4_0 B1_4_3 B1_4_2 B1_4_1 B1_4_0 G04 net0131_0 net0131_1 net0131_2 net0131_3 net0131_4 net0131_5 net0131_6 net0131_7 W0_4_3 W0_4_2 W0_4_1 W0_4_0 W1_4_3 W1_4_2 W1_4_1 W1_4_0 \~R0_4_3 \~R0_4_2 \~R0_4_1 \~R0_4_0 \~R1_4_3 \~R1_4_2 \~R1_4_1 \~R1_4_0) _sub81
    I13 (net087_0 net087_1 net087_2 net087_3 net087_4 net087_5 net087_6 net087_7 net087_8 net087_9 net087_10 net087_11 net087_12 net087_13 net087_14 net087_15 net087_16 net087_17 net087_18 net087_19 net087_20 net087_21 net087_22 net087_23 net087_24 net087_25 net087_26 net087_27 net087_28 net087_29 net087_30 net087_31 net087_32 net087_33 net087_34 net087_35 net087_36 net087_37 net087_38 net087_39 net087_40 net087_41 net087_42 net087_43 net087_44 net087_45 net087_46 net087_47 net087_48 net087_49 net087_50 net087_51 net087_52 net087_53 net087_54 net087_55 net087_56 net087_57 net087_58 net087_59 net087_60 net087_61 net087_62 net087_63 B0_4_3 B0_4_2 B0_4_1 B0_4_0 B1_4_3 B1_4_2 B1_4_1 B1_4_0 G04 net059_0 net059_1 net059_2 net059_3 net059_4 net059_5 net059_6 net059_7 W0_4_3 W0_4_2 W0_4_1 W0_4_0 W1_4_3 W1_4_2 W1_4_1 W1_4_0 \~R0_4_3 \~R0_4_2 \~R0_4_1 \~R0_4_0 \~R1_4_3 \~R1_4_2 \~R1_4_1 \~R1_4_0) _sub81
    I12 (A_1_63 A_1_62 A_1_61 A_1_60 A_1_59 A_1_58 A_1_57 A_1_56 A_1_55 A_1_54 A_1_53 A_1_52 A_1_51 A_1_50 A_1_49 A_1_48 A_1_47 A_1_46 A_1_45 A_1_44 A_1_43 A_1_42 A_1_41 A_1_40 A_1_39 A_1_38 A_1_37 A_1_36 A_1_35 A_1_34 A_1_33 A_1_32 A_1_31 A_1_30 A_1_29 A_1_28 A_1_27 A_1_26 A_1_25 A_1_24 A_1_23 A_1_22 A_1_21 A_1_20 A_1_19 A_1_18 A_1_17 A_1_16 A_1_15 A_1_14 A_1_13 A_1_12 A_1_11 A_1_10 A_1_9 A_1_8 A_1_7 A_1_6 A_1_5 A_1_4 A_1_3 A_1_2 A_1_1 A_1_0 B0_4_3 B0_4_2 B0_4_1 B0_4_0 B1_4_3 B1_4_2 B1_4_1 B1_4_0 G04 S_1_7 S_1_6 S_1_5 S_1_4 S_1_3 S_1_2 S_1_1 S_1_0 W0_4_3 W0_4_2 W0_4_1 W0_4_0 W1_4_3 W1_4_2 W1_4_1 W1_4_0 \~R0_4_3 \~R0_4_2 \~R0_4_1 \~R0_4_0 \~R1_4_3 \~R1_4_2 \~R1_4_1 \~R1_4_0) _sub81
    I11 (net096_0 net096_1 net096_2 net096_3 net096_4 net096_5 net096_6 net096_7 net096_8 net096_9 net096_10 net096_11 net096_12 net096_13 net096_14 net096_15 net096_16 net096_17 net096_18 net096_19 net096_20 net096_21 net096_22 net096_23 net096_24 net096_25 net096_26 net096_27 net096_28 net096_29 net096_30 net096_31 net096_32 net096_33 net096_34 net096_35 net096_36 net096_37 net096_38 net096_39 net096_40 net096_41 net096_42 net096_43 net096_44 net096_45 net096_46 net096_47 net096_48 net096_49 net096_50 net096_51 net096_52 net096_53 net096_54 net096_55 net096_56 net096_57 net096_58 net096_59 net096_60 net096_61 net096_62 net096_63 B0_3_3 B0_3_2 B0_3_1 B0_3_0 B1_3_3 B1_3_2 B1_3_1 B1_3_0 G03 net068_0 net068_1 net068_2 net068_3 net068_4 net068_5 net068_6 net068_7 W0_3_3 W0_3_2 W0_3_1 W0_3_0 W1_3_3 W1_3_2 W1_3_1 W1_3_0 \~R0_3_3 \~R0_3_2 \~R0_3_1 \~R0_3_0 \~R1_3_3 \~R1_3_2 \~R1_3_1 \~R1_3_0) _sub81
    I10 (net0157_0 net0157_1 net0157_2 net0157_3 net0157_4 net0157_5 net0157_6 net0157_7 net0157_8 net0157_9 net0157_10 net0157_11 net0157_12 net0157_13 net0157_14 net0157_15 net0157_16 net0157_17 net0157_18 net0157_19 net0157_20 net0157_21 net0157_22 net0157_23 net0157_24 net0157_25 net0157_26 net0157_27 net0157_28 net0157_29 net0157_30 net0157_31 net0157_32 net0157_33 net0157_34 net0157_35 net0157_36 net0157_37 net0157_38 net0157_39 net0157_40 net0157_41 net0157_42 net0157_43 net0157_44 net0157_45 net0157_46 net0157_47 net0157_48 net0157_49 net0157_50 net0157_51 net0157_52 net0157_53 net0157_54 net0157_55 net0157_56 net0157_57 net0157_58 net0157_59 net0157_60 net0157_61 net0157_62 net0157_63 B0_3_3 B0_3_2 B0_3_1 B0_3_0 B1_3_3 B1_3_2 B1_3_1 B1_3_0 G03 net0131_0 net0131_1 net0131_2 net0131_3 net0131_4 net0131_5 net0131_6 net0131_7 W0_3_3 W0_3_2 W0_3_1 W0_3_0 W1_3_3 W1_3_2 W1_3_1 W1_3_0 \~R0_3_3 \~R0_3_2 \~R0_3_1 \~R0_3_0 \~R1_3_3 \~R1_3_2 \~R1_3_1 \~R1_3_0) _sub81
    I9 (net087_0 net087_1 net087_2 net087_3 net087_4 net087_5 net087_6 net087_7 net087_8 net087_9 net087_10 net087_11 net087_12 net087_13 net087_14 net087_15 net087_16 net087_17 net087_18 net087_19 net087_20 net087_21 net087_22 net087_23 net087_24 net087_25 net087_26 net087_27 net087_28 net087_29 net087_30 net087_31 net087_32 net087_33 net087_34 net087_35 net087_36 net087_37 net087_38 net087_39 net087_40 net087_41 net087_42 net087_43 net087_44 net087_45 net087_46 net087_47 net087_48 net087_49 net087_50 net087_51 net087_52 net087_53 net087_54 net087_55 net087_56 net087_57 net087_58 net087_59 net087_60 net087_61 net087_62 net087_63 B0_3_3 B0_3_2 B0_3_1 B0_3_0 B1_3_3 B1_3_2 B1_3_1 B1_3_0 G03 net059_0 net059_1 net059_2 net059_3 net059_4 net059_5 net059_6 net059_7 W0_3_3 W0_3_2 W0_3_1 W0_3_0 W1_3_3 W1_3_2 W1_3_1 W1_3_0 \~R0_3_3 \~R0_3_2 \~R0_3_1 \~R0_3_0 \~R1_3_3 \~R1_3_2 \~R1_3_1 \~R1_3_0) _sub81
    I8 (A_1_63 A_1_62 A_1_61 A_1_60 A_1_59 A_1_58 A_1_57 A_1_56 A_1_55 A_1_54 A_1_53 A_1_52 A_1_51 A_1_50 A_1_49 A_1_48 A_1_47 A_1_46 A_1_45 A_1_44 A_1_43 A_1_42 A_1_41 A_1_40 A_1_39 A_1_38 A_1_37 A_1_36 A_1_35 A_1_34 A_1_33 A_1_32 A_1_31 A_1_30 A_1_29 A_1_28 A_1_27 A_1_26 A_1_25 A_1_24 A_1_23 A_1_22 A_1_21 A_1_20 A_1_19 A_1_18 A_1_17 A_1_16 A_1_15 A_1_14 A_1_13 A_1_12 A_1_11 A_1_10 A_1_9 A_1_8 A_1_7 A_1_6 A_1_5 A_1_4 A_1_3 A_1_2 A_1_1 A_1_0 B0_3_3 B0_3_2 B0_3_1 B0_3_0 B1_3_3 B1_3_2 B1_3_1 B1_3_0 G03 S_1_7 S_1_6 S_1_5 S_1_4 S_1_3 S_1_2 S_1_1 S_1_0 W0_3_3 W0_3_2 W0_3_1 W0_3_0 W1_3_3 W1_3_2 W1_3_1 W1_3_0 \~R0_3_3 \~R0_3_2 \~R0_3_1 \~R0_3_0 \~R1_3_3 \~R1_3_2 \~R1_3_1 \~R1_3_0) _sub81
    I7 (net096_0 net096_1 net096_2 net096_3 net096_4 net096_5 net096_6 net096_7 net096_8 net096_9 net096_10 net096_11 net096_12 net096_13 net096_14 net096_15 net096_16 net096_17 net096_18 net096_19 net096_20 net096_21 net096_22 net096_23 net096_24 net096_25 net096_26 net096_27 net096_28 net096_29 net096_30 net096_31 net096_32 net096_33 net096_34 net096_35 net096_36 net096_37 net096_38 net096_39 net096_40 net096_41 net096_42 net096_43 net096_44 net096_45 net096_46 net096_47 net096_48 net096_49 net096_50 net096_51 net096_52 net096_53 net096_54 net096_55 net096_56 net096_57 net096_58 net096_59 net096_60 net096_61 net096_62 net096_63 B0_2_3 B0_2_2 B0_2_1 B0_2_0 B1_2_3 B1_2_2 B1_2_1 B1_2_0 G02 net068_0 net068_1 net068_2 net068_3 net068_4 net068_5 net068_6 net068_7 W0_2_3 W0_2_2 W0_2_1 W0_2_0 W1_2_3 W1_2_2 W1_2_1 W1_2_0 \~R0_2_3 \~R0_2_2 \~R0_2_1 \~R0_2_0 \~R1_2_3 \~R1_2_2 \~R1_2_1 \~R1_2_0) _sub81
    I6 (net0157_0 net0157_1 net0157_2 net0157_3 net0157_4 net0157_5 net0157_6 net0157_7 net0157_8 net0157_9 net0157_10 net0157_11 net0157_12 net0157_13 net0157_14 net0157_15 net0157_16 net0157_17 net0157_18 net0157_19 net0157_20 net0157_21 net0157_22 net0157_23 net0157_24 net0157_25 net0157_26 net0157_27 net0157_28 net0157_29 net0157_30 net0157_31 net0157_32 net0157_33 net0157_34 net0157_35 net0157_36 net0157_37 net0157_38 net0157_39 net0157_40 net0157_41 net0157_42 net0157_43 net0157_44 net0157_45 net0157_46 net0157_47 net0157_48 net0157_49 net0157_50 net0157_51 net0157_52 net0157_53 net0157_54 net0157_55 net0157_56 net0157_57 net0157_58 net0157_59 net0157_60 net0157_61 net0157_62 net0157_63 B0_2_3 B0_2_2 B0_2_1 B0_2_0 B1_2_3 B1_2_2 B1_2_1 B1_2_0 G02 net0131_0 net0131_1 net0131_2 net0131_3 net0131_4 net0131_5 net0131_6 net0131_7 W0_2_3 W0_2_2 W0_2_1 W0_2_0 W1_2_3 W1_2_2 W1_2_1 W1_2_0 \~R0_2_3 \~R0_2_2 \~R0_2_1 \~R0_2_0 \~R1_2_3 \~R1_2_2 \~R1_2_1 \~R1_2_0) _sub81
    I5 (net087_0 net087_1 net087_2 net087_3 net087_4 net087_5 net087_6 net087_7 net087_8 net087_9 net087_10 net087_11 net087_12 net087_13 net087_14 net087_15 net087_16 net087_17 net087_18 net087_19 net087_20 net087_21 net087_22 net087_23 net087_24 net087_25 net087_26 net087_27 net087_28 net087_29 net087_30 net087_31 net087_32 net087_33 net087_34 net087_35 net087_36 net087_37 net087_38 net087_39 net087_40 net087_41 net087_42 net087_43 net087_44 net087_45 net087_46 net087_47 net087_48 net087_49 net087_50 net087_51 net087_52 net087_53 net087_54 net087_55 net087_56 net087_57 net087_58 net087_59 net087_60 net087_61 net087_62 net087_63 B0_2_3 B0_2_2 B0_2_1 B0_2_0 B1_2_3 B1_2_2 B1_2_1 B1_2_0 G02 net059_0 net059_1 net059_2 net059_3 net059_4 net059_5 net059_6 net059_7 W0_2_3 W0_2_2 W0_2_1 W0_2_0 W1_2_3 W1_2_2 W1_2_1 W1_2_0 \~R0_2_3 \~R0_2_2 \~R0_2_1 \~R0_2_0 \~R1_2_3 \~R1_2_2 \~R1_2_1 \~R1_2_0) _sub81
    I4 (A_1_63 A_1_62 A_1_61 A_1_60 A_1_59 A_1_58 A_1_57 A_1_56 A_1_55 A_1_54 A_1_53 A_1_52 A_1_51 A_1_50 A_1_49 A_1_48 A_1_47 A_1_46 A_1_45 A_1_44 A_1_43 A_1_42 A_1_41 A_1_40 A_1_39 A_1_38 A_1_37 A_1_36 A_1_35 A_1_34 A_1_33 A_1_32 A_1_31 A_1_30 A_1_29 A_1_28 A_1_27 A_1_26 A_1_25 A_1_24 A_1_23 A_1_22 A_1_21 A_1_20 A_1_19 A_1_18 A_1_17 A_1_16 A_1_15 A_1_14 A_1_13 A_1_12 A_1_11 A_1_10 A_1_9 A_1_8 A_1_7 A_1_6 A_1_5 A_1_4 A_1_3 A_1_2 A_1_1 A_1_0 B0_2_3 B0_2_2 B0_2_1 B0_2_0 B1_2_3 B1_2_2 B1_2_1 B1_2_0 G02 S_1_7 S_1_6 S_1_5 S_1_4 S_1_3 S_1_2 S_1_1 S_1_0 W0_2_3 W0_2_2 W0_2_1 W0_2_0 W1_2_3 W1_2_2 W1_2_1 W1_2_0 \~R0_2_3 \~R0_2_2 \~R0_2_1 \~R0_2_0 \~R1_2_3 \~R1_2_2 \~R1_2_1 \~R1_2_0) _sub81
    I3 (net096_0 net096_1 net096_2 net096_3 net096_4 net096_5 net096_6 net096_7 net096_8 net096_9 net096_10 net096_11 net096_12 net096_13 net096_14 net096_15 net096_16 net096_17 net096_18 net096_19 net096_20 net096_21 net096_22 net096_23 net096_24 net096_25 net096_26 net096_27 net096_28 net096_29 net096_30 net096_31 net096_32 net096_33 net096_34 net096_35 net096_36 net096_37 net096_38 net096_39 net096_40 net096_41 net096_42 net096_43 net096_44 net096_45 net096_46 net096_47 net096_48 net096_49 net096_50 net096_51 net096_52 net096_53 net096_54 net096_55 net096_56 net096_57 net096_58 net096_59 net096_60 net096_61 net096_62 net096_63 B0_1_3 B0_1_2 B0_1_1 B0_1_0 B1_1_3 B1_1_2 B1_1_1 B1_1_0 G01 net068_0 net068_1 net068_2 net068_3 net068_4 net068_5 net068_6 net068_7 W0_1_3 W0_1_2 W0_1_1 W0_1_0 W1_1_3 W1_1_2 W1_1_1 W1_1_0 \~R0_1_3 \~R0_1_2 \~R0_1_1 \~R0_1_0 \~R1_1_3 \~R1_1_2 \~R1_1_1 \~R1_1_0) _sub81
    I2 (net0157_0 net0157_1 net0157_2 net0157_3 net0157_4 net0157_5 net0157_6 net0157_7 net0157_8 net0157_9 net0157_10 net0157_11 net0157_12 net0157_13 net0157_14 net0157_15 net0157_16 net0157_17 net0157_18 net0157_19 net0157_20 net0157_21 net0157_22 net0157_23 net0157_24 net0157_25 net0157_26 net0157_27 net0157_28 net0157_29 net0157_30 net0157_31 net0157_32 net0157_33 net0157_34 net0157_35 net0157_36 net0157_37 net0157_38 net0157_39 net0157_40 net0157_41 net0157_42 net0157_43 net0157_44 net0157_45 net0157_46 net0157_47 net0157_48 net0157_49 net0157_50 net0157_51 net0157_52 net0157_53 net0157_54 net0157_55 net0157_56 net0157_57 net0157_58 net0157_59 net0157_60 net0157_61 net0157_62 net0157_63 B0_1_3 B0_1_2 B0_1_1 B0_1_0 B1_1_3 B1_1_2 B1_1_1 B1_1_0 G01 net0131_0 net0131_1 net0131_2 net0131_3 net0131_4 net0131_5 net0131_6 net0131_7 W0_1_3 W0_1_2 W0_1_1 W0_1_0 W1_1_3 W1_1_2 W1_1_1 W1_1_0 \~R0_1_3 \~R0_1_2 \~R0_1_1 \~R0_1_0 \~R1_1_3 \~R1_1_2 \~R1_1_1 \~R1_1_0) _sub81
    I1 (net087_0 net087_1 net087_2 net087_3 net087_4 net087_5 net087_6 net087_7 net087_8 net087_9 net087_10 net087_11 net087_12 net087_13 net087_14 net087_15 net087_16 net087_17 net087_18 net087_19 net087_20 net087_21 net087_22 net087_23 net087_24 net087_25 net087_26 net087_27 net087_28 net087_29 net087_30 net087_31 net087_32 net087_33 net087_34 net087_35 net087_36 net087_37 net087_38 net087_39 net087_40 net087_41 net087_42 net087_43 net087_44 net087_45 net087_46 net087_47 net087_48 net087_49 net087_50 net087_51 net087_52 net087_53 net087_54 net087_55 net087_56 net087_57 net087_58 net087_59 net087_60 net087_61 net087_62 net087_63 B0_1_3 B0_1_2 B0_1_1 B0_1_0 B1_1_3 B1_1_2 B1_1_1 B1_1_0 G01 net059_0 net059_1 net059_2 net059_3 net059_4 net059_5 net059_6 net059_7 W0_1_3 W0_1_2 W0_1_1 W0_1_0 W1_1_3 W1_1_2 W1_1_1 W1_1_0 \~R0_1_3 \~R0_1_2 \~R0_1_1 \~R0_1_0 \~R1_1_3 \~R1_1_2 \~R1_1_1 \~R1_1_0) _sub81
    I0 (A_1_63 A_1_62 A_1_61 A_1_60 A_1_59 A_1_58 A_1_57 A_1_56 A_1_55 A_1_54 A_1_53 A_1_52 A_1_51 A_1_50 A_1_49 A_1_48 A_1_47 A_1_46 A_1_45 A_1_44 A_1_43 A_1_42 A_1_41 A_1_40 A_1_39 A_1_38 A_1_37 A_1_36 A_1_35 A_1_34 A_1_33 A_1_32 A_1_31 A_1_30 A_1_29 A_1_28 A_1_27 A_1_26 A_1_25 A_1_24 A_1_23 A_1_22 A_1_21 A_1_20 A_1_19 A_1_18 A_1_17 A_1_16 A_1_15 A_1_14 A_1_13 A_1_12 A_1_11 A_1_10 A_1_9 A_1_8 A_1_7 A_1_6 A_1_5 A_1_4 A_1_3 A_1_2 A_1_1 A_1_0 B0_1_3 B0_1_2 B0_1_1 B0_1_0 B1_1_3 B1_1_2 B1_1_1 B1_1_0 G01 S_1_7 S_1_6 S_1_5 S_1_4 S_1_3 S_1_2 S_1_1 S_1_0 W0_1_3 W0_1_2 W0_1_1 W0_1_0 W1_1_3 W1_1_2 W1_1_1 W1_1_0 \~R0_1_3 \~R0_1_2 \~R0_1_1 \~R0_1_0 \~R1_1_3 \~R1_1_2 \~R1_1_1 \~R1_1_0) _sub81
    I25 (net042 B0_4_3 B0_4_2 B0_4_1 B0_4_0 B1_4_3 B1_4_2 B1_4_1 B1_4_0 G04 RD_8of32_27 RD_8of32_26 RD_8of32_25 RD_8of32_24 RD_8of32_31 RD_8of32_30 RD_8of32_29 RD_8of32_28 RW_1 RW_0 Reset ValAddr W0_4_3 W0_4_2 W0_4_1 W0_4_0 W1_4_3 W1_4_2 W1_4_1 W1_4_0 WD_8of32_27 WD_8of32_26 WD_8of32_25 WD_8of32_24 WD_8of32_31 WD_8of32_30 WD_8of32_29 WD_8of32_28 0 net0170 RD_Ack_7 RD_Ack_6 WD_Ack_7 WD_Ack_6 \~R0_4_3 \~R0_4_2 \~R0_4_1 \~R0_4_0 \~R1_4_3 \~R1_4_2 \~R1_4_1 \~R1_4_0) _sub84
    I22 (ck_2 B0_3_3 B0_3_2 B0_3_1 B0_3_0 B1_3_3 B1_3_2 B1_3_1 B1_3_0 G03 RD_8of32_19 RD_8of32_18 RD_8of32_17 RD_8of32_16 RD_8of32_23 RD_8of32_22 RD_8of32_21 RD_8of32_20 RW_1 RW_0 Reset ValAddr W0_3_3 W0_3_2 W0_3_1 W0_3_0 W1_3_3 W1_3_2 W1_3_1 W1_3_0 WD_8of32_19 WD_8of32_18 WD_8of32_17 WD_8of32_16 WD_8of32_23 WD_8of32_22 WD_8of32_21 WD_8of32_20 net042 ck_3 RD_Ack_5 RD_Ack_4 WD_Ack_5 WD_Ack_4 \~R0_3_3 \~R0_3_2 \~R0_3_1 \~R0_3_0 \~R1_3_3 \~R1_3_2 \~R1_3_1 \~R1_3_0) _sub84
    I21 (ck_0 B0_2_3 B0_2_2 B0_2_1 B0_2_0 B1_2_3 B1_2_2 B1_2_1 B1_2_0 G02 RD_8of32_11 RD_8of32_10 RD_8of32_9 RD_8of32_8 RD_8of32_15 RD_8of32_14 RD_8of32_13 RD_8of32_12 RW_1 RW_0 Reset ValAddr W0_2_3 W0_2_2 W0_2_1 W0_2_0 W1_2_3 W1_2_2 W1_2_1 W1_2_0 WD_8of32_11 WD_8of32_10 WD_8of32_9 WD_8of32_8 WD_8of32_15 WD_8of32_14 WD_8of32_13 WD_8of32_12 ck_1 net027 RD_Ack_3 RD_Ack_2 WD_Ack_3 WD_Ack_2 \~R0_2_3 \~R0_2_2 \~R0_2_1 \~R0_2_0 \~R1_2_3 \~R1_2_2 \~R1_2_1 \~R1_2_0) _sub84
    I20 (net027 B0_1_3 B0_1_2 B0_1_1 B0_1_0 B1_1_3 B1_1_2 B1_1_1 B1_1_0 G01 RD_8of32_3 RD_8of32_2 RD_8of32_1 RD_8of32_0 RD_8of32_7 RD_8of32_6 RD_8of32_5 RD_8of32_4 RW_1 RW_0 Reset ValAddr W0_1_3 W0_1_2 W0_1_1 W0_1_0 W1_1_3 W1_1_2 W1_1_1 W1_1_0 WD_8of32_3 WD_8of32_2 WD_8of32_1 WD_8of32_0 WD_8of32_7 WD_8of32_6 WD_8of32_5 WD_8of32_4 net0173 0 RD_Ack_1 RD_Ack_0 WD_Ack_1 WD_Ack_0 \~R0_1_3 \~R0_1_2 \~R0_1_1 \~R0_1_0 \~R1_1_3 \~R1_1_2 \~R1_1_1 \~R1_1_0) _sub84
    I24 (A_3 A_2 A_1 A_0 A_7 A_6 A_5 A_4 A_11 A_10 A_9 A_8 A_15 A_14 A_13 A_12 A_19 A_18 A_17 A_16 AvAck_3 AvAck_2 AvAck_1 AvAck_0 ck_1 ck_0 ck_3 ck_2 net09 RW_1 RW_0 Reset ValAddr) _sub85
    I30 (net09 Ack) inv_1x
    I29_4 (net09 Ctrl_Ack_4) inv_1x
    I29_3 (net09 Ctrl_Ack_3) inv_1x
    I29_2 (net09 Ctrl_Ack_2) inv_1x
    I29_1 (net09 Ctrl_Ack_1) inv_1x
    I29_0 (net09 Ctrl_Ack_0) inv_1x
    I19 (A_3 A_2 A_1 A_0 A_7 A_6 A_5 A_4 A_11 A_10 A_9 A_8 A_15 A_14 A_13 A_12 net096_0 net096_1 net096_2 net096_3 net096_4 net096_5 net096_6 net096_7 net096_8 net096_9 net096_10 net096_11 net096_12 net096_13 net096_14 net096_15 net096_16 net096_17 net096_18 net096_19 net096_20 net096_21 net096_22 net096_23 net096_24 net096_25 net096_26 net096_27 net096_28 net096_29 net096_30 net096_31 net096_32 net096_33 net096_34 net096_35 net096_36 net096_37 net096_38 net096_39 net096_40 net096_41 net096_42 net096_43 net096_44 net096_45 net096_46 net096_47 net096_48 net096_49 net096_50 net096_51 net096_52 net096_53 net096_54 net096_55 net096_56 net096_57 net096_58 net096_59 net096_60 net096_61 net096_62 net096_63 A_19 net068_0 net068_1 net068_2 net068_3 net068_4 net068_5 net068_6 net068_7 AvAck_3) _sub86
    I18 (A_3 A_2 A_1 A_0 A_7 A_6 A_5 A_4 A_11 A_10 A_9 A_8 A_15 A_14 A_13 A_12 net0157_0 net0157_1 net0157_2 net0157_3 net0157_4 net0157_5 net0157_6 net0157_7 net0157_8 net0157_9 net0157_10 net0157_11 net0157_12 net0157_13 net0157_14 net0157_15 net0157_16 net0157_17 net0157_18 net0157_19 net0157_20 net0157_21 net0157_22 net0157_23 net0157_24 net0157_25 net0157_26 net0157_27 net0157_28 net0157_29 net0157_30 net0157_31 net0157_32 net0157_33 net0157_34 net0157_35 net0157_36 net0157_37 net0157_38 net0157_39 net0157_40 net0157_41 net0157_42 net0157_43 net0157_44 net0157_45 net0157_46 net0157_47 net0157_48 net0157_49 net0157_50 net0157_51 net0157_52 net0157_53 net0157_54 net0157_55 net0157_56 net0157_57 net0157_58 net0157_59 net0157_60 net0157_61 net0157_62 net0157_63 A_18 net0131_0 net0131_1 net0131_2 net0131_3 net0131_4 net0131_5 net0131_6 net0131_7 AvAck_2) _sub86
    I17 (A_3 A_2 A_1 A_0 A_7 A_6 A_5 A_4 A_11 A_10 A_9 A_8 A_15 A_14 A_13 A_12 net087_0 net087_1 net087_2 net087_3 net087_4 net087_5 net087_6 net087_7 net087_8 net087_9 net087_10 net087_11 net087_12 net087_13 net087_14 net087_15 net087_16 net087_17 net087_18 net087_19 net087_20 net087_21 net087_22 net087_23 net087_24 net087_25 net087_26 net087_27 net087_28 net087_29 net087_30 net087_31 net087_32 net087_33 net087_34 net087_35 net087_36 net087_37 net087_38 net087_39 net087_40 net087_41 net087_42 net087_43 net087_44 net087_45 net087_46 net087_47 net087_48 net087_49 net087_50 net087_51 net087_52 net087_53 net087_54 net087_55 net087_56 net087_57 net087_58 net087_59 net087_60 net087_61 net087_62 net087_63 A_17 net059_0 net059_1 net059_2 net059_3 net059_4 net059_5 net059_6 net059_7 AvAck_1) _sub86
    I16 (A_3 A_2 A_1 A_0 A_7 A_6 A_5 A_4 A_11 A_10 A_9 A_8 A_15 A_14 A_13 A_12 A_1_63 A_1_62 A_1_61 A_1_60 A_1_59 A_1_58 A_1_57 A_1_56 A_1_55 A_1_54 A_1_53 A_1_52 A_1_51 A_1_50 A_1_49 A_1_48 A_1_47 A_1_46 A_1_45 A_1_44 A_1_43 A_1_42 A_1_41 A_1_40 A_1_39 A_1_38 A_1_37 A_1_36 A_1_35 A_1_34 A_1_33 A_1_32 A_1_31 A_1_30 A_1_29 A_1_28 A_1_27 A_1_26 A_1_25 A_1_24 A_1_23 A_1_22 A_1_21 A_1_20 A_1_19 A_1_18 A_1_17 A_1_16 A_1_15 A_1_14 A_1_13 A_1_12 A_1_11 A_1_10 A_1_9 A_1_8 A_1_7 A_1_6 A_1_5 A_1_4 A_1_3 A_1_2 A_1_1 A_1_0 A_16 S_1_7 S_1_6 S_1_5 S_1_4 S_1_3 S_1_2 S_1_1 S_1_0 AvAck_0) _sub86
ends _sub87

// 16nm/TH33~/schematic
//system verilogNetlist schematic cmos.sch cmos_sch veriloga ahdl
subckt _sub88 A B C Y
    M19 (net13 A 0 0) nfet w=80n l=16n nfin=1 m=1 degradation=no
    M18 (net13 B 0 0) nfet w=80n l=16n nfin=1 m=1 degradation=no
    M17 (net13 C 0 0) nfet w=80n l=16n nfin=1 m=1 degradation=no
    M15 (net09 net44 0 0) nfet w=40n l=16n nfin=1 m=1 degradation=no
    M14 (net42 A 0 0) nfet w=120n l=16n nfin=1 m=1 degradation=no
    M13 (net43 B net42 0) nfet w=120n l=16n nfin=1 m=1 degradation=no
    M12 (net44 C net43 0) nfet w=120n l=16n nfin=1 m=1 degradation=no
    M10 (net44 net09 net13 0) nfet w=80n l=16n nfin=1 m=1 degradation=no
    I6 (net09 Y) inv_1x
    M9 (net09 net44 vdd! vdd!) pfet w=80n l=16n nfin=1 m=1 degradation=yes
    M8 (net44 net09 net15 vdd!) pfet w=160n l=16n nfin=1 m=1 degradation=yes
    M6 (net15 C vdd! vdd!) pfet w=160n l=16n nfin=1 m=1 degradation=yes
    M5 (net15 B vdd! vdd!) pfet w=160n l=16n nfin=1 m=1 degradation=yes
    M4 (net15 A vdd! vdd!) pfet w=160n l=16n nfin=1 m=1 degradation=yes
    M2 (net44 C net46 vdd!) pfet w=240n l=16n nfin=1 m=1 degradation=yes
    M1 (net46 B net47 vdd!) pfet w=240n l=16n nfin=1 m=1 degradation=yes
    M0 (net47 A vdd! vdd!) pfet w=240n l=16n nfin=1 m=1 degradation=yes
ends _sub88

// 16nm/6T_1of4Merge/schematic
//system verilogNetlist schematic cmos.sch cmos_sch veriloga ahdl
subckt _sub89 a_3 a_2 a_1 a_0 a_ack ack asel b_3 b_2 b_1 b_0 b_ack bsel out_3 out_2 out_1 out_0
    I4 (b_3 bsel net24 bmid_3) _sub88
    I0 (a_0 asel net21 amid_0) _sub88
    I1 (a_1 asel net22 amid_1) _sub88
    I2 (a_2 asel net23 amid_2) _sub88
    I3 (a_3 asel net24 amid_3) _sub88
    I7 (b_0 bsel net21 bmid_0) _sub88
    I6 (b_1 bsel net22 bmid_1) _sub88
    I5 (b_2 bsel net23 bmid_2) _sub88
    I11 (Vpass_0 ack out_0) TH22
    I10 (Vpass_1 ack out_1) TH22
    I9 (Vpass_2 ack out_2) TH22
    I8 (Vpass_3 ack out_3) TH22
    I17 (amid_3 bmid_3 Vpass_3) nand_1x
    I16 (amid_2 bmid_2 Vpass_2) nand_1x
    I15 (amid_1 bmid_1 Vpass_1) nand_1x
    I14 (amid_0 bmid_0 Vpass_0) nand_1x
    I21 (out_0 net21) inv_1x
    I20 (out_1 net22) inv_1x
    I19 (out_2 net23) inv_1x
    I18 (out_3 net24) inv_1x
    I13 (bmid_0 bmid_1 bmid_2 bmid_3 b_ack) nand4_1x
    I12 (amid_0 amid_1 amid_2 amid_3 a_ack) nand4_1x
ends _sub89

// 16nm/6T_4of16Merge/schematic
//system verilogNetlist schematic cmos.sch cmos_sch veriloga ahdl
subckt _sub90 A1_1of4_3 A1_1of4_2 A1_1of4_1 A1_1of4_0 A2_1of4_3 A2_1of4_2 A2_1of4_1 A2_1of4_0 A3_1of4_3 A3_1of4_2 A3_1of4_1 A3_1of4_0 A4_1of4_3 A4_1of4_2 A4_1of4_1 A4_1of4_0 A_Ack_3 A_Ack_2 A_Ack_1 A_Ack_0 Asel B1_1of4_3 B1_1of4_2 B1_1of4_1 B1_1of4_0 B2_1of4_3 B2_1of4_2 B2_1of4_1 B2_1of4_0 B3_1of4_3 B3_1of4_2 B3_1of4_1 B3_1of4_0 B4_1of4_3 B4_1of4_2 B4_1of4_1 B4_1of4_0 B_Ack_3 B_Ack_2 B_Ack_1 B_Ack_0 Bsel C1_1of4_3 C1_1of4_2 C1_1of4_1 C1_1of4_0 C2_1of4_3 C2_1of4_2 C2_1of4_1 C2_1of4_0 C3_1of4_3 C3_1of4_2 C3_1of4_1 C3_1of4_0 C4_1of4_3 C4_1of4_2 C4_1of4_1 C4_1of4_0 C_Ack_3 C_Ack_2 C_Ack_1 C_Ack_0
    I25 (A4_1of4_3 A4_1of4_2 A4_1of4_1 A4_1of4_0 A_Ack_3 C_Ack_3 Asel B4_1of4_3 B4_1of4_2 B4_1of4_1 B4_1of4_0 B_Ack_3 Bsel C4_1of4_3 C4_1of4_2 C4_1of4_1 C4_1of4_0) _sub89
    I24 (A3_1of4_3 A3_1of4_2 A3_1of4_1 A3_1of4_0 A_Ack_2 C_Ack_2 Asel B3_1of4_3 B3_1of4_2 B3_1of4_1 B3_1of4_0 B_Ack_2 Bsel C3_1of4_3 C3_1of4_2 C3_1of4_1 C3_1of4_0) _sub89
    I23 (A2_1of4_3 A2_1of4_2 A2_1of4_1 A2_1of4_0 A_Ack_1 C_Ack_1 Asel B2_1of4_3 B2_1of4_2 B2_1of4_1 B2_1of4_0 B_Ack_1 Bsel C2_1of4_3 C2_1of4_2 C2_1of4_1 C2_1of4_0) _sub89
    I22 (A1_1of4_3 A1_1of4_2 A1_1of4_1 A1_1of4_0 A_Ack_0 C_Ack_0 Asel B1_1of4_3 B1_1of4_2 B1_1of4_1 B1_1of4_0 B_Ack_0 Bsel C1_1of4_3 C1_1of4_2 C1_1of4_1 C1_1of4_0) _sub89
ends _sub90

// 16nm/6T_1of2Merge/schematic
//system verilogNetlist schematic cmos.sch cmos_sch veriloga ahdl
subckt _sub91 a_1 a_0 a_ack ack asel b_1 b_0 b_ack bsel out_1 out_0
    I15 (net28 net29 net41) nand_1x
    I14 (net26 net31 net42) nand_1x
    I13 (net31 net29 b_ack) nand_1x
    I12 (net26 net28 a_ack) nand_1x
    I11 (net42 ack out_0) TH22
    I10 (net41 ack out_1) TH22
    I7 (b_0 bsel net21 net31) _sub88
    I6 (b_1 bsel net22 net29) _sub88
    I1 (a_1 asel net22 net28) _sub88
    I0 (a_0 asel net21 net26) _sub88
    I21 (out_0 net21) inv_1x
    I20 (out_1 net22) inv_1x
ends _sub91

// 16nm/6T_AddressMerge/schematic
//system verilogNetlist schematic cmos.sch cmos_sch veriloga ahdl
subckt _sub92 Ack_4 Ack_3 Ack_2 Ack_1 Ack_0 Addr_19 Addr_18 Addr_17 Addr_16 Addr_15 Addr_14 Addr_13 Addr_12 Addr_11 Addr_10 Addr_9 Addr_8 Addr_7 Addr_6 Addr_5 Addr_4 Addr_3 Addr_2 Addr_1 Addr_0 RAddr_Ack_4 RAddr_Ack_3 RAddr_Ack_2 RAddr_Ack_1 RAddr_Ack_0 RW_1 RW_0 RW_Ack R_Addr_19 R_Addr_18 R_Addr_17 R_Addr_16 R_Addr_15 R_Addr_14 R_Addr_13 R_Addr_12 R_Addr_11 R_Addr_10 R_Addr_9 R_Addr_8 R_Addr_7 R_Addr_6 R_Addr_5 R_Addr_4 R_Addr_3 R_Addr_2 R_Addr_1 R_Addr_0 Read_1 Read_0 Read_Ack WAddr_Ack_4 WAddr_Ack_3 WAddr_Ack_2 WAddr_Ack_1 WAddr_Ack_0 W_Addr_19 W_Addr_18 W_Addr_17 W_Addr_16 W_Addr_15 W_Addr_14 W_Addr_13 W_Addr_12 W_Addr_11 W_Addr_10 W_Addr_9 W_Addr_8 W_Addr_7 W_Addr_6 W_Addr_5 W_Addr_4 W_Addr_3 W_Addr_2 W_Addr_1 W_Addr_0 Write_1 Write_0 Write_Ack
    I0 (W_Addr_3 W_Addr_2 W_Addr_1 W_Addr_0 W_Addr_7 W_Addr_6 W_Addr_5 W_Addr_4 W_Addr_11 W_Addr_10 W_Addr_9 W_Addr_8 W_Addr_15 W_Addr_14 W_Addr_13 W_Addr_12 WAddr_Ack_3 WAddr_Ack_2 WAddr_Ack_1 WAddr_Ack_0 Write_0 R_Addr_3 R_Addr_2 R_Addr_1 R_Addr_0 R_Addr_7 R_Addr_6 R_Addr_5 R_Addr_4 R_Addr_11 R_Addr_10 R_Addr_9 R_Addr_8 R_Addr_15 R_Addr_14 R_Addr_13 R_Addr_12 RAddr_Ack_3 RAddr_Ack_2 RAddr_Ack_1 RAddr_Ack_0 Read_1 Addr_3 Addr_2 Addr_1 Addr_0 Addr_7 Addr_6 Addr_5 Addr_4 Addr_11 Addr_10 Addr_9 Addr_8 Addr_15 Addr_14 Addr_13 Addr_12 Ack_3 Ack_2 Ack_1 Ack_0) _sub90
    I1 (W_Addr_19 W_Addr_18 W_Addr_17 W_Addr_16 WAddr_Ack_4 Ack_4 Write_0 R_Addr_19 R_Addr_18 R_Addr_17 R_Addr_16 RAddr_Ack_4 Read_1 Addr_19 Addr_18 Addr_17 Addr_16) _sub89
    I3 (Write_1 Write_0 Write_Ack RW_Ack Write_0 Read_1 Read_0 Read_Ack Read_1 RW_1 RW_0) _sub91
ends _sub92

// 16nm/6T_SDP_BANK/schematic
//system verilogNetlist schematic cmos.sch cmos_sch veriloga ahdl
subckt _sub93 RAddr_Ack_4 RAddr_Ack_3 RAddr_Ack_2 RAddr_Ack_1 RAddr_Ack_0 Read_1 Read_0 ReadAck_7 ReadAck_6 ReadAck_5 ReadAck_4 ReadAck_3 ReadAck_2 ReadAck_1 ReadAck_0 ReadData_31 ReadData_30 ReadData_29 ReadData_28 ReadData_27 ReadData_26 ReadData_25 ReadData_24 ReadData_23 ReadData_22 ReadData_21 ReadData_20 ReadData_19 ReadData_18 ReadData_17 ReadData_16 ReadData_15 ReadData_14 ReadData_13 ReadData_12 ReadData_11 ReadData_10 ReadData_9 ReadData_8 ReadData_7 ReadData_6 ReadData_5 ReadData_4 ReadData_3 ReadData_2 ReadData_1 ReadData_0 Read_Ack Read_Address_19 Read_Address_18 Read_Address_17 Read_Address_16 Read_Address_15 Read_Address_14 Read_Address_13 Read_Address_12 Read_Address_11 Read_Address_10 Read_Address_9 Read_Address_8 Read_Address_7 Read_Address_6 Read_Address_5 Read_Address_4 Read_Address_3 Read_Address_2 Read_Address_1 Read_Address_0 WAddr_Ack_4 WAddr_Ack_3 WAddr_Ack_2 WAddr_Ack_1 WAddr_Ack_0 Write_1 Write_0 WriteAck_7 WriteAck_6 WriteAck_5 WriteAck_4 WriteAck_3 WriteAck_2 WriteAck_1 WriteAck_0 WriteData_31 WriteData_30 WriteData_29 WriteData_28 WriteData_27 WriteData_26 WriteData_25 WriteData_24 WriteData_23 WriteData_22 WriteData_21 WriteData_20 WriteData_19 WriteData_18 WriteData_17 WriteData_16 WriteData_15 WriteData_14 WriteData_13 WriteData_12 WriteData_11 WriteData_10 WriteData_9 WriteData_8 WriteData_7 WriteData_6 WriteData_5 WriteData_4 WriteData_3 WriteData_2 WriteData_1 WriteData_0 Write_Ack Write_Address_19 Write_Address_18 Write_Address_17 Write_Address_16 Write_Address_15 Write_Address_14 Write_Address_13 Write_Address_12 Write_Address_11 Write_Address_10 Write_Address_9 Write_Address_8 Write_Address_7 Write_Address_6 Write_Address_5 Write_Address_4 Write_Address_3 Write_Address_2 Write_Address_1 Write_Address_0
    I0 (Ap_19 Ap_18 Ap_17 Ap_16 Ap_15 Ap_14 Ap_13 Ap_12 Ap_11 Ap_10 Ap_9 Ap_8 Ap_7 Ap_6 Ap_5 Ap_4 Ap_3 Ap_2 Ap_1 Ap_0 WAck WAckp_4 WAckp_3 WAckp_2 WAckp_1 WAckp_0 ReadData_31 ReadData_30 ReadData_29 ReadData_28 ReadData_27 ReadData_26 ReadData_25 ReadData_24 ReadData_23 ReadData_22 ReadData_21 ReadData_20 ReadData_19 ReadData_18 ReadData_17 ReadData_16 ReadData_15 ReadData_14 ReadData_13 ReadData_12 ReadData_11 ReadData_10 ReadData_9 ReadData_8 ReadData_7 ReadData_6 ReadData_5 ReadData_4 ReadData_3 ReadData_2 ReadData_1 ReadData_0 ReadAck_7 ReadAck_6 ReadAck_5 ReadAck_4 ReadAck_3 ReadAck_2 ReadAck_1 ReadAck_0 WRWp_1 WRWp_0 WriteData_31 WriteData_30 WriteData_29 WriteData_28 WriteData_27 WriteData_26 WriteData_25 WriteData_24 WriteData_23 WriteData_22 WriteData_21 WriteData_20 WriteData_19 WriteData_18 WriteData_17 WriteData_16 WriteData_15 WriteData_14 WriteData_13 WriteData_12 WriteData_11 WriteData_10 WriteData_9 WriteData_8 WriteData_7 WriteData_6 WriteData_5 WriteData_4 WriteData_3 WriteData_2 WriteData_1 WriteData_0 WriteAck_7 WriteAck_6 WriteAck_5 WriteAck_4 WriteAck_3 WriteAck_2 WriteAck_1 WriteAck_0) _sub87
    I1 (WAckp_4 WAckp_3 WAckp_2 WAckp_1 WAckp_0 Ap_19 Ap_18 Ap_17 Ap_16 Ap_15 Ap_14 Ap_13 Ap_12 Ap_11 Ap_10 Ap_9 Ap_8 Ap_7 Ap_6 Ap_5 Ap_4 Ap_3 Ap_2 Ap_1 Ap_0 RAddr_Ack_4 RAddr_Ack_3 RAddr_Ack_2 RAddr_Ack_1 RAddr_Ack_0 WRWp_1 WRWp_0 WAck Read_Address_19 Read_Address_18 Read_Address_17 Read_Address_16 Read_Address_15 Read_Address_14 Read_Address_13 Read_Address_12 Read_Address_11 Read_Address_10 Read_Address_9 Read_Address_8 Read_Address_7 Read_Address_6 Read_Address_5 Read_Address_4 Read_Address_3 Read_Address_2 Read_Address_1 Read_Address_0 Read_1 Read_0 Read_Ack WAddr_Ack_4 WAddr_Ack_3 WAddr_Ack_2 WAddr_Ack_1 WAddr_Ack_0 Write_Address_19 Write_Address_18 Write_Address_17 Write_Address_16 Write_Address_15 Write_Address_14 Write_Address_13 Write_Address_12 Write_Address_11 Write_Address_10 Write_Address_9 Write_Address_8 Write_Address_7 Write_Address_6 Write_Address_5 Write_Address_4 Write_Address_3 Write_Address_2 Write_Address_1 Write_Address_0 Write_1 Write_0 Write_Ack) _sub92
ends _sub93

// 16nm/inv_1xt/schematic
//system verilogNetlist schematic cmos.sch cmos_sch veriloga ahdl
subckt inv_1xt A Y
    M0 (Y A 0 0) nfet w=60n l=20n nfin=1 m=1 degradation=no
    M1 (Y A vcc! vcc!) pfet w=100n l=20n nfin=1 m=1 degradation=no
ends inv_1xt

// 16nm_Tests/6T_SDP_BANK_Test/schematic
// system verilogNetlist schematic cmos.sch cmos_sch veriloga ahdl
V1 (vdd! 0) vsource type=dc dc=vdd
V0 (vcc! 0) vsource type=dc dc=vcc
IBank (RA_AckT_4 RA_AckT_3 RA_AckT_2 RA_AckT_1 RA_AckT_0 RRWT_1 RRWT_0 RD_AckT_7 RD_AckT_6 RD_AckT_5 RD_AckT_4 RD_AckT_3 RD_AckT_2 RD_AckT_1 RD_AckT_0 ReadDataT_31 ReadDataT_30 ReadDataT_29 ReadDataT_28 ReadDataT_27 ReadDataT_26 ReadDataT_25 ReadDataT_24 ReadDataT_23 ReadDataT_22 ReadDataT_21 ReadDataT_20 ReadDataT_19 ReadDataT_18 ReadDataT_17 ReadDataT_16 ReadDataT_15 ReadDataT_14 ReadDataT_13 ReadDataT_12 ReadDataT_11 ReadDataT_10 ReadDataT_9 ReadDataT_8 ReadDataT_7 ReadDataT_6 ReadDataT_5 ReadDataT_4 ReadDataT_3 ReadDataT_2 ReadDataT_1 ReadDataT_0 ReadAckT R_AddressT_19 R_AddressT_18 R_AddressT_17 R_AddressT_16 R_AddressT_15 R_AddressT_14 R_AddressT_13 R_AddressT_12 R_AddressT_11 R_AddressT_10 R_AddressT_9 R_AddressT_8 R_AddressT_7 R_AddressT_6 R_AddressT_5 R_AddressT_4 R_AddressT_3 R_AddressT_2 R_AddressT_1 R_AddressT_0 WA_AckT_4 WA_AckT_3 WA_AckT_2 WA_AckT_1 WA_AckT_0 WRWT_1 WRWT_0 WD_AckT_7 WD_AckT_6 WD_AckT_5 WD_AckT_4 WD_AckT_3 WD_AckT_2 WD_AckT_1 WD_AckT_0 WriteDataT_31 WriteDataT_30 WriteDataT_29 WriteDataT_28 WriteDataT_27 WriteDataT_26 WriteDataT_25 WriteDataT_24 WriteDataT_23 WriteDataT_22 WriteDataT_21 WriteDataT_20 WriteDataT_19 WriteDataT_18 WriteDataT_17 WriteDataT_16 WriteDataT_15 WriteDataT_14 WriteDataT_13 WriteDataT_12 WriteDataT_11 WriteDataT_10 WriteDataT_9 WriteDataT_8 WriteDataT_7 WriteDataT_6 WriteDataT_5 WriteDataT_4 WriteDataT_3 WriteDataT_2 WriteDataT_1 WriteDataT_0 WriteAckT W_AddressT_19 W_AddressT_18 W_AddressT_17 W_AddressT_16 W_AddressT_15 W_AddressT_14 W_AddressT_13 W_AddressT_12 W_AddressT_11 W_AddressT_10 W_AddressT_9 W_AddressT_8 W_AddressT_7 W_AddressT_6 W_AddressT_5 W_AddressT_4 W_AddressT_3 W_AddressT_2 W_AddressT_1 W_AddressT_0) _sub93
I20_19 (\~R_Address_19 R_AddressT_19) inv_1xt
I20_18 (\~R_Address_18 R_AddressT_18) inv_1xt
I20_17 (\~R_Address_17 R_AddressT_17) inv_1xt
I20_16 (\~R_Address_16 R_AddressT_16) inv_1xt
I20_15 (\~R_Address_15 R_AddressT_15) inv_1xt
I20_14 (\~R_Address_14 R_AddressT_14) inv_1xt
I20_13 (\~R_Address_13 R_AddressT_13) inv_1xt
I20_12 (\~R_Address_12 R_AddressT_12) inv_1xt
I20_11 (\~R_Address_11 R_AddressT_11) inv_1xt
I20_10 (\~R_Address_10 R_AddressT_10) inv_1xt
I20_9 (\~R_Address_9 R_AddressT_9) inv_1xt
I20_8 (\~R_Address_8 R_AddressT_8) inv_1xt
I20_7 (\~R_Address_7 R_AddressT_7) inv_1xt
I20_6 (\~R_Address_6 R_AddressT_6) inv_1xt
I20_5 (\~R_Address_5 R_AddressT_5) inv_1xt
I20_4 (\~R_Address_4 R_AddressT_4) inv_1xt
I20_3 (\~R_Address_3 R_AddressT_3) inv_1xt
I20_2 (\~R_Address_2 R_AddressT_2) inv_1xt
I20_1 (\~R_Address_1 R_AddressT_1) inv_1xt
I20_0 (\~R_Address_0 R_AddressT_0) inv_1xt
I19_1 (\~RRW_1 RRWT_1) inv_1xt
I19_0 (\~RRW_0 RRWT_0) inv_1xt
I16_4 (RA_AckT_4 \~RA_Ack_4) inv_1xt
I16_3 (RA_AckT_3 \~RA_Ack_3) inv_1xt
I16_2 (RA_AckT_2 \~RA_Ack_2) inv_1xt
I16_1 (RA_AckT_1 \~RA_Ack_1) inv_1xt
I16_0 (RA_AckT_0 \~RA_Ack_0) inv_1xt
I15 (ReadAckT \~ReadAck) inv_1xt
I13_4 (WA_AckT_4 \~WA_Ack_4) inv_1xt
I13_3 (WA_AckT_3 \~WA_Ack_3) inv_1xt
I13_2 (WA_AckT_2 \~WA_Ack_2) inv_1xt
I13_1 (WA_AckT_1 \~WA_Ack_1) inv_1xt
I13_0 (WA_AckT_0 \~WA_Ack_0) inv_1xt
I11_7 (\~RD_Ack_7 RD_AckT_7) inv_1xt
I11_6 (\~RD_Ack_6 RD_AckT_6) inv_1xt
I11_5 (\~RD_Ack_5 RD_AckT_5) inv_1xt
I11_4 (\~RD_Ack_4 RD_AckT_4) inv_1xt
I11_3 (\~RD_Ack_3 RD_AckT_3) inv_1xt
I11_2 (\~RD_Ack_2 RD_AckT_2) inv_1xt
I11_1 (\~RD_Ack_1 RD_AckT_1) inv_1xt
I11_0 (\~RD_Ack_0 RD_AckT_0) inv_1xt
I10_7 (WD_AckT_7 \~WD_Ack_7) inv_1xt
I10_6 (WD_AckT_6 \~WD_Ack_6) inv_1xt
I10_5 (WD_AckT_5 \~WD_Ack_5) inv_1xt
I10_4 (WD_AckT_4 \~WD_Ack_4) inv_1xt
I10_3 (WD_AckT_3 \~WD_Ack_3) inv_1xt
I10_2 (WD_AckT_2 \~WD_Ack_2) inv_1xt
I10_1 (WD_AckT_1 \~WD_Ack_1) inv_1xt
I10_0 (WD_AckT_0 \~WD_Ack_0) inv_1xt
I18_1 (\~WRW_1 WRWT_1) inv_1xt
I18_0 (\~WRW_0 WRWT_0) inv_1xt
I17_19 (\~W_Address_19 W_AddressT_19) inv_1xt
I17_18 (\~W_Address_18 W_AddressT_18) inv_1xt
I17_17 (\~W_Address_17 W_AddressT_17) inv_1xt
I17_16 (\~W_Address_16 W_AddressT_16) inv_1xt
I17_15 (\~W_Address_15 W_AddressT_15) inv_1xt
I17_14 (\~W_Address_14 W_AddressT_14) inv_1xt
I17_13 (\~W_Address_13 W_AddressT_13) inv_1xt
I17_12 (\~W_Address_12 W_AddressT_12) inv_1xt
I17_11 (\~W_Address_11 W_AddressT_11) inv_1xt
I17_10 (\~W_Address_10 W_AddressT_10) inv_1xt
I17_9 (\~W_Address_9 W_AddressT_9) inv_1xt
I17_8 (\~W_Address_8 W_AddressT_8) inv_1xt
I17_7 (\~W_Address_7 W_AddressT_7) inv_1xt
I17_6 (\~W_Address_6 W_AddressT_6) inv_1xt
I17_5 (\~W_Address_5 W_AddressT_5) inv_1xt
I17_4 (\~W_Address_4 W_AddressT_4) inv_1xt
I17_3 (\~W_Address_3 W_AddressT_3) inv_1xt
I17_2 (\~W_Address_2 W_AddressT_2) inv_1xt
I17_1 (\~W_Address_1 W_AddressT_1) inv_1xt
I17_0 (\~W_Address_0 W_AddressT_0) inv_1xt
I14 (WriteAckT \~WriteAck) inv_1xt
I6_31 (ReadDataT_31 \~ReadData_31) inv_1xt
I6_30 (ReadDataT_30 \~ReadData_30) inv_1xt
I6_29 (ReadDataT_29 \~ReadData_29) inv_1xt
I6_28 (ReadDataT_28 \~ReadData_28) inv_1xt
I6_27 (ReadDataT_27 \~ReadData_27) inv_1xt
I6_26 (ReadDataT_26 \~ReadData_26) inv_1xt
I6_25 (ReadDataT_25 \~ReadData_25) inv_1xt
I6_24 (ReadDataT_24 \~ReadData_24) inv_1xt
I6_23 (ReadDataT_23 \~ReadData_23) inv_1xt
I6_22 (ReadDataT_22 \~ReadData_22) inv_1xt
I6_21 (ReadDataT_21 \~ReadData_21) inv_1xt
I6_20 (ReadDataT_20 \~ReadData_20) inv_1xt
I6_19 (ReadDataT_19 \~ReadData_19) inv_1xt
I6_18 (ReadDataT_18 \~ReadData_18) inv_1xt
I6_17 (ReadDataT_17 \~ReadData_17) inv_1xt
I6_16 (ReadDataT_16 \~ReadData_16) inv_1xt
I6_15 (ReadDataT_15 \~ReadData_15) inv_1xt
I6_14 (ReadDataT_14 \~ReadData_14) inv_1xt
I6_13 (ReadDataT_13 \~ReadData_13) inv_1xt
I6_12 (ReadDataT_12 \~ReadData_12) inv_1xt
I6_11 (ReadDataT_11 \~ReadData_11) inv_1xt
I6_10 (ReadDataT_10 \~ReadData_10) inv_1xt
I6_9 (ReadDataT_9 \~ReadData_9) inv_1xt
I6_8 (ReadDataT_8 \~ReadData_8) inv_1xt
I6_7 (ReadDataT_7 \~ReadData_7) inv_1xt
I6_6 (ReadDataT_6 \~ReadData_6) inv_1xt
I6_5 (ReadDataT_5 \~ReadData_5) inv_1xt
I6_4 (ReadDataT_4 \~ReadData_4) inv_1xt
I6_3 (ReadDataT_3 \~ReadData_3) inv_1xt
I6_2 (ReadDataT_2 \~ReadData_2) inv_1xt
I6_1 (ReadDataT_1 \~ReadData_1) inv_1xt
I6_0 (ReadDataT_0 \~ReadData_0) inv_1xt
I5_31 (\~WriteData_31 WriteDataT_31) inv_1xt
I5_30 (\~WriteData_30 WriteDataT_30) inv_1xt
I5_29 (\~WriteData_29 WriteDataT_29) inv_1xt
I5_28 (\~WriteData_28 WriteDataT_28) inv_1xt
I5_27 (\~WriteData_27 WriteDataT_27) inv_1xt
I5_26 (\~WriteData_26 WriteDataT_26) inv_1xt
I5_25 (\~WriteData_25 WriteDataT_25) inv_1xt
I5_24 (\~WriteData_24 WriteDataT_24) inv_1xt
I5_23 (\~WriteData_23 WriteDataT_23) inv_1xt
I5_22 (\~WriteData_22 WriteDataT_22) inv_1xt
I5_21 (\~WriteData_21 WriteDataT_21) inv_1xt
I5_20 (\~WriteData_20 WriteDataT_20) inv_1xt
I5_19 (\~WriteData_19 WriteDataT_19) inv_1xt
I5_18 (\~WriteData_18 WriteDataT_18) inv_1xt
I5_17 (\~WriteData_17 WriteDataT_17) inv_1xt
I5_16 (\~WriteData_16 WriteDataT_16) inv_1xt
I5_15 (\~WriteData_15 WriteDataT_15) inv_1xt
I5_14 (\~WriteData_14 WriteDataT_14) inv_1xt
I5_13 (\~WriteData_13 WriteDataT_13) inv_1xt
I5_12 (\~WriteData_12 WriteDataT_12) inv_1xt
I5_11 (\~WriteData_11 WriteDataT_11) inv_1xt
I5_10 (\~WriteData_10 WriteDataT_10) inv_1xt
I5_9 (\~WriteData_9 WriteDataT_9) inv_1xt
I5_8 (\~WriteData_8 WriteDataT_8) inv_1xt
I5_7 (\~WriteData_7 WriteDataT_7) inv_1xt
I5_6 (\~WriteData_6 WriteDataT_6) inv_1xt
I5_5 (\~WriteData_5 WriteDataT_5) inv_1xt
I5_4 (\~WriteData_4 WriteDataT_4) inv_1xt
I5_3 (\~WriteData_3 WriteDataT_3) inv_1xt
I5_2 (\~WriteData_2 WriteDataT_2) inv_1xt
I5_1 (\~WriteData_1 WriteDataT_1) inv_1xt
I5_0 (\~WriteData_0 WriteDataT_0) inv_1xt
// BEGIN Hierarchical Interface Elements
_ie99864 (\~WriteData_8 0) d2a src="99864" val0=0.0 val1=vdd valx=vdd/2 rise=2p fall=2p
_ie99865 (\~WD_Ack_7 0) a2d dest="99865" vl=0.3*vdd vh=0.7*vdd timex=20n
_ie99866 (\~WA_Ack_4 0) a2d dest="99866" vl=0.3*vdd vh=0.7*vdd timex=20n
_ie99867 (\~WriteData_9 0) d2a src="99867" val0=0.0 val1=vdd valx=vdd/2 rise=2p fall=2p
_ie99868 (\~WriteData_6 0) d2a src="99868" val0=0.0 val1=vdd valx=vdd/2 rise=2p fall=2p
_ie99869 (\~WriteData_31 0) d2a src="99869" val0=0.0 val1=vdd valx=vdd/2 rise=2p fall=2p
_ie99870 (\~WriteData_26 0) d2a src="99870" val0=0.0 val1=vdd valx=vdd/2 rise=2p fall=2p
_ie99871 (\~WriteData_29 0) d2a src="99871" val0=0.0 val1=vdd valx=vdd/2 rise=2p fall=2p
_ie99872 (\~ReadData_25 0) a2d dest="99872" vl=0.3*vdd vh=0.7*vdd timex=20n
_ie99873 (\~WriteData_7 0) d2a src="99873" val0=0.0 val1=vdd valx=vdd/2 rise=2p fall=2p
_ie99874 (\~RD_Ack_6 0) d2a src="99874" val0=0.0 val1=vdd valx=vdd/2 rise=2p fall=2p
_ie99875 (\~W_Address_3 0) d2a src="99875" val0=0.0 val1=vdd valx=vdd/2 rise=2p fall=2p
_ie99876 (\~W_Address_4 0) d2a src="99876" val0=0.0 val1=vdd valx=vdd/2 rise=2p fall=2p
_ie99877 (\~W_Address_14 0) d2a src="99877" val0=0.0 val1=vdd valx=vdd/2 rise=2p fall=2p
_ie99878 (\~WD_Ack_5 0) a2d dest="99878" vl=0.3*vdd vh=0.7*vdd timex=20n
_ie99879 (\~W_Address_6 0) d2a src="99879" val0=0.0 val1=vdd valx=vdd/2 rise=2p fall=2p
_ie99880 (\~ReadAck 0) a2d dest="99880" vl=0.3*vdd vh=0.7*vdd timex=20n
_ie99881 (\~RD_Ack_0 0) d2a src="99881" val0=0.0 val1=vdd valx=vdd/2 rise=2p fall=2p
_ie99882 (\~ReadData_19 0) a2d dest="99882" vl=0.3*vdd vh=0.7*vdd timex=20n
_ie99883 (\~WA_Ack_0 0) a2d dest="99883" vl=0.3*vdd vh=0.7*vdd timex=20n
_ie99884 (\~ReadData_16 0) a2d dest="99884" vl=0.3*vdd vh=0.7*vdd timex=20n
_ie99885 (\~ReadData_20 0) a2d dest="99885" vl=0.3*vdd vh=0.7*vdd timex=20n
_ie99886 (\~ReadData_27 0) a2d dest="99886" vl=0.3*vdd vh=0.7*vdd timex=20n
_ie99887 (\~WriteData_28 0) d2a src="99887" val0=0.0 val1=vdd valx=vdd/2 rise=2p fall=2p
_ie99888 (\~ReadData_9 0) a2d dest="99888" vl=0.3*vdd vh=0.7*vdd timex=20n
_ie99889 (\~ReadData_10 0) a2d dest="99889" vl=0.3*vdd vh=0.7*vdd timex=20n
_ie99890 (\~ReadData_12 0) a2d dest="99890" vl=0.3*vdd vh=0.7*vdd timex=20n
_ie99891 (\~RD_Ack_4 0) d2a src="99891" val0=0.0 val1=vdd valx=vdd/2 rise=2p fall=2p
_ie99892 (\~W_Address_16 0) d2a src="99892" val0=0.0 val1=vdd valx=vdd/2 rise=2p fall=2p
_ie99893 (\~RRW_1 0) d2a src="99893" val0=0.0 val1=vdd valx=vdd/2 rise=2p fall=2p
_ie99894 (\~R_Address_4 0) d2a src="99894" val0=0.0 val1=vdd valx=vdd/2 rise=2p fall=2p
_ie99895 (\~RRW_0 0) d2a src="99895" val0=0.0 val1=vdd valx=vdd/2 rise=2p fall=2p
_ie99896 (\~ReadData_13 0) a2d dest="99896" vl=0.3*vdd vh=0.7*vdd timex=20n
_ie99897 (\~W_Address_0 0) d2a src="99897" val0=0.0 val1=vdd valx=vdd/2 rise=2p fall=2p
_ie99898 (\~WD_Ack_2 0) a2d dest="99898" vl=0.3*vdd vh=0.7*vdd timex=20n
_ie99899 (\~R_Address_8 0) d2a src="99899" val0=0.0 val1=vdd valx=vdd/2 rise=2p fall=2p
_ie99900 (\~WriteData_0 0) d2a src="99900" val0=0.0 val1=vdd valx=vdd/2 rise=2p fall=2p
_ie99901 (\~WriteData_17 0) d2a src="99901" val0=0.0 val1=vdd valx=vdd/2 rise=2p fall=2p
_ie99902 (\~RA_Ack_4 0) a2d dest="99902" vl=0.3*vdd vh=0.7*vdd timex=20n
_ie99903 (\~W_Address_9 0) d2a src="99903" val0=0.0 val1=vdd valx=vdd/2 rise=2p fall=2p
_ie99904 (\~WriteData_18 0) d2a src="99904" val0=0.0 val1=vdd valx=vdd/2 rise=2p fall=2p
_ie99905 (\~R_Address_19 0) d2a src="99905" val0=0.0 val1=vdd valx=vdd/2 rise=2p fall=2p
_ie99906 (\~W_Address_7 0) d2a src="99906" val0=0.0 val1=vdd valx=vdd/2 rise=2p fall=2p
_ie99907 (\~RD_Ack_2 0) d2a src="99907" val0=0.0 val1=vdd valx=vdd/2 rise=2p fall=2p
_ie99908 (\~RD_Ack_7 0) d2a src="99908" val0=0.0 val1=vdd valx=vdd/2 rise=2p fall=2p
_ie99909 (\~ReadData_2 0) a2d dest="99909" vl=0.3*vdd vh=0.7*vdd timex=20n
_ie99910 (\~WriteData_3 0) d2a src="99910" val0=0.0 val1=vdd valx=vdd/2 rise=2p fall=2p
_ie99911 (\~WD_Ack_0 0) a2d dest="99911" vl=0.3*vdd vh=0.7*vdd timex=20n
_ie99912 (\~ReadData_0 0) a2d dest="99912" vl=0.3*vdd vh=0.7*vdd timex=20n
_ie99913 (\~WriteData_12 0) d2a src="99913" val0=0.0 val1=vdd valx=vdd/2 rise=2p fall=2p
_ie99914 (\~WriteData_1 0) d2a src="99914" val0=0.0 val1=vdd valx=vdd/2 rise=2p fall=2p
_ie99915 (\~RA_Ack_3 0) a2d dest="99915" vl=0.3*vdd vh=0.7*vdd timex=20n
_ie99916 (\~WriteData_19 0) d2a src="99916" val0=0.0 val1=vdd valx=vdd/2 rise=2p fall=2p
_ie99917 (\~ReadData_1 0) a2d dest="99917" vl=0.3*vdd vh=0.7*vdd timex=20n
_ie99918 (\~ReadData_5 0) a2d dest="99918" vl=0.3*vdd vh=0.7*vdd timex=20n
_ie99919 (\~WriteData_4 0) d2a src="99919" val0=0.0 val1=vdd valx=vdd/2 rise=2p fall=2p
_ie99920 (\~ReadData_26 0) a2d dest="99920" vl=0.3*vdd vh=0.7*vdd timex=20n
_ie99921 (\~R_Address_15 0) d2a src="99921" val0=0.0 val1=vdd valx=vdd/2 rise=2p fall=2p
_ie99922 (\~W_Address_8 0) d2a src="99922" val0=0.0 val1=vdd valx=vdd/2 rise=2p fall=2p
_ie99923 (\~WriteData_5 0) d2a src="99923" val0=0.0 val1=vdd valx=vdd/2 rise=2p fall=2p
_ie99924 (\~R_Address_3 0) d2a src="99924" val0=0.0 val1=vdd valx=vdd/2 rise=2p fall=2p
_ie99925 (\~WriteData_22 0) d2a src="99925" val0=0.0 val1=vdd valx=vdd/2 rise=2p fall=2p
_ie99926 (\~W_Address_1 0) d2a src="99926" val0=0.0 val1=vdd valx=vdd/2 rise=2p fall=2p
_ie99927 (\~ReadData_21 0) a2d dest="99927" vl=0.3*vdd vh=0.7*vdd timex=20n
_ie99928 (\~WriteData_20 0) d2a src="99928" val0=0.0 val1=vdd valx=vdd/2 rise=2p fall=2p
_ie99929 (\~R_Address_13 0) d2a src="99929" val0=0.0 val1=vdd valx=vdd/2 rise=2p fall=2p
_ie99930 (\~R_Address_5 0) d2a src="99930" val0=0.0 val1=vdd valx=vdd/2 rise=2p fall=2p
_ie99931 (\~WriteData_13 0) d2a src="99931" val0=0.0 val1=vdd valx=vdd/2 rise=2p fall=2p
_ie99932 (\~ReadData_29 0) a2d dest="99932" vl=0.3*vdd vh=0.7*vdd timex=20n
_ie99933 (\~ReadData_15 0) a2d dest="99933" vl=0.3*vdd vh=0.7*vdd timex=20n
_ie99934 (\~WriteData_2 0) d2a src="99934" val0=0.0 val1=vdd valx=vdd/2 rise=2p fall=2p
_ie99935 (\~R_Address_16 0) d2a src="99935" val0=0.0 val1=vdd valx=vdd/2 rise=2p fall=2p
_ie99936 (\~R_Address_17 0) d2a src="99936" val0=0.0 val1=vdd valx=vdd/2 rise=2p fall=2p
_ie99937 (\~R_Address_18 0) d2a src="99937" val0=0.0 val1=vdd valx=vdd/2 rise=2p fall=2p
_ie99938 (\~R_Address_14 0) d2a src="99938" val0=0.0 val1=vdd valx=vdd/2 rise=2p fall=2p
_ie99939 (\~WD_Ack_1 0) a2d dest="99939" vl=0.3*vdd vh=0.7*vdd timex=20n
_ie99940 (\~W_Address_10 0) d2a src="99940" val0=0.0 val1=vdd valx=vdd/2 rise=2p fall=2p
_ie99941 (\~WriteData_14 0) d2a src="99941" val0=0.0 val1=vdd valx=vdd/2 rise=2p fall=2p
_ie99942 (\~W_Address_11 0) d2a src="99942" val0=0.0 val1=vdd valx=vdd/2 rise=2p fall=2p
_ie99943 (\~W_Address_12 0) d2a src="99943" val0=0.0 val1=vdd valx=vdd/2 rise=2p fall=2p
_ie99944 (\~W_Address_13 0) d2a src="99944" val0=0.0 val1=vdd valx=vdd/2 rise=2p fall=2p
_ie99945 (\~WriteData_30 0) d2a src="99945" val0=0.0 val1=vdd valx=vdd/2 rise=2p fall=2p
_ie99946 (\~ReadData_22 0) a2d dest="99946" vl=0.3*vdd vh=0.7*vdd timex=20n
_ie99947 (\~ReadData_23 0) a2d dest="99947" vl=0.3*vdd vh=0.7*vdd timex=20n
_ie99948 (\~R_Address_6 0) d2a src="99948" val0=0.0 val1=vdd valx=vdd/2 rise=2p fall=2p
_ie99949 (\~WriteAck 0) a2d dest="99949" vl=0.3*vdd vh=0.7*vdd timex=20n
_ie99950 (\~WA_Ack_3 0) a2d dest="99950" vl=0.3*vdd vh=0.7*vdd timex=20n
_ie99951 (\~WriteData_15 0) d2a src="99951" val0=0.0 val1=vdd valx=vdd/2 rise=2p fall=2p
_ie99952 (\~WriteData_16 0) d2a src="99952" val0=0.0 val1=vdd valx=vdd/2 rise=2p fall=2p
_ie99953 (\~W_Address_5 0) d2a src="99953" val0=0.0 val1=vdd valx=vdd/2 rise=2p fall=2p
_ie99954 (\~WriteData_25 0) d2a src="99954" val0=0.0 val1=vdd valx=vdd/2 rise=2p fall=2p
_ie99955 (\~R_Address_7 0) d2a src="99955" val0=0.0 val1=vdd valx=vdd/2 rise=2p fall=2p
_ie99956 (\~W_Address_19 0) d2a src="99956" val0=0.0 val1=vdd valx=vdd/2 rise=2p fall=2p
_ie99957 (\~R_Address_11 0) d2a src="99957" val0=0.0 val1=vdd valx=vdd/2 rise=2p fall=2p
_ie99958 (\~R_Address_12 0) d2a src="99958" val0=0.0 val1=vdd valx=vdd/2 rise=2p fall=2p
_ie99959 (\~WriteData_27 0) d2a src="99959" val0=0.0 val1=vdd valx=vdd/2 rise=2p fall=2p
_ie99960 (\~RD_Ack_5 0) d2a src="99960" val0=0.0 val1=vdd valx=vdd/2 rise=2p fall=2p
_ie99961 (\~ReadData_14 0) a2d dest="99961" vl=0.3*vdd vh=0.7*vdd timex=20n
_ie99962 (\~ReadData_24 0) a2d dest="99962" vl=0.3*vdd vh=0.7*vdd timex=20n
_ie99963 (\~ReadData_17 0) a2d dest="99963" vl=0.3*vdd vh=0.7*vdd timex=20n
_ie99964 (\~R_Address_10 0) d2a src="99964" val0=0.0 val1=vdd valx=vdd/2 rise=2p fall=2p
_ie99965 (\~ReadData_30 0) a2d dest="99965" vl=0.3*vdd vh=0.7*vdd timex=20n
_ie99966 (\~W_Address_15 0) d2a src="99966" val0=0.0 val1=vdd valx=vdd/2 rise=2p fall=2p
_ie99967 (\~R_Address_1 0) d2a src="99967" val0=0.0 val1=vdd valx=vdd/2 rise=2p fall=2p
_ie99968 (\~ReadData_4 0) a2d dest="99968" vl=0.3*vdd vh=0.7*vdd timex=20n
_ie99969 (\~R_Address_0 0) d2a src="99969" val0=0.0 val1=vdd valx=vdd/2 rise=2p fall=2p
_ie99970 (\~ReadData_18 0) a2d dest="99970" vl=0.3*vdd vh=0.7*vdd timex=20n
_ie99971 (\~ReadData_3 0) a2d dest="99971" vl=0.3*vdd vh=0.7*vdd timex=20n
_ie99972 (\~R_Address_9 0) d2a src="99972" val0=0.0 val1=vdd valx=vdd/2 rise=2p fall=2p
_ie99973 (\~ReadData_11 0) a2d dest="99973" vl=0.3*vdd vh=0.7*vdd timex=20n
_ie99974 (\~W_Address_17 0) d2a src="99974" val0=0.0 val1=vdd valx=vdd/2 rise=2p fall=2p
_ie99975 (\~W_Address_2 0) d2a src="99975" val0=0.0 val1=vdd valx=vdd/2 rise=2p fall=2p
_ie99976 (\~WriteData_21 0) d2a src="99976" val0=0.0 val1=vdd valx=vdd/2 rise=2p fall=2p
_ie99977 (\~W_Address_18 0) d2a src="99977" val0=0.0 val1=vdd valx=vdd/2 rise=2p fall=2p
_ie99978 (\~WriteData_23 0) d2a src="99978" val0=0.0 val1=vdd valx=vdd/2 rise=2p fall=2p
_ie99979 (\~R_Address_2 0) d2a src="99979" val0=0.0 val1=vdd valx=vdd/2 rise=2p fall=2p
_ie99980 (\~RA_Ack_2 0) a2d dest="99980" vl=0.3*vdd vh=0.7*vdd timex=20n
_ie99981 (\~WRW_0 0) d2a src="99981" val0=0.0 val1=vdd valx=vdd/2 rise=2p fall=2p
_ie99982 (\~RA_Ack_1 0) a2d dest="99982" vl=0.3*vdd vh=0.7*vdd timex=20n
_ie99983 (\~ReadData_8 0) a2d dest="99983" vl=0.3*vdd vh=0.7*vdd timex=20n
_ie99984 (\~WriteData_24 0) d2a src="99984" val0=0.0 val1=vdd valx=vdd/2 rise=2p fall=2p
_ie99985 (\~WA_Ack_1 0) a2d dest="99985" vl=0.3*vdd vh=0.7*vdd timex=20n
_ie99986 (\~WA_Ack_2 0) a2d dest="99986" vl=0.3*vdd vh=0.7*vdd timex=20n
_ie99987 (\~WD_Ack_6 0) a2d dest="99987" vl=0.3*vdd vh=0.7*vdd timex=20n
_ie99988 (\~WD_Ack_4 0) a2d dest="99988" vl=0.3*vdd vh=0.7*vdd timex=20n
_ie99989 (\~WriteData_10 0) d2a src="99989" val0=0.0 val1=vdd valx=vdd/2 rise=2p fall=2p
_ie99990 (\~WD_Ack_3 0) a2d dest="99990" vl=0.3*vdd vh=0.7*vdd timex=20n
_ie99991 (\~ReadData_7 0) a2d dest="99991" vl=0.3*vdd vh=0.7*vdd timex=20n
_ie99992 (\~RD_Ack_3 0) d2a src="99992" val0=0.0 val1=vdd valx=vdd/2 rise=2p fall=2p
_ie99993 (\~WRW_1 0) d2a src="99993" val0=0.0 val1=vdd valx=vdd/2 rise=2p fall=2p
_ie99994 (\~ReadData_28 0) a2d dest="99994" vl=0.3*vdd vh=0.7*vdd timex=20n
_ie99995 (\~WriteData_11 0) d2a src="99995" val0=0.0 val1=vdd valx=vdd/2 rise=2p fall=2p
_ie99996 (\~RD_Ack_1 0) d2a src="99996" val0=0.0 val1=vdd valx=vdd/2 rise=2p fall=2p
_ie99997 (\~ReadData_6 0) a2d dest="99997" vl=0.3*vdd vh=0.7*vdd timex=20n
_ie99998 (\~ReadData_31 0) a2d dest="99998" vl=0.3*vdd vh=0.7*vdd timex=20n
_ie99999 (\~RA_Ack_0 0) a2d dest="99999" vl=0.3*vdd vh=0.7*vdd timex=20n
// END Hierarchical Interface Elements
ic IBank.Ap_15=0 IBank.Ap_14=0 IBank.Ap_13=0 IBank.Ap_12=0 IBank.Ap_11=0 IBank.Ap_10=0 IBank.Ap_9=0 IBank.Ap_8=0 IBank.Ap_7=0 IBank.Ap_6=0 IBank.Ap_5=0 IBank.Ap_4=0 IBank.Ap_3=0 IBank.Ap_2=0 IBank.Ap_1=0 IBank.Ap_0=0 IBank.WRWp_1=0 IBank.WRWp_0=0 IBank.I1.I3.net31=0 IBank.I1.I3.net29=0 IBank.I1.I3.net28=0 IBank.I1.I3.net26=0 IBank.I1.I1.Vpass_0=0 IBank.I1.I1.Vpass_1=0 IBank.I1.I1.Vpass_2=0 IBank.I1.I1.Vpass_3=0 IBank.I1.I1.bmid_2=0 IBank.I1.I1.bmid_3=0 IBank.I1.I1.bmid_1=0 IBank.I1.I1.bmid_0=0 IBank.I1.I1.amid_3=0 IBank.I1.I1.amid_2=0 IBank.I1.I1.amid_1=0 IBank.I1.I1.amid_0=0 IBank.Ap_19=0 IBank.Ap_18=0 IBank.Ap_17=0 IBank.Ap_16=0 WD_AckT_7=0 WD_AckT_6=0 WD_AckT_5=0 WD_AckT_4=0 WD_AckT_3=0 WD_AckT_2=0 WD_AckT_1=0 WD_AckT_0=0 \~RD_Ack_7=vdd \~RD_Ack_6=vdd \~RD_Ack_5=vdd \~RD_Ack_4=vdd \~RD_Ack_3=vdd \~RD_Ack_2=vdd \~RD_Ack_1=vdd \~RD_Ack_0=vdd RD_AckT_7=0 RD_AckT_6=0 RD_AckT_5=0 RD_AckT_4=0 RD_AckT_3=0 RD_AckT_2=0 RD_AckT_1=0 RD_AckT_0=0 R_AddressT_19=0 R_AddressT_18=0 R_AddressT_17=0 R_AddressT_16=0 R_AddressT_15=0 R_AddressT_14=0 R_AddressT_13=0 R_AddressT_12=0 R_AddressT_11=0 R_AddressT_10=0 R_AddressT_9=0 R_AddressT_8=0 R_AddressT_7=0 R_AddressT_6=0 R_AddressT_5=0 R_AddressT_4=0 R_AddressT_3=0 R_AddressT_2=0 R_AddressT_1=0 R_AddressT_0=0 RRWT_1=0 RRWT_0=0 WRWT_1=0 WRWT_0=0 W_AddressT_19=0 W_AddressT_18=0 W_AddressT_17=0 W_AddressT_16=0 W_AddressT_15=0 W_AddressT_14=0 W_AddressT_13=0 W_AddressT_12=0 W_AddressT_11=0 W_AddressT_10=0 W_AddressT_9=0 W_AddressT_8=0 W_AddressT_7=0 W_AddressT_6=0 W_AddressT_5=0 W_AddressT_4=0 W_AddressT_3=0 W_AddressT_2=0 W_AddressT_1=0 W_AddressT_0=0 WriteDataT_31=0 WriteDataT_30=0 WriteDataT_29=0 WriteDataT_28=0 WriteDataT_27=0 WriteDataT_26=0 WriteDataT_25=0 WriteDataT_24=0 WriteDataT_23=0 WriteDataT_22=0 WriteDataT_21=0 WriteDataT_20=0 WriteDataT_19=0 WriteDataT_18=0 WriteDataT_17=0 WriteDataT_16=0 WriteDataT_15=0 WriteDataT_14=0 WriteDataT_13=0 WriteDataT_12=0 WriteDataT_11=0 WriteDataT_10=0 WriteDataT_9=0 WriteDataT_8=0 WriteDataT_7=0 WriteDataT_6=0 WriteDataT_5=0 WriteDataT_4=0 WriteDataT_3=0 WriteDataT_2=0 WriteDataT_1=0 WriteDataT_0=0 IBank.I0.I0.I0.I0.I7.I3.Q1=vdd IBank.I0.I0.I0.I0.I7.I3.Q0=0
simulatorOptions options temp=30.0
tran tran stop=6n errpreset=conservative
save V1:p V0:p V0:p vdd! IBank:48 IBank:116 V1:p
