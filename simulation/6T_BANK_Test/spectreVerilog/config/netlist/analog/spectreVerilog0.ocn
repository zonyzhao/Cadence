simulator( 'spectreVerilog )
design(	 "/net/kafka/nfs/rstdenis/Cadence/simulation/6T_BANK_Test/spectreVerilog/config/netlist/analog/netlist")
resultsDir( "/net/kafka/nfs/rstdenis/Cadence/simulation/6T_BANK_Test/spectreVerilog/config" )
modelFile(
    '("/software/cadence/ncsu-FreePDK15/hspice_16nm_hp.include" "")
)
analysis('tran ?stop "5n "  ?errpreset "conservative"  )
desVar(	  "vcc" "vdd"	)
desVar(	  "vdd" .700	)
envOption(
	'mspSetupNetlistSimPrecisionUnit  "ps"
	'mspSetupNetlistSimTimeUnit  "ps"
	'mspSetupNetlistSwitchRC  t
	'userCmdLineOption  "+multithread"
	'analysisOrder  list("tran")
)
option(	'temp  "30.0"
)
saveOption( ?simOutputFormat "psfxl" )
save( 'i "/V0/MINUS" "/V0/PLUS" "/V1/MINUS" "/V1/PLUS" )
converge( 'ic "/WriteDataT<0>" "0" )
converge( 'ic "/WriteDataT<1>" "0" )
converge( 'ic "/WriteDataT<2>" "0" )
converge( 'ic "/WriteDataT<3>" "0" )
converge( 'ic "/WriteDataT<4>" "0" )
converge( 'ic "/WriteDataT<5>" "0" )
converge( 'ic "/WriteDataT<6>" "0" )
converge( 'ic "/WriteDataT<7>" "0" )
converge( 'ic "/WriteDataT<8>" "0" )
converge( 'ic "/WriteDataT<9>" "0" )
converge( 'ic "/WriteDataT<10>" "0" )
converge( 'ic "/WriteDataT<11>" "0" )
converge( 'ic "/WriteDataT<12>" "0" )
converge( 'ic "/WriteDataT<13>" "0" )
converge( 'ic "/WriteDataT<14>" "0" )
converge( 'ic "/WriteDataT<15>" "0" )
converge( 'ic "/WriteDataT<16>" "0" )
converge( 'ic "/WriteDataT<17>" "0" )
converge( 'ic "/WriteDataT<18>" "0" )
converge( 'ic "/WriteDataT<19>" "0" )
converge( 'ic "/WriteDataT<20>" "0" )
converge( 'ic "/WriteDataT<21>" "0" )
converge( 'ic "/WriteDataT<22>" "0" )
converge( 'ic "/WriteDataT<23>" "0" )
converge( 'ic "/WriteDataT<24>" "0" )
converge( 'ic "/WriteDataT<25>" "0" )
converge( 'ic "/WriteDataT<26>" "0" )
converge( 'ic "/WriteDataT<27>" "0" )
converge( 'ic "/WriteDataT<28>" "0" )
converge( 'ic "/WriteDataT<29>" "0" )
converge( 'ic "/WriteDataT<30>" "0" )
converge( 'ic "/WriteDataT<31>" "0" )
converge( 'ic "/ReaDataT<0>" "0" )
converge( 'ic "/ReaDataT<1>" "0" )
converge( 'ic "/ReaDataT<2>" "0" )
converge( 'ic "/ReaDataT<3>" "0" )
converge( 'ic "/ReaDataT<4>" "0" )
converge( 'ic "/ReaDataT<5>" "0" )
converge( 'ic "/ReaDataT<6>" "0" )
converge( 'ic "/ReaDataT<7>" "0" )
converge( 'ic "/ReaDataT<8>" "0" )
converge( 'ic "/ReaDataT<9>" "0" )
converge( 'ic "/ReaDataT<10>" "0" )
converge( 'ic "/ReaDataT<11>" "0" )
converge( 'ic "/ReaDataT<12>" "0" )
converge( 'ic "/ReaDataT<13>" "0" )
converge( 'ic "/ReaDataT<14>" "0" )
converge( 'ic "/ReaDataT<15>" "0" )
converge( 'ic "/ReaDataT<16>" "0" )
converge( 'ic "/ReaDataT<17>" "0" )
converge( 'ic "/ReaDataT<18>" "0" )
converge( 'ic "/ReaDataT<19>" "0" )
converge( 'ic "/ReaDataT<20>" "0" )
converge( 'ic "/ReaDataT<21>" "0" )
converge( 'ic "/ReaDataT<22>" "0" )
converge( 'ic "/ReaDataT<23>" "0" )
converge( 'ic "/ReaDataT<24>" "0" )
converge( 'ic "/ReaDataT<25>" "0" )
converge( 'ic "/ReaDataT<26>" "0" )
converge( 'ic "/ReaDataT<27>" "0" )
converge( 'ic "/ReaDataT<28>" "0" )
converge( 'ic "/ReaDataT<29>" "0" )
converge( 'ic "/ReaDataT<30>" "0" )
converge( 'ic "/ReaDataT<31>" "0" )
temp( 30.0 )
run()
selectResult( 'tran )
plot(getData("/A<19:0>") getData("/AT<0>") getData("/AT<10>") getData("/AT<11>") getData("/AT<12>") getData("/AT<13>") getData("/AT<14>") getData("/AT<15>") getData("/AT<16>") getData("/AT<17>") getData("/AT<18>") getData("/AT<19>") getData("/AT<1>") getData("/AT<2>") getData("/AT<3>") getData("/AT<4>") getData("/AT<5>") getData("/AT<6>") getData("/AT<7>") getData("/AT<8>") getData("/AT<9>") getData("/Ack") getData("/AckT") getData("/IBank/B0_1<0>") getData("/IBank/B0_1<1>") getData("/IBank/B0_1<2>") getData("/IBank/B0_1<3>") getData("/IBank/B1_1<0>") getData("/IBank/B1_1<1>") getData("/IBank/B1_1<2>") getData("/IBank/B1_1<3>") getData("/IBank/G01") getData("/IBank/I20/B0p<0>") getData("/IBank/I20/B0p<1>") getData("/IBank/I20/B0p<2>") getData("/IBank/I20/B0p<3>") getData("/IBank/I20/B1p<0>") getData("/IBank/I20/B1p<1>") getData("/IBank/I20/B1p<2>") getData("/IBank/I20/B1p<3>") getData("/IBank/I20/R0p<0>") getData("/IBank/I20/R0p<1>") getData("/IBank/I20/R0p<2>") getData("/IBank/I20/R0p<3>") getData("/IBank/I20/R1p<0>") getData("/IBank/I20/R1p<1>") getData("/IBank/I20/R1p<2>") getData("/IBank/I20/R1p<3>") getData("/IBank/I20/Wen") getData("/IBank/RD_Ack<1:0>") getData("/IBank/W0_1<0>") getData("/IBank/W0_1<1>") getData("/IBank/W0_1<2>") getData("/IBank/W0_1<3>") getData("/IBank/W1_1<0>") getData("/IBank/W1_1<1>") getData("/IBank/W1_1<2>") getData("/IBank/W1_1<3>") getData("/IBank/~R0_1<0>") getData("/IBank/~R0_1<1>") getData("/IBank/~R0_1<2>") getData("/IBank/~R0_1<3>") getData("/IBank/~R1_1<0>") getData("/IBank/~R1_1<1>") getData("/IBank/~R1_1<2>") getData("/IBank/~R1_1<3>") getData("/RD_Ack<7:0>") getData("/RW<1:0>") getData("/RWT<0>") getData("/RWT<1>") getData("/ReaDataT<0>") getData("/ReaDataT<1>") getData("/ReaDataT<2>") getData("/ReaDataT<3>") getData("/ReaDataT<4>") getData("/ReaDataT<5>") getData("/ReaDataT<6>") getData("/ReaDataT<7>") getData("/ReadData<31:0>") getData("/V0/MINUS") getData("/V0/PLUS") getData("/V1/MINUS") getData("/V1/PLUS") getData("/WAck<0>") getData("/WAck<1>") getData("/WriteAck<7:0>") getData("/WriteData<31:0>") getData("/WriteDataT<0>") getData("/WriteDataT<10>") getData("/WriteDataT<11>") getData("/WriteDataT<12>") getData("/WriteDataT<13>") getData("/WriteDataT<14>") getData("/WriteDataT<15>") getData("/WriteDataT<16>") getData("/WriteDataT<17>") getData("/WriteDataT<18>") getData("/WriteDataT<19>") getData("/WriteDataT<1>") getData("/WriteDataT<20>") getData("/WriteDataT<21>") getData("/WriteDataT<22>") getData("/WriteDataT<23>") getData("/WriteDataT<24>") getData("/WriteDataT<25>") getData("/WriteDataT<26>") getData("/WriteDataT<27>") getData("/WriteDataT<28>") getData("/WriteDataT<29>") getData("/WriteDataT<2>") getData("/WriteDataT<30>") getData("/WriteDataT<31>") getData("/WriteDataT<3>") getData("/WriteDataT<4>") getData("/WriteDataT<5>") getData("/WriteDataT<6>") getData("/WriteDataT<7>") getData("/WriteDataT<8>") getData("/WriteDataT<9>") getData("/vcc!") getData("/vdd!") getData("/~A<19:0>") getData("/~RW<1:0>") )
