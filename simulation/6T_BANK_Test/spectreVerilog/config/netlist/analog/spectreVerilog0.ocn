simulator( 'spectreVerilog )
design(	 "/net/kafka/nfs/rstdenis/Cadence/simulation/6T_BANK_Test/spectreVerilog/config/netlist/analog/netlist")
resultsDir( "/net/kafka/nfs/rstdenis/Cadence/simulation/6T_BANK_Test/spectreVerilog/config" )
modelFile(
    '("/software/cadence/ncsu-FreePDK15/hspice_16nm_hp.include" "")
)
analysis('tran ?stop "5n "  ?errpreset "conservative"  )
desVar(	  "vcc" "vdd"	)
desVar(	  "vdd" .700	)
envOption(
	'mspSetupNetlistSimPrecisionUnit  "ps"
	'mspSetupNetlistSimTimeUnit  "ps"
	'mspSetupNetlistSwitchRC  t
	'userCmdLineOption  "+multithread"
	'analysisOrder  list("tran")
)
option(	'temp  "30.0"
)
saveOption( ?simOutputFormat "psfxl" )
save( 'i "/V0/MINUS" "/V0/PLUS" "/V1/MINUS" "/V1/PLUS" )
converge( 'ic "/WriteDataT<0>" "0" )
converge( 'ic "/WriteDataT<1>" "0" )
converge( 'ic "/WriteDataT<2>" "0" )
converge( 'ic "/WriteDataT<3>" "0" )
converge( 'ic "/WriteDataT<4>" "0" )
converge( 'ic "/WriteDataT<5>" "0" )
converge( 'ic "/WriteDataT<6>" "0" )
converge( 'ic "/WriteDataT<7>" "0" )
converge( 'ic "/WriteDataT<8>" "0" )
converge( 'ic "/WriteDataT<9>" "0" )
converge( 'ic "/WriteDataT<10>" "0" )
converge( 'ic "/WriteDataT<11>" "0" )
converge( 'ic "/WriteDataT<12>" "0" )
converge( 'ic "/WriteDataT<13>" "0" )
converge( 'ic "/WriteDataT<14>" "0" )
converge( 'ic "/WriteDataT<15>" "0" )
converge( 'ic "/WriteDataT<16>" "0" )
converge( 'ic "/WriteDataT<17>" "0" )
converge( 'ic "/WriteDataT<18>" "0" )
converge( 'ic "/WriteDataT<19>" "0" )
converge( 'ic "/WriteDataT<20>" "0" )
converge( 'ic "/WriteDataT<21>" "0" )
converge( 'ic "/WriteDataT<22>" "0" )
converge( 'ic "/WriteDataT<23>" "0" )
converge( 'ic "/WriteDataT<24>" "0" )
converge( 'ic "/WriteDataT<25>" "0" )
converge( 'ic "/WriteDataT<26>" "0" )
converge( 'ic "/WriteDataT<27>" "0" )
converge( 'ic "/WriteDataT<28>" "0" )
converge( 'ic "/WriteDataT<29>" "0" )
converge( 'ic "/WriteDataT<30>" "0" )
converge( 'ic "/WriteDataT<31>" "0" )
converge( 'ic "/ReaDataT<0>" "0" )
converge( 'ic "/ReaDataT<1>" "0" )
converge( 'ic "/ReaDataT<2>" "0" )
converge( 'ic "/ReaDataT<3>" "0" )
converge( 'ic "/ReaDataT<4>" "0" )
converge( 'ic "/ReaDataT<5>" "0" )
converge( 'ic "/ReaDataT<6>" "0" )
converge( 'ic "/ReaDataT<7>" "0" )
converge( 'ic "/ReaDataT<8>" "0" )
converge( 'ic "/ReaDataT<9>" "0" )
converge( 'ic "/ReaDataT<10>" "0" )
converge( 'ic "/ReaDataT<11>" "0" )
converge( 'ic "/ReaDataT<12>" "0" )
converge( 'ic "/ReaDataT<13>" "0" )
converge( 'ic "/ReaDataT<14>" "0" )
converge( 'ic "/ReaDataT<15>" "0" )
converge( 'ic "/ReaDataT<16>" "0" )
converge( 'ic "/ReaDataT<17>" "0" )
converge( 'ic "/ReaDataT<18>" "0" )
converge( 'ic "/ReaDataT<19>" "0" )
converge( 'ic "/ReaDataT<20>" "0" )
converge( 'ic "/ReaDataT<21>" "0" )
converge( 'ic "/ReaDataT<22>" "0" )
converge( 'ic "/ReaDataT<23>" "0" )
converge( 'ic "/ReaDataT<24>" "0" )
converge( 'ic "/ReaDataT<25>" "0" )
converge( 'ic "/ReaDataT<26>" "0" )
converge( 'ic "/ReaDataT<27>" "0" )
converge( 'ic "/ReaDataT<28>" "0" )
converge( 'ic "/ReaDataT<29>" "0" )
converge( 'ic "/ReaDataT<30>" "0" )
converge( 'ic "/ReaDataT<31>" "0" )
temp( 30.0 )
run()
selectResult( 'tran )
plot(getData("/A<19:0>") getData("/AT<0>") getData("/AT<10>") getData("/AT<11>") getData("/AT<12>") getData("/AT<13>") getData("/AT<14>") getData("/AT<15>") getData("/AT<16>") getData("/AT<17>") getData("/AT<18>") getData("/AT<19>") getData("/AT<1>") getData("/AT<2>") getData("/AT<3>") getData("/AT<4>") getData("/AT<5>") getData("/AT<6>") getData("/AT<7>") getData("/AT<8>") getData("/AT<9>") getData("/Ack") getData("/AckT") getData("/IBank/B0_1<0>") getData("/IBank/B0_1<1>") getData("/IBank/B0_1<2>") getData("/IBank/B0_1<3>") getData("/IBank/B1_1<0>") getData("/IBank/B1_1<1>") getData("/IBank/B1_1<2>") getData("/IBank/B1_1<3>") getData("/IBank/G01") getData("/IBank/I20/B0p<0>") getData("/IBank/I20/B0p<1>") getData("/IBank/I20/B0p<2>") getData("/IBank/I20/B0p<3>") getData("/IBank/I20/B1p<0>") getData("/IBank/I20/B1p<1>") getData("/IBank/I20/B1p<2>") getData("/IBank/I20/B1p<3>") getData("/IBank/I20/R0p<0>") getData("/IBank/I20/R0p<1>") getData("/IBank/I20/R0p<2>") getData("/IBank/I20/R0p<3>") getData("/IBank/I20/R1p<0>") getData("/IBank/I20/R1p<1>") getData("/IBank/I20/R1p<2>") getData("/IBank/I20/R1p<3>") getData("/IBank/I20/Wen") getData("/IBank/RD_Ack<1:0>") getData("/IBank/W0_1<0>") getData("/IBank/W0_1<1>") getData("/IBank/W0_1<2>") getData("/IBank/W0_1<3>") getData("/IBank/W1_1<0>") getData("/IBank/W1_1<1>") getData("/IBank/W1_1<2>") getData("/IBank/W1_1<3>") getData("/IBank/~R0_1<0>") getData("/IBank/~R0_1<1>") getData("/IBank/~R0_1<2>") getData("/IBank/~R0_1<3>") getData("/IBank/~R1_1<0>") getData("/IBank/~R1_1<1>") getData("/IBank/~R1_1<2>") getData("/IBank/~R1_1<3>") getData("/RD_Ack<7:0>") getData("/RW<1:0>") getData("/RWT<0>") getData("/RWT<1>") getData("/ReaDataT<0>") getData("/ReaDataT<1>") getData("/ReaDataT<2>") getData("/ReaDataT<3>") getData("/ReaDataT<4>") getData("/ReaDataT<5>") getData("/ReaDataT<6>") getData("/ReaDataT<7>") getData("/ReadData<31:0>") getData("/V0/MINUS") getData("/V0/PLUS") getData("/V1/MINUS") getData("/V1/PLUS") getData("/WAck<0>") getData("/WAck<1>") getData("/WriteAck<7:0>") getData("/WriteData<31:0>") getData("/WriteDataT<0>") getData("/WriteDataT<10>") getData("/WriteDataT<11>") getData("/WriteDataT<12>") getData("/WriteDataT<13>") getData("/WriteDataT<14>") getData("/WriteDataT<15>") getData("/WriteDataT<16>") getData("/WriteDataT<17>") getData("/WriteDataT<18>") getData("/WriteDataT<19>") getData("/WriteDataT<1>") getData("/WriteDataT<20>") getData("/WriteDataT<21>") getData("/WriteDataT<22>") getData("/WriteDataT<23>") getData("/WriteDataT<24>") getData("/WriteDataT<25>") getData("/WriteDataT<26>") getData("/WriteDataT<27>") getData("/WriteDataT<28>") getData("/WriteDataT<29>") getData("/WriteDataT<2>") getData("/WriteDataT<30>") getData("/WriteDataT<31>") getData("/WriteDataT<3>") getData("/WriteDataT<4>") getData("/WriteDataT<5>") getData("/WriteDataT<6>") getData("/WriteDataT<7>") getData("/WriteDataT<8>") getData("/WriteDataT<9>") getData("/vcc!") getData("/vdd!") getData("/~A<19:0>") getData("/~RW<1:0>") )
modelFile(
    '("/software/cadence/ncsu-FreePDK15/hspice_16nm_hp.include" "")
)
converge( 'ic "/RAckT<0>" "vdd" )
converge( 'ic "/RAckT<1>" "vdd" )
converge( 'ic "/RAckT<2>" "vdd" )
converge( 'ic "/RAckT<3>" "vdd" )
converge( 'ic "/RAckT<4>" "vdd" )
converge( 'ic "/RAckT<5>" "vdd" )
converge( 'ic "/RAckT<6>" "vdd" )
converge( 'ic "/RAckT<7>" "vdd" )
converge( 'ic "/AT<0>" "0" )
converge( 'ic "/AT<1>" "0" )
converge( 'ic "/AT<2>" "0" )
converge( 'ic "/AT<3>" "0" )
converge( 'ic "/AT<4>" "0" )
converge( 'ic "/AT<5>" "0" )
converge( 'ic "/AT<6>" "0" )
converge( 'ic "/AT<7>" "0" )
converge( 'ic "/AT<8>" "0" )
converge( 'ic "/AT<9>" "0" )
converge( 'ic "/AT<10>" "0" )
converge( 'ic "/AT<11>" "0" )
converge( 'ic "/AT<12>" "0" )
converge( 'ic "/AT<13>" "0" )
converge( 'ic "/AT<14>" "0" )
converge( 'ic "/AT<15>" "0" )
converge( 'ic "/AT<16>" "0" )
converge( 'ic "/AT<17>" "0" )
converge( 'ic "/AT<18>" "0" )
converge( 'ic "/AT<19>" "0" )
converge( 'ic "/IBank/I0/I0/I0/I7/I3/Q0" "0" )
converge( 'ic "/IBank/I0/I0/I0/I7/I3/Q1" "vdd" )
delete( 'converge 'ic "/ReaDataT<0>" )
delete( 'converge 'ic "/ReaDataT<1>" )
delete( 'converge 'ic "/ReaDataT<2>" )
delete( 'converge 'ic "/ReaDataT<3>" )
delete( 'converge 'ic "/ReaDataT<4>" )
delete( 'converge 'ic "/ReaDataT<5>" )
delete( 'converge 'ic "/ReaDataT<6>" )
delete( 'converge 'ic "/ReaDataT<7>" )
delete( 'converge 'ic "/ReaDataT<8>" )
delete( 'converge 'ic "/ReaDataT<9>" )
delete( 'converge 'ic "/ReaDataT<10>" )
delete( 'converge 'ic "/ReaDataT<11>" )
delete( 'converge 'ic "/ReaDataT<12>" )
delete( 'converge 'ic "/ReaDataT<13>" )
delete( 'converge 'ic "/ReaDataT<14>" )
delete( 'converge 'ic "/ReaDataT<15>" )
delete( 'converge 'ic "/ReaDataT<16>" )
delete( 'converge 'ic "/ReaDataT<17>" )
delete( 'converge 'ic "/ReaDataT<18>" )
delete( 'converge 'ic "/ReaDataT<19>" )
delete( 'converge 'ic "/ReaDataT<20>" )
delete( 'converge 'ic "/ReaDataT<21>" )
delete( 'converge 'ic "/ReaDataT<22>" )
delete( 'converge 'ic "/ReaDataT<23>" )
delete( 'converge 'ic "/ReaDataT<24>" )
delete( 'converge 'ic "/ReaDataT<25>" )
delete( 'converge 'ic "/ReaDataT<26>" )
delete( 'converge 'ic "/ReaDataT<27>" )
delete( 'converge 'ic "/ReaDataT<28>" )
delete( 'converge 'ic "/ReaDataT<29>" )
delete( 'converge 'ic "/ReaDataT<30>" )
delete( 'converge 'ic "/ReaDataT<31>" )
run()
selectResult( 'tran )
plot(getData("/A<19:0>") getData("/AT<0>") getData("/AT<10>") getData("/AT<11>") getData("/AT<12>") getData("/AT<13>") getData("/AT<14>") getData("/AT<15>") getData("/AT<16>") getData("/AT<17>") getData("/AT<18>") getData("/AT<19>") getData("/AT<1>") getData("/AT<2>") getData("/AT<3>") getData("/AT<4>") getData("/AT<5>") getData("/AT<6>") getData("/AT<7>") getData("/AT<8>") getData("/AT<9>") getData("/Ack") getData("/AckT") getData("/IBank/B0_1<0>") getData("/IBank/B0_1<1>") getData("/IBank/B0_1<2>") getData("/IBank/B0_1<3>") getData("/IBank/B1_1<0>") getData("/IBank/B1_1<1>") getData("/IBank/B1_1<2>") getData("/IBank/B1_1<3>") getData("/IBank/G01") getData("/IBank/I20/B0p<0>") getData("/IBank/I20/B0p<1>") getData("/IBank/I20/B0p<2>") getData("/IBank/I20/B0p<3>") getData("/IBank/I20/B1p<0>") getData("/IBank/I20/B1p<1>") getData("/IBank/I20/B1p<2>") getData("/IBank/I20/B1p<3>") getData("/IBank/I20/R0p<0>") getData("/IBank/I20/R0p<1>") getData("/IBank/I20/R0p<2>") getData("/IBank/I20/R0p<3>") getData("/IBank/I20/R1p<0>") getData("/IBank/I20/R1p<1>") getData("/IBank/I20/R1p<2>") getData("/IBank/I20/R1p<3>") getData("/IBank/I20/Wen") getData("/IBank/RD_Ack<1:0>") getData("/IBank/W0_1<0>") getData("/IBank/W0_1<1>") getData("/IBank/W0_1<2>") getData("/IBank/W0_1<3>") getData("/IBank/W1_1<0>") getData("/IBank/W1_1<1>") getData("/IBank/W1_1<2>") getData("/IBank/W1_1<3>") getData("/IBank/~R0_1<0>") getData("/IBank/~R0_1<1>") getData("/IBank/~R0_1<2>") getData("/IBank/~R0_1<3>") getData("/IBank/~R1_1<0>") getData("/IBank/~R1_1<1>") getData("/IBank/~R1_1<2>") getData("/IBank/~R1_1<3>") getData("/RD_Ack<7:0>") getData("/RW<1:0>") getData("/RWT<0>") getData("/RWT<1>") getData("/ReaDataT<0>") getData("/ReaDataT<1>") getData("/ReaDataT<2>") getData("/ReaDataT<3>") getData("/ReaDataT<4>") getData("/ReaDataT<5>") getData("/ReaDataT<6>") getData("/ReaDataT<7>") getData("/ReadData<31:0>") getData("/V0/MINUS") getData("/V0/PLUS") getData("/V1/MINUS") getData("/V1/PLUS") getData("/WAck<0>") getData("/WAck<1>") getData("/WriteAck<7:0>") getData("/WriteData<31:0>") getData("/WriteDataT<0>") getData("/WriteDataT<10>") getData("/WriteDataT<11>") getData("/WriteDataT<12>") getData("/WriteDataT<13>") getData("/WriteDataT<14>") getData("/WriteDataT<15>") getData("/WriteDataT<16>") getData("/WriteDataT<17>") getData("/WriteDataT<18>") getData("/WriteDataT<19>") getData("/WriteDataT<1>") getData("/WriteDataT<20>") getData("/WriteDataT<21>") getData("/WriteDataT<22>") getData("/WriteDataT<23>") getData("/WriteDataT<24>") getData("/WriteDataT<25>") getData("/WriteDataT<26>") getData("/WriteDataT<27>") getData("/WriteDataT<28>") getData("/WriteDataT<29>") getData("/WriteDataT<2>") getData("/WriteDataT<30>") getData("/WriteDataT<31>") getData("/WriteDataT<3>") getData("/WriteDataT<4>") getData("/WriteDataT<5>") getData("/WriteDataT<6>") getData("/WriteDataT<7>") getData("/WriteDataT<8>") getData("/WriteDataT<9>") getData("/vcc!") getData("/vdd!") getData("/~A<19:0>") getData("/~RW<1:0>") )
modelFile(
    '("/software/cadence/ncsu-FreePDK15/hspice_16nm_hp.include" "")
)
run()
selectResult( 'tran )
plot(getData("/A<19:0>") getData("/AT<0>") getData("/AT<10>") getData("/AT<11>") getData("/AT<12>") getData("/AT<13>") getData("/AT<14>") getData("/AT<15>") getData("/AT<16>") getData("/AT<17>") getData("/AT<18>") getData("/AT<19>") getData("/AT<1>") getData("/AT<2>") getData("/AT<3>") getData("/AT<4>") getData("/AT<5>") getData("/AT<6>") getData("/AT<7>") getData("/AT<8>") getData("/AT<9>") getData("/Ack") getData("/AckT") getData("/IBank/B0_1<0>") getData("/IBank/B0_1<1>") getData("/IBank/B0_1<2>") getData("/IBank/B0_1<3>") getData("/IBank/B1_1<0>") getData("/IBank/B1_1<1>") getData("/IBank/B1_1<2>") getData("/IBank/B1_1<3>") getData("/IBank/G01") getData("/IBank/I20/B0p<0>") getData("/IBank/I20/B0p<1>") getData("/IBank/I20/B0p<2>") getData("/IBank/I20/B0p<3>") getData("/IBank/I20/B1p<0>") getData("/IBank/I20/B1p<1>") getData("/IBank/I20/B1p<2>") getData("/IBank/I20/B1p<3>") getData("/IBank/I20/R0p<0>") getData("/IBank/I20/R0p<1>") getData("/IBank/I20/R0p<2>") getData("/IBank/I20/R0p<3>") getData("/IBank/I20/R1p<0>") getData("/IBank/I20/R1p<1>") getData("/IBank/I20/R1p<2>") getData("/IBank/I20/R1p<3>") getData("/IBank/I20/Wen") getData("/IBank/RD_Ack<1:0>") getData("/IBank/W0_1<0>") getData("/IBank/W0_1<1>") getData("/IBank/W0_1<2>") getData("/IBank/W0_1<3>") getData("/IBank/W1_1<0>") getData("/IBank/W1_1<1>") getData("/IBank/W1_1<2>") getData("/IBank/W1_1<3>") getData("/IBank/~R0_1<0>") getData("/IBank/~R0_1<1>") getData("/IBank/~R0_1<2>") getData("/IBank/~R0_1<3>") getData("/IBank/~R1_1<0>") getData("/IBank/~R1_1<1>") getData("/IBank/~R1_1<2>") getData("/IBank/~R1_1<3>") getData("/RD_Ack<7:0>") getData("/RW<1:0>") getData("/RWT<0>") getData("/RWT<1>") getData("/ReaDataT<0>") getData("/ReaDataT<1>") getData("/ReaDataT<2>") getData("/ReaDataT<3>") getData("/ReaDataT<4>") getData("/ReaDataT<5>") getData("/ReaDataT<6>") getData("/ReaDataT<7>") getData("/ReadData<31:0>") getData("/V0/MINUS") getData("/V0/PLUS") getData("/V1/MINUS") getData("/V1/PLUS") getData("/WAck<0>") getData("/WAck<1>") getData("/WriteAck<7:0>") getData("/WriteData<31:0>") getData("/WriteDataT<0>") getData("/WriteDataT<10>") getData("/WriteDataT<11>") getData("/WriteDataT<12>") getData("/WriteDataT<13>") getData("/WriteDataT<14>") getData("/WriteDataT<15>") getData("/WriteDataT<16>") getData("/WriteDataT<17>") getData("/WriteDataT<18>") getData("/WriteDataT<19>") getData("/WriteDataT<1>") getData("/WriteDataT<20>") getData("/WriteDataT<21>") getData("/WriteDataT<22>") getData("/WriteDataT<23>") getData("/WriteDataT<24>") getData("/WriteDataT<25>") getData("/WriteDataT<26>") getData("/WriteDataT<27>") getData("/WriteDataT<28>") getData("/WriteDataT<29>") getData("/WriteDataT<2>") getData("/WriteDataT<30>") getData("/WriteDataT<31>") getData("/WriteDataT<3>") getData("/WriteDataT<4>") getData("/WriteDataT<5>") getData("/WriteDataT<6>") getData("/WriteDataT<7>") getData("/WriteDataT<8>") getData("/WriteDataT<9>") getData("/vcc!") getData("/vdd!") getData("/~A<19:0>") getData("/~RW<1:0>") )
modelFile(
    '("/software/cadence/ncsu-FreePDK15/hspice_16nm_hp.include" "")
)
desVar(	  "vdd" .850	)
converge( 'ic "/RWT<0>" "0" )
converge( 'ic "/RWT<1>" "0" )
converge( 'ic "/net018<4>" "vdd" )
converge( 'ic "/net018<3>" "vdd" )
converge( 'ic "/net018<2>" "vdd" )
converge( 'ic "/net018<1>" "vdd" )
converge( 'ic "/net018<0>" "vdd" )
converge( 'ic "/AckT" "vdd" )
run()
selectResult( 'tran )
plot(getData("/A<19:0>") getData("/AT<0>") getData("/AT<10>") getData("/AT<11>") getData("/AT<12>") getData("/AT<13>") getData("/AT<14>") getData("/AT<15>") getData("/AT<16>") getData("/AT<17>") getData("/AT<18>") getData("/AT<19>") getData("/AT<1>") getData("/AT<2>") getData("/AT<3>") getData("/AT<4>") getData("/AT<5>") getData("/AT<6>") getData("/AT<7>") getData("/AT<8>") getData("/AT<9>") getData("/Ack") getData("/AckT") getData("/IBank/B0_1<0>") getData("/IBank/B0_1<1>") getData("/IBank/B0_1<2>") getData("/IBank/B0_1<3>") getData("/IBank/B1_1<0>") getData("/IBank/B1_1<1>") getData("/IBank/B1_1<2>") getData("/IBank/B1_1<3>") getData("/IBank/G01") getData("/IBank/I20/B0p<0>") getData("/IBank/I20/B0p<1>") getData("/IBank/I20/B0p<2>") getData("/IBank/I20/B0p<3>") getData("/IBank/I20/B1p<0>") getData("/IBank/I20/B1p<1>") getData("/IBank/I20/B1p<2>") getData("/IBank/I20/B1p<3>") getData("/IBank/I20/R0p<0>") getData("/IBank/I20/R0p<1>") getData("/IBank/I20/R0p<2>") getData("/IBank/I20/R0p<3>") getData("/IBank/I20/R1p<0>") getData("/IBank/I20/R1p<1>") getData("/IBank/I20/R1p<2>") getData("/IBank/I20/R1p<3>") getData("/IBank/I20/Wen") getData("/IBank/RD_Ack<1:0>") getData("/IBank/W0_1<0>") getData("/IBank/W0_1<1>") getData("/IBank/W0_1<2>") getData("/IBank/W0_1<3>") getData("/IBank/W1_1<0>") getData("/IBank/W1_1<1>") getData("/IBank/W1_1<2>") getData("/IBank/W1_1<3>") getData("/IBank/~R0_1<0>") getData("/IBank/~R0_1<1>") getData("/IBank/~R0_1<2>") getData("/IBank/~R0_1<3>") getData("/IBank/~R1_1<0>") getData("/IBank/~R1_1<1>") getData("/IBank/~R1_1<2>") getData("/IBank/~R1_1<3>") getData("/RD_Ack<7:0>") getData("/RW<1:0>") getData("/RWT<0>") getData("/RWT<1>") getData("/ReaDataT<0>") getData("/ReaDataT<1>") getData("/ReaDataT<2>") getData("/ReaDataT<3>") getData("/ReaDataT<4>") getData("/ReaDataT<5>") getData("/ReaDataT<6>") getData("/ReaDataT<7>") getData("/ReadData<31:0>") getData("/V0/MINUS") getData("/V0/PLUS") getData("/V1/MINUS") getData("/V1/PLUS") getData("/WAck<0>") getData("/WAck<1>") getData("/WriteAck<7:0>") getData("/WriteData<31:0>") getData("/WriteDataT<0>") getData("/WriteDataT<10>") getData("/WriteDataT<11>") getData("/WriteDataT<12>") getData("/WriteDataT<13>") getData("/WriteDataT<14>") getData("/WriteDataT<15>") getData("/WriteDataT<16>") getData("/WriteDataT<17>") getData("/WriteDataT<18>") getData("/WriteDataT<19>") getData("/WriteDataT<1>") getData("/WriteDataT<20>") getData("/WriteDataT<21>") getData("/WriteDataT<22>") getData("/WriteDataT<23>") getData("/WriteDataT<24>") getData("/WriteDataT<25>") getData("/WriteDataT<26>") getData("/WriteDataT<27>") getData("/WriteDataT<28>") getData("/WriteDataT<29>") getData("/WriteDataT<2>") getData("/WriteDataT<30>") getData("/WriteDataT<31>") getData("/WriteDataT<3>") getData("/WriteDataT<4>") getData("/WriteDataT<5>") getData("/WriteDataT<6>") getData("/WriteDataT<7>") getData("/WriteDataT<8>") getData("/WriteDataT<9>") getData("/vcc!") getData("/vdd!") getData("/~A<19:0>") getData("/~RW<1:0>") )
modelFile(
    '("/software/cadence/ncsu-FreePDK15/hspice_16nm_hp.include" "")
)
analysis('tran ?stop "6n "  )
converge( 'ic "/IBank/I20/nOr<0>" "0" )
converge( 'ic "/IBank/I20/nOr<1>" "0" )
converge( 'ic "/IBank/I20/nOr<2>" "0" )
converge( 'ic "/IBank/I20/nOr<3>" "0" )
converge( 'ic "/IBank/I20/nOr<4>" "0" )
converge( 'ic "/IBank/I20/nOr<5>" "0" )
converge( 'ic "/IBank/I20/nOr<6>" "0" )
converge( 'ic "/IBank/I20/nOr<7>" "0" )
converge( 'ic "/IBank/I20/B1p<0>" "0" )
converge( 'ic "/IBank/I20/B0p<0>" "0" )
converge( 'ic "/IBank/I20/B1p<1>" "0" )
converge( 'ic "/IBank/I20/B0p<1>" "0" )
converge( 'ic "/IBank/I20/B1p<2>" "0" )
converge( 'ic "/IBank/I20/B0p<2>" "0" )
converge( 'ic "/IBank/I20/B1p<3>" "0" )
converge( 'ic "/IBank/I20/B0p<3>" "0" )
converge( 'ic "/IBank/B1_1<0>" "0" )
converge( 'ic "/IBank/B0_1<0>" "0" )
converge( 'ic "/IBank/B1_1<1>" "0" )
converge( 'ic "/IBank/B0_1<1>" "0" )
converge( 'ic "/IBank/B1_1<2>" "0" )
converge( 'ic "/IBank/B0_1<2>" "0" )
converge( 'ic "/IBank/B1_1<3>" "0" )
converge( 'ic "/IBank/B0_1<3>" "0" )
converge( 'ic "/IBank/I20/Wen" "0" )
converge( 'ic "/IBank/I20/net063" "vdd" )
converge( 'ic "/IBank/I20/net053" "vdd" )
converge( 'ic "/IBank/I20/net056" "vdd" )
converge( 'ic "/IBank/I20/net052" "vdd" )
converge( 'ic "/IBank/I20/wack<0>" "vdd" )
converge( 'ic "/IBank/I20/wack<1>" "vdd" )
converge( 'ic "/IBank/I20/wack<2>" "vdd" )
converge( 'ic "/IBank/I20/wack<3>" "vdd" )
converge( 'ic "/WAck<0>" "vdd" )
converge( 'ic "/WAck<1>" "vdd" )
converge( 'ic "/IBank/ValAddr" "0" )
converge( 'ic "/IBank/I20/net030" "vdd" )
converge( 'ic "/IBank/~R1_1<0>" "vdd" )
converge( 'ic "/IBank/~R1_1<1>" "vdd" )
converge( 'ic "/IBank/~R1_1<2>" "vdd" )
converge( 'ic "/IBank/~R1_1<3>" "vdd" )
converge( 'ic "/IBank/~R0_1<0>" "vdd" )
converge( 'ic "/IBank/~R0_1<1>" "vdd" )
converge( 'ic "/IBank/~R0_1<2>" "vdd" )
converge( 'ic "/IBank/~R0_1<3>" "vdd" )
converge( 'ic "/IBank/I20/R1<0>" "0" )
converge( 'ic "/IBank/I20/R1<1>" "0" )
converge( 'ic "/IBank/I20/R1<2>" "0" )
converge( 'ic "/IBank/I20/R1<3>" "0" )
converge( 'ic "/IBank/I20/R0<0>" "0" )
converge( 'ic "/IBank/I20/R0<1>" "0" )
converge( 'ic "/IBank/I20/R0<2>" "0" )
converge( 'ic "/IBank/I20/R0<3>" "0" )
converge( 'ic "/IBank/I20/R0p<0>" "0" )
converge( 'ic "/IBank/I20/R0p<1>" "0" )
converge( 'ic "/IBank/I20/R0p<2>" "0" )
converge( 'ic "/IBank/I20/R0p<3>" "0" )
converge( 'ic "/IBank/I20/R1p<0>" "0" )
converge( 'ic "/IBank/I20/R1p<1>" "0" )
converge( 'ic "/IBank/I20/R1p<2>" "0" )
converge( 'ic "/IBank/I20/R1p<3>" "0" )
converge( 'ic "/IBank/G01" "0" )
converge( 'ic "/IBank/I20/Rack<0>" "vdd" )
converge( 'ic "/IBank/I20/Rack<1>" "vdd" )
converge( 'ic "/IBank/I20/Rack<2>" "vdd" )
converge( 'ic "/IBank/I20/Rack<3>" "vdd" )
converge( 'ic "/IBank/I20/RAckp<0>" "0" )
converge( 'ic "/IBank/I20/RAckp<1>" "0" )
converge( 'ic "/IBank/I20/RAckp<2>" "0" )
converge( 'ic "/IBank/I20/RAckp<3>" "0" )
run()
selectResult( 'tran )
plot(getData("/IBank/I20/Out0<3>") getData("/IBank/I20/Out0<2>") getData("/IBank/I20/Out0<1>") getData("/IBank/I20/Out0<0>") getData("/IBank/I20/Out1<3>") getData("/IBank/I20/Out1<2>") getData("/IBank/I20/Out1<1>") getData("/IBank/I20/Out1<0>") getData("/vdd!") getData("/WriteDataT<9>") getData("/WriteDataT<8>") getData("/WriteDataT<7>") getData("/WriteDataT<6>") getData("/WriteDataT<5>") getData("/WriteDataT<4>") getData("/WriteDataT<3>") getData("/WriteDataT<31>") getData("/WriteDataT<30>") getData("/WriteDataT<2>") getData("/WriteDataT<29>") getData("/WriteDataT<28>") getData("/WriteDataT<27>") getData("/WriteDataT<26>") getData("/WriteDataT<25>") getData("/WriteDataT<24>") getData("/WriteDataT<23>") getData("/WriteDataT<22>") getData("/WriteDataT<21>") getData("/WriteDataT<20>") getData("/WriteDataT<1>") getData("/WriteDataT<19>") getData("/WriteDataT<18>") getData("/WriteDataT<17>") getData("/WriteDataT<16>") getData("/WriteDataT<15>") getData("/WriteDataT<14>") getData("/WriteDataT<13>") getData("/WriteDataT<12>") getData("/WriteDataT<11>") getData("/WriteDataT<10>") getData("/WriteDataT<0>") getData("/WriteData<31:0>") getData("/WriteAck<7:0>") getData("/WAck<1>") getData("/WAck<0>") getData("/V1/PLUS") getData("/V1/MINUS") getData("/V0/PLUS") getData("/V0/MINUS") getData("/ReadData<31:0>") getData("/ReaDataT<7>") getData("/ReaDataT<6>") getData("/ReaDataT<5>") getData("/ReaDataT<4>") getData("/ReaDataT<3>") getData("/ReaDataT<2>") getData("/ReaDataT<1>") getData("/ReaDataT<0>") getData("/RWT<1>") getData("/RWT<0>") getData("/RW<1:0>") getData("/RD_Ack<7:0>") getData("/IBank/~R1_1<3>") getData("/IBank/~R1_1<2>") getData("/IBank/~R1_1<1>") getData("/IBank/~R1_1<0>") getData("/IBank/~R0_1<3>") getData("/IBank/~R0_1<2>") getData("/IBank/~R0_1<1>") getData("/IBank/~R0_1<0>") getData("/IBank/W1_1<3>") getData("/IBank/W1_1<2>") getData("/IBank/W1_1<1>") getData("/IBank/W1_1<0>") getData("/IBank/W0_1<3>") getData("/IBank/W0_1<2>") getData("/IBank/W0_1<1>") getData("/IBank/W0_1<0>") getData("/IBank/S_1<7>") getData("/IBank/S_1<6>") getData("/IBank/S_1<5>") getData("/IBank/S_1<4>") getData("/IBank/S_1<3>") getData("/IBank/S_1<2>") getData("/IBank/S_1<1>") getData("/IBank/S_1<0>") getData("/IBank/RD_Ack<1:0>") getData("/IBank/I20/Wen") getData("/IBank/I20/R1p<3>") getData("/IBank/I20/R1p<2>") getData("/IBank/I20/R1p<1>") getData("/IBank/I20/R1p<0>") getData("/IBank/I20/R0p<3>") getData("/IBank/I20/R0p<2>") getData("/IBank/I20/R0p<1>") getData("/IBank/I20/R0p<0>") getData("/IBank/I20/B1p<3>") getData("/IBank/I20/B1p<2>") getData("/IBank/I20/B1p<1>") getData("/IBank/I20/B1p<0>") getData("/IBank/I20/B0p<3>") getData("/IBank/I20/B0p<2>") getData("/IBank/I20/B0p<1>") getData("/IBank/I20/B0p<0>") getData("/IBank/G01") getData("/IBank/B1_1<3>") getData("/IBank/B1_1<2>") getData("/IBank/B1_1<1>") getData("/IBank/B1_1<0>") getData("/IBank/B0_1<3>") getData("/IBank/B0_1<2>") getData("/IBank/B0_1<1>") getData("/IBank/B0_1<0>") getData("/AckT") getData("/Ack") getData("/AT<9>") getData("/AT<8>") getData("/AT<7>") getData("/AT<6>") getData("/AT<5>") getData("/AT<4>") getData("/AT<3>") getData("/AT<2>") getData("/AT<1>") getData("/AT<19>") getData("/AT<18>") getData("/AT<17>") getData("/AT<16>") getData("/AT<15>") getData("/AT<14>") getData("/AT<13>") getData("/AT<12>") getData("/AT<11>") getData("/AT<10>") getData("/AT<0>") getData("/A<19:0>") getData("/IBank/A_1<63>") getData("/IBank/A_1<62>") getData("/IBank/A_1<61>") getData("/IBank/A_1<60>") getData("/IBank/A_1<59>") getData("/IBank/A_1<58>") getData("/IBank/A_1<57>") getData("/IBank/A_1<56>") getData("/IBank/A_1<55>") getData("/IBank/A_1<54>") getData("/IBank/A_1<53>") getData("/IBank/A_1<52>") getData("/IBank/A_1<51>") getData("/IBank/A_1<50>") getData("/IBank/A_1<49>") getData("/IBank/A_1<48>") getData("/IBank/A_1<47>") getData("/IBank/A_1<46>") getData("/IBank/A_1<45>") getData("/IBank/A_1<44>") getData("/IBank/A_1<43>") getData("/IBank/A_1<42>") getData("/IBank/A_1<41>") getData("/IBank/A_1<40>") getData("/IBank/A_1<39>") getData("/IBank/A_1<38>") getData("/IBank/A_1<37>") getData("/IBank/A_1<36>") getData("/IBank/A_1<35>") getData("/IBank/A_1<34>") getData("/IBank/A_1<33>") getData("/IBank/A_1<32>") getData("/IBank/A_1<31>") getData("/IBank/A_1<30>") getData("/IBank/A_1<29>") getData("/IBank/A_1<28>") getData("/IBank/A_1<27>") getData("/IBank/A_1<26>") getData("/IBank/A_1<25>") getData("/IBank/A_1<24>") getData("/IBank/A_1<23>") getData("/IBank/A_1<22>") getData("/IBank/A_1<21>") getData("/IBank/A_1<20>") getData("/IBank/A_1<19>") getData("/IBank/A_1<18>") getData("/IBank/A_1<17>") getData("/IBank/A_1<16>") getData("/IBank/A_1<15>") getData("/IBank/A_1<14>") getData("/IBank/A_1<13>") getData("/IBank/A_1<12>") getData("/IBank/A_1<11>") getData("/IBank/A_1<10>") getData("/IBank/A_1<9>") getData("/IBank/A_1<8>") getData("/IBank/A_1<7>") getData("/IBank/A_1<6>") getData("/IBank/A_1<5>") getData("/IBank/A_1<4>") getData("/IBank/A_1<3>") getData("/IBank/A_1<2>") getData("/IBank/A_1<1>") getData("/IBank/A_1<0>") )
modelFile(
    '("/software/cadence/ncsu-FreePDK15/hspice_16nm_hp.include" "")
)
desVar(	  "vdd" .7	)
run()
selectResult( 'tran )
plot(getData("/vdd!") getData("/WriteDataT<9>") getData("/WriteDataT<8>") getData("/WriteDataT<7>") getData("/WriteDataT<6>") getData("/WriteDataT<5>") getData("/WriteDataT<4>") getData("/WriteDataT<3>") getData("/WriteDataT<31>") getData("/WriteDataT<30>") getData("/WriteDataT<2>") getData("/WriteDataT<29>") getData("/WriteDataT<28>") getData("/WriteDataT<27>") getData("/WriteDataT<26>") getData("/WriteDataT<25>") getData("/WriteDataT<24>") getData("/WriteDataT<23>") getData("/WriteDataT<22>") getData("/WriteDataT<21>") getData("/WriteDataT<20>") getData("/WriteDataT<1>") getData("/WriteDataT<19>") getData("/WriteDataT<18>") getData("/WriteDataT<17>") getData("/WriteDataT<16>") getData("/WriteDataT<15>") getData("/WriteDataT<14>") getData("/WriteDataT<13>") getData("/WriteDataT<12>") getData("/WriteDataT<11>") getData("/WriteDataT<10>") getData("/WriteDataT<0>") getData("/WriteData<31:0>") getData("/WriteAck<7:0>") getData("/WAck<1>") getData("/WAck<0>") getData("/V1/PLUS") getData("/V1/MINUS") getData("/V0/PLUS") getData("/V0/MINUS") getData("/ReadData<31:0>") getData("/ReaDataT<7>") getData("/ReaDataT<6>") getData("/ReaDataT<5>") getData("/ReaDataT<4>") getData("/ReaDataT<3>") getData("/ReaDataT<2>") getData("/ReaDataT<1>") getData("/ReaDataT<0>") getData("/RWT<1>") getData("/RWT<0>") getData("/RW<1:0>") getData("/RD_Ack<7:0>") getData("/IBank/~R1_1<3>") getData("/IBank/~R1_1<2>") getData("/IBank/~R1_1<1>") getData("/IBank/~R1_1<0>") getData("/IBank/~R0_1<3>") getData("/IBank/~R0_1<2>") getData("/IBank/~R0_1<1>") getData("/IBank/~R0_1<0>") getData("/IBank/W1_1<3>") getData("/IBank/W1_1<2>") getData("/IBank/W1_1<1>") getData("/IBank/W1_1<0>") getData("/IBank/W0_1<3>") getData("/IBank/W0_1<2>") getData("/IBank/W0_1<1>") getData("/IBank/W0_1<0>") getData("/IBank/S_1<7>") getData("/IBank/S_1<6>") getData("/IBank/S_1<5>") getData("/IBank/S_1<4>") getData("/IBank/S_1<3>") getData("/IBank/S_1<2>") getData("/IBank/S_1<1>") getData("/IBank/S_1<0>") getData("/IBank/RD_Ack<1:0>") getData("/IBank/I20/Wen") getData("/IBank/I20/R1p<3>") getData("/IBank/I20/R1p<2>") getData("/IBank/I20/R1p<1>") getData("/IBank/I20/R1p<0>") getData("/IBank/I20/R0p<3>") getData("/IBank/I20/R0p<2>") getData("/IBank/I20/R0p<1>") getData("/IBank/I20/R0p<0>") getData("/IBank/I20/B1p<3>") getData("/IBank/I20/B1p<2>") getData("/IBank/I20/B1p<1>") getData("/IBank/I20/B1p<0>") getData("/IBank/I20/B0p<3>") getData("/IBank/I20/B0p<2>") getData("/IBank/I20/B0p<1>") getData("/IBank/I20/B0p<0>") getData("/IBank/G01") getData("/IBank/B1_1<3>") getData("/IBank/B1_1<2>") getData("/IBank/B1_1<1>") getData("/IBank/B1_1<0>") getData("/IBank/B0_1<3>") getData("/IBank/B0_1<2>") getData("/IBank/B0_1<1>") getData("/IBank/B0_1<0>") getData("/AckT") getData("/Ack") getData("/AT<9>") getData("/AT<8>") getData("/AT<7>") getData("/AT<6>") getData("/AT<5>") getData("/AT<4>") getData("/AT<3>") getData("/AT<2>") getData("/AT<1>") getData("/AT<19>") getData("/AT<18>") getData("/AT<17>") getData("/AT<16>") getData("/AT<15>") getData("/AT<14>") getData("/AT<13>") getData("/AT<12>") getData("/AT<11>") getData("/AT<10>") getData("/AT<0>") getData("/A<19:0>") getData("/IBank/A_1<63>") getData("/IBank/A_1<62>") getData("/IBank/A_1<61>") getData("/IBank/A_1<60>") getData("/IBank/A_1<59>") getData("/IBank/A_1<58>") getData("/IBank/A_1<57>") getData("/IBank/A_1<56>") getData("/IBank/A_1<55>") getData("/IBank/A_1<54>") getData("/IBank/A_1<53>") getData("/IBank/A_1<52>") getData("/IBank/A_1<51>") getData("/IBank/A_1<50>") getData("/IBank/A_1<49>") getData("/IBank/A_1<48>") getData("/IBank/A_1<47>") getData("/IBank/A_1<46>") getData("/IBank/A_1<45>") getData("/IBank/A_1<44>") getData("/IBank/A_1<43>") getData("/IBank/A_1<42>") getData("/IBank/A_1<41>") getData("/IBank/A_1<40>") getData("/IBank/A_1<39>") getData("/IBank/A_1<38>") getData("/IBank/A_1<37>") getData("/IBank/A_1<36>") getData("/IBank/A_1<35>") getData("/IBank/A_1<34>") getData("/IBank/A_1<33>") getData("/IBank/A_1<32>") getData("/IBank/A_1<31>") getData("/IBank/A_1<30>") getData("/IBank/A_1<29>") getData("/IBank/A_1<28>") getData("/IBank/A_1<27>") getData("/IBank/A_1<26>") getData("/IBank/A_1<25>") getData("/IBank/A_1<24>") getData("/IBank/A_1<23>") getData("/IBank/A_1<22>") getData("/IBank/A_1<21>") getData("/IBank/A_1<20>") getData("/IBank/A_1<19>") getData("/IBank/A_1<18>") getData("/IBank/A_1<17>") getData("/IBank/A_1<16>") getData("/IBank/A_1<15>") getData("/IBank/A_1<14>") getData("/IBank/A_1<13>") getData("/IBank/A_1<12>") getData("/IBank/A_1<11>") getData("/IBank/A_1<10>") getData("/IBank/A_1<9>") getData("/IBank/A_1<8>") getData("/IBank/A_1<7>") getData("/IBank/A_1<6>") getData("/IBank/A_1<5>") getData("/IBank/A_1<4>") getData("/IBank/A_1<3>") getData("/IBank/A_1<2>") getData("/IBank/A_1<1>") getData("/IBank/A_1<0>") getData("/IBank/I20/Out1<3>") getData("/IBank/I20/Out1<2>") getData("/IBank/I20/Out1<1>") getData("/IBank/I20/Out1<0>") getData("/IBank/I20/Out0<3>") getData("/IBank/I20/Out0<2>") getData("/IBank/I20/Out0<1>") getData("/IBank/I20/Out0<0>") )
modelFile(
    '("/software/cadence/ncsu-FreePDK15/hspice_16nm_hp.include" "")
)
save( 'i "/IBank/I20/I24/Lack" )
converge( 'ic "/IBank/I20/BpAck<0>" "vdd" )
converge( 'ic "/IBank/I20/BpAck<1>" "vdd" )
converge( 'ic "/IBank/I20/BpAck<2>" "vdd" )
converge( 'ic "/IBank/I20/BpAck<3>" "vdd" )
run()
selectResult( 'tran )
plot(getData("/vdd!") getData("/WriteDataT<9>") getData("/WriteDataT<8>") getData("/WriteDataT<7>") getData("/WriteDataT<6>") getData("/WriteDataT<5>") getData("/WriteDataT<4>") getData("/WriteDataT<3>") getData("/WriteDataT<31>") getData("/WriteDataT<30>") getData("/WriteDataT<2>") getData("/WriteDataT<29>") getData("/WriteDataT<28>") getData("/WriteDataT<27>") getData("/WriteDataT<26>") getData("/WriteDataT<25>") getData("/WriteDataT<24>") getData("/WriteDataT<23>") getData("/WriteDataT<22>") getData("/WriteDataT<21>") getData("/WriteDataT<20>") getData("/WriteDataT<1>") getData("/WriteDataT<19>") getData("/WriteDataT<18>") getData("/WriteDataT<17>") getData("/WriteDataT<16>") getData("/WriteDataT<15>") getData("/WriteDataT<14>") getData("/WriteDataT<13>") getData("/WriteDataT<12>") getData("/WriteDataT<11>") getData("/WriteDataT<10>") getData("/WriteDataT<0>") getData("/WriteData<31:0>") getData("/WriteAck<7:0>") getData("/WAck<1>") getData("/WAck<0>") getData("/V1/PLUS") getData("/V1/MINUS") getData("/V0/PLUS") getData("/V0/MINUS") getData("/ReadData<31:0>") getData("/ReaDataT<7>") getData("/ReaDataT<6>") getData("/ReaDataT<5>") getData("/ReaDataT<4>") getData("/ReaDataT<3>") getData("/ReaDataT<2>") getData("/ReaDataT<1>") getData("/ReaDataT<0>") getData("/RWT<1>") getData("/RWT<0>") getData("/RW<1:0>") getData("/RD_Ack<7:0>") getData("/IBank/~R1_1<3>") getData("/IBank/~R1_1<2>") getData("/IBank/~R1_1<1>") getData("/IBank/~R1_1<0>") getData("/IBank/~R0_1<3>") getData("/IBank/~R0_1<2>") getData("/IBank/~R0_1<1>") getData("/IBank/~R0_1<0>") getData("/IBank/W1_1<3>") getData("/IBank/W1_1<2>") getData("/IBank/W1_1<1>") getData("/IBank/W1_1<0>") getData("/IBank/W0_1<3>") getData("/IBank/W0_1<2>") getData("/IBank/W0_1<1>") getData("/IBank/W0_1<0>") getData("/IBank/S_1<7>") getData("/IBank/S_1<6>") getData("/IBank/S_1<5>") getData("/IBank/S_1<4>") getData("/IBank/S_1<3>") getData("/IBank/S_1<2>") getData("/IBank/S_1<1>") getData("/IBank/S_1<0>") getData("/IBank/I20/Wen") getData("/IBank/I20/R1p<3>") getData("/IBank/I20/R1p<2>") getData("/IBank/I20/R1p<1>") getData("/IBank/I20/R1p<0>") getData("/IBank/I20/R0p<3>") getData("/IBank/I20/R0p<2>") getData("/IBank/I20/R0p<1>") getData("/IBank/I20/R0p<0>") getData("/IBank/I20/B1p<3>") getData("/IBank/I20/B1p<2>") getData("/IBank/I20/B1p<1>") getData("/IBank/I20/B1p<0>") getData("/IBank/I20/B0p<3>") getData("/IBank/I20/B0p<2>") getData("/IBank/I20/B0p<1>") getData("/IBank/I20/B0p<0>") getData("/IBank/G01") getData("/IBank/B1_1<3>") getData("/IBank/B1_1<2>") getData("/IBank/B1_1<1>") getData("/IBank/B1_1<0>") getData("/IBank/B0_1<3>") getData("/IBank/B0_1<2>") getData("/IBank/B0_1<1>") getData("/IBank/B0_1<0>") getData("/AckT") getData("/Ack") getData("/AT<9>") getData("/AT<8>") getData("/AT<7>") getData("/AT<6>") getData("/AT<5>") getData("/AT<4>") getData("/AT<3>") getData("/AT<2>") getData("/AT<1>") getData("/AT<19>") getData("/AT<18>") getData("/AT<17>") getData("/AT<16>") getData("/AT<15>") getData("/AT<14>") getData("/AT<13>") getData("/AT<12>") getData("/AT<11>") getData("/AT<10>") getData("/AT<0>") getData("/A<19:0>") getData("/IBank/A_1<63>") getData("/IBank/A_1<62>") getData("/IBank/A_1<61>") getData("/IBank/A_1<60>") getData("/IBank/A_1<59>") getData("/IBank/A_1<58>") getData("/IBank/A_1<57>") getData("/IBank/A_1<56>") getData("/IBank/A_1<55>") getData("/IBank/A_1<54>") getData("/IBank/A_1<53>") getData("/IBank/A_1<52>") getData("/IBank/A_1<51>") getData("/IBank/A_1<50>") getData("/IBank/A_1<49>") getData("/IBank/A_1<48>") getData("/IBank/A_1<47>") getData("/IBank/A_1<46>") getData("/IBank/A_1<45>") getData("/IBank/A_1<44>") getData("/IBank/A_1<43>") getData("/IBank/A_1<42>") getData("/IBank/A_1<41>") getData("/IBank/A_1<40>") getData("/IBank/A_1<39>") getData("/IBank/A_1<38>") getData("/IBank/A_1<37>") getData("/IBank/A_1<36>") getData("/IBank/A_1<35>") getData("/IBank/A_1<34>") getData("/IBank/A_1<33>") getData("/IBank/A_1<32>") getData("/IBank/A_1<31>") getData("/IBank/A_1<30>") getData("/IBank/A_1<29>") getData("/IBank/A_1<28>") getData("/IBank/A_1<27>") getData("/IBank/A_1<26>") getData("/IBank/A_1<25>") getData("/IBank/A_1<24>") getData("/IBank/A_1<23>") getData("/IBank/A_1<22>") getData("/IBank/A_1<21>") getData("/IBank/A_1<20>") getData("/IBank/A_1<19>") getData("/IBank/A_1<18>") getData("/IBank/A_1<17>") getData("/IBank/A_1<16>") getData("/IBank/A_1<15>") getData("/IBank/A_1<14>") getData("/IBank/A_1<13>") getData("/IBank/A_1<12>") getData("/IBank/A_1<11>") getData("/IBank/A_1<10>") getData("/IBank/A_1<9>") getData("/IBank/A_1<8>") getData("/IBank/A_1<7>") getData("/IBank/A_1<6>") getData("/IBank/A_1<5>") getData("/IBank/A_1<4>") getData("/IBank/A_1<3>") getData("/IBank/A_1<2>") getData("/IBank/A_1<1>") getData("/IBank/A_1<0>") getData("/IBank/I20/Out1<3>") getData("/IBank/I20/Out1<2>") getData("/IBank/I20/Out1<1>") getData("/IBank/I20/Out1<0>") getData("/IBank/I20/Out0<3>") getData("/IBank/I20/Out0<2>") getData("/IBank/I20/Out0<1>") getData("/IBank/I20/Out0<0>") getData("/IBank/I20/BpAck<0>") getData("/IBank/I20/BpAck<1>") getData("/IBank/I20/BpAck<2>") getData("/IBank/I20/BpAck<3>") getData("/IBank/I20/wack<0>") getData("/IBank/I20/wack<1>") getData("/IBank/I20/wack<2>") getData("/IBank/I20/I24/Lack") getData("/IBank/I20/wack<3>") )
modelFile(
    '("/software/cadence/ncsu-FreePDK15/hspice_16nm_hp.include" "")
)
analysis('dc ?saveOppoint t  ?param "vdd"  ?start "0.3"
		?stop "1.5"  )
envOption(
	'analysisOrder  list("tran" "dc")
)
run()
selectResult( 'dc )
plot(getData("/vdd!") getData("/WriteDataT<9>") getData("/WriteDataT<8>") getData("/WriteDataT<7>") getData("/WriteDataT<6>") getData("/WriteDataT<5>") getData("/WriteDataT<4>") getData("/WriteDataT<3>") getData("/WriteDataT<31>") getData("/WriteDataT<30>") getData("/WriteDataT<2>") getData("/WriteDataT<29>") getData("/WriteDataT<28>") getData("/WriteDataT<27>") getData("/WriteDataT<26>") getData("/WriteDataT<25>") getData("/WriteDataT<24>") getData("/WriteDataT<23>") getData("/WriteDataT<22>") getData("/WriteDataT<21>") getData("/WriteDataT<20>") getData("/WriteDataT<1>") getData("/WriteDataT<19>") getData("/WriteDataT<18>") getData("/WriteDataT<17>") getData("/WriteDataT<16>") getData("/WriteDataT<15>") getData("/WriteDataT<14>") getData("/WriteDataT<13>") getData("/WriteDataT<12>") getData("/WriteDataT<11>") getData("/WriteDataT<10>") getData("/WriteDataT<0>") getData("/WriteData<31:0>") getData("/WriteAck<7:0>") getData("/WAck<1>") getData("/WAck<0>") getData("/V1/PLUS") getData("/V1/MINUS") getData("/V0/PLUS") getData("/V0/MINUS") getData("/ReadData<31:0>") getData("/ReaDataT<7>") getData("/ReaDataT<6>") getData("/ReaDataT<5>") getData("/ReaDataT<4>") getData("/ReaDataT<3>") getData("/ReaDataT<2>") getData("/ReaDataT<1>") getData("/ReaDataT<0>") getData("/RWT<1>") getData("/RWT<0>") getData("/RW<1:0>") getData("/RD_Ack<7:0>") getData("/IBank/~R1_1<3>") getData("/IBank/~R1_1<2>") getData("/IBank/~R1_1<1>") getData("/IBank/~R1_1<0>") getData("/IBank/~R0_1<3>") getData("/IBank/~R0_1<2>") getData("/IBank/~R0_1<1>") getData("/IBank/~R0_1<0>") getData("/IBank/W1_1<3>") getData("/IBank/W1_1<2>") getData("/IBank/W1_1<1>") getData("/IBank/W1_1<0>") getData("/IBank/W0_1<3>") getData("/IBank/W0_1<2>") getData("/IBank/W0_1<1>") getData("/IBank/W0_1<0>") getData("/IBank/S_1<7>") getData("/IBank/S_1<6>") getData("/IBank/S_1<5>") getData("/IBank/S_1<4>") getData("/IBank/S_1<3>") getData("/IBank/S_1<2>") getData("/IBank/S_1<1>") getData("/IBank/S_1<0>") getData("/IBank/I20/Wen") getData("/IBank/I20/R1p<3>") getData("/IBank/I20/R1p<2>") getData("/IBank/I20/R1p<1>") getData("/IBank/I20/R1p<0>") getData("/IBank/I20/R0p<3>") getData("/IBank/I20/R0p<2>") getData("/IBank/I20/R0p<1>") getData("/IBank/I20/R0p<0>") getData("/IBank/I20/B1p<3>") getData("/IBank/I20/B1p<2>") getData("/IBank/I20/B1p<1>") getData("/IBank/I20/B1p<0>") getData("/IBank/I20/B0p<3>") getData("/IBank/I20/B0p<2>") getData("/IBank/I20/B0p<1>") getData("/IBank/I20/B0p<0>") getData("/IBank/G01") getData("/IBank/B1_1<3>") getData("/IBank/B1_1<2>") getData("/IBank/B1_1<1>") getData("/IBank/B1_1<0>") getData("/IBank/B0_1<3>") getData("/IBank/B0_1<2>") getData("/IBank/B0_1<1>") getData("/IBank/B0_1<0>") getData("/AckT") getData("/Ack") getData("/AT<9>") getData("/AT<8>") getData("/AT<7>") getData("/AT<6>") getData("/AT<5>") getData("/AT<4>") getData("/AT<3>") getData("/AT<2>") getData("/AT<1>") getData("/AT<19>") getData("/AT<18>") getData("/AT<17>") getData("/AT<16>") getData("/AT<15>") getData("/AT<14>") getData("/AT<13>") getData("/AT<12>") getData("/AT<11>") getData("/AT<10>") getData("/AT<0>") getData("/A<19:0>") getData("/IBank/A_1<63>") getData("/IBank/A_1<62>") getData("/IBank/A_1<61>") getData("/IBank/A_1<60>") getData("/IBank/A_1<59>") getData("/IBank/A_1<58>") getData("/IBank/A_1<57>") getData("/IBank/A_1<56>") getData("/IBank/A_1<55>") getData("/IBank/A_1<54>") getData("/IBank/A_1<53>") getData("/IBank/A_1<52>") getData("/IBank/A_1<51>") getData("/IBank/A_1<50>") getData("/IBank/A_1<49>") getData("/IBank/A_1<48>") getData("/IBank/A_1<47>") getData("/IBank/A_1<46>") getData("/IBank/A_1<45>") getData("/IBank/A_1<44>") getData("/IBank/A_1<43>") getData("/IBank/A_1<42>") getData("/IBank/A_1<41>") getData("/IBank/A_1<40>") getData("/IBank/A_1<39>") getData("/IBank/A_1<38>") getData("/IBank/A_1<37>") getData("/IBank/A_1<36>") getData("/IBank/A_1<35>") getData("/IBank/A_1<34>") getData("/IBank/A_1<33>") getData("/IBank/A_1<32>") getData("/IBank/A_1<31>") getData("/IBank/A_1<30>") getData("/IBank/A_1<29>") getData("/IBank/A_1<28>") getData("/IBank/A_1<27>") getData("/IBank/A_1<26>") getData("/IBank/A_1<25>") getData("/IBank/A_1<24>") getData("/IBank/A_1<23>") getData("/IBank/A_1<22>") getData("/IBank/A_1<21>") getData("/IBank/A_1<20>") getData("/IBank/A_1<19>") getData("/IBank/A_1<18>") getData("/IBank/A_1<17>") getData("/IBank/A_1<16>") getData("/IBank/A_1<15>") getData("/IBank/A_1<14>") getData("/IBank/A_1<13>") getData("/IBank/A_1<12>") getData("/IBank/A_1<11>") getData("/IBank/A_1<10>") getData("/IBank/A_1<9>") getData("/IBank/A_1<8>") getData("/IBank/A_1<7>") getData("/IBank/A_1<6>") getData("/IBank/A_1<5>") getData("/IBank/A_1<4>") getData("/IBank/A_1<3>") getData("/IBank/A_1<2>") getData("/IBank/A_1<1>") getData("/IBank/A_1<0>") getData("/IBank/I20/Out1<3>") getData("/IBank/I20/Out1<2>") getData("/IBank/I20/Out1<1>") getData("/IBank/I20/Out1<0>") getData("/IBank/I20/Out0<3>") getData("/IBank/I20/Out0<2>") getData("/IBank/I20/Out0<1>") getData("/IBank/I20/Out0<0>") getData("/IBank/I20/BpAck<0>") getData("/IBank/I20/BpAck<1>") getData("/IBank/I20/BpAck<2>") getData("/IBank/I20/BpAck<3>") getData("/IBank/I20/wack<0>") getData("/IBank/I20/wack<1>") getData("/IBank/I20/wack<2>") getData("/IBank/I20/I24/Lack") getData("/IBank/I20/wack<3>") )
modelFile(
    '("/software/cadence/ncsu-FreePDK15/hspice_16nm_hp.include" "")
)
analysis('tran ?stop "6n "  ?errpreset "conservative"  )
run()
selectResult( 'tran )
plot(getData("/vdd!") getData("/WriteDataT<9>") getData("/WriteDataT<8>") getData("/WriteDataT<7>") getData("/WriteDataT<6>") getData("/WriteDataT<5>") getData("/WriteDataT<4>") getData("/WriteDataT<3>") getData("/WriteDataT<31>") getData("/WriteDataT<30>") getData("/WriteDataT<2>") getData("/WriteDataT<29>") getData("/WriteDataT<28>") getData("/WriteDataT<27>") getData("/WriteDataT<26>") getData("/WriteDataT<25>") getData("/WriteDataT<24>") getData("/WriteDataT<23>") getData("/WriteDataT<22>") getData("/WriteDataT<21>") getData("/WriteDataT<20>") getData("/WriteDataT<1>") getData("/WriteDataT<19>") getData("/WriteDataT<18>") getData("/WriteDataT<17>") getData("/WriteDataT<16>") getData("/WriteDataT<15>") getData("/WriteDataT<14>") getData("/WriteDataT<13>") getData("/WriteDataT<12>") getData("/WriteDataT<11>") getData("/WriteDataT<10>") getData("/WriteDataT<0>") getData("/WriteData<31:0>") getData("/WriteAck<7:0>") getData("/WAck<1>") getData("/WAck<0>") getData("/V1/PLUS") getData("/V1/MINUS") getData("/V0/PLUS") getData("/V0/MINUS") getData("/ReadData<31:0>") getData("/ReaDataT<7>") getData("/ReaDataT<6>") getData("/ReaDataT<5>") getData("/ReaDataT<4>") getData("/ReaDataT<3>") getData("/ReaDataT<2>") getData("/ReaDataT<1>") getData("/ReaDataT<0>") getData("/RWT<1>") getData("/RWT<0>") getData("/RW<1:0>") getData("/RD_Ack<7:0>") getData("/IBank/~R1_1<3>") getData("/IBank/~R1_1<2>") getData("/IBank/~R1_1<1>") getData("/IBank/~R1_1<0>") getData("/IBank/~R0_1<3>") getData("/IBank/~R0_1<2>") getData("/IBank/~R0_1<1>") getData("/IBank/~R0_1<0>") getData("/IBank/W1_1<3>") getData("/IBank/W1_1<2>") getData("/IBank/W1_1<1>") getData("/IBank/W1_1<0>") getData("/IBank/W0_1<3>") getData("/IBank/W0_1<2>") getData("/IBank/W0_1<1>") getData("/IBank/W0_1<0>") getData("/IBank/S_1<7>") getData("/IBank/S_1<6>") getData("/IBank/S_1<5>") getData("/IBank/S_1<4>") getData("/IBank/S_1<3>") getData("/IBank/S_1<2>") getData("/IBank/S_1<1>") getData("/IBank/S_1<0>") getData("/IBank/I20/Wen") getData("/IBank/I20/R1p<3>") getData("/IBank/I20/R1p<2>") getData("/IBank/I20/R1p<1>") getData("/IBank/I20/R1p<0>") getData("/IBank/I20/R0p<3>") getData("/IBank/I20/R0p<2>") getData("/IBank/I20/R0p<1>") getData("/IBank/I20/R0p<0>") getData("/IBank/I20/B1p<3>") getData("/IBank/I20/B1p<2>") getData("/IBank/I20/B1p<1>") getData("/IBank/I20/B1p<0>") getData("/IBank/I20/B0p<3>") getData("/IBank/I20/B0p<2>") getData("/IBank/I20/B0p<1>") getData("/IBank/I20/B0p<0>") getData("/IBank/G01") getData("/IBank/B1_1<3>") getData("/IBank/B1_1<2>") getData("/IBank/B1_1<1>") getData("/IBank/B1_1<0>") getData("/IBank/B0_1<3>") getData("/IBank/B0_1<2>") getData("/IBank/B0_1<1>") getData("/IBank/B0_1<0>") getData("/AckT") getData("/Ack") getData("/AT<9>") getData("/AT<8>") getData("/AT<7>") getData("/AT<6>") getData("/AT<5>") getData("/AT<4>") getData("/AT<3>") getData("/AT<2>") getData("/AT<1>") getData("/AT<19>") getData("/AT<18>") getData("/AT<17>") getData("/AT<16>") getData("/AT<15>") getData("/AT<14>") getData("/AT<13>") getData("/AT<12>") getData("/AT<11>") getData("/AT<10>") getData("/AT<0>") getData("/A<19:0>") getData("/IBank/A_1<63>") getData("/IBank/A_1<62>") getData("/IBank/A_1<61>") getData("/IBank/A_1<60>") getData("/IBank/A_1<59>") getData("/IBank/A_1<58>") getData("/IBank/A_1<57>") getData("/IBank/A_1<56>") getData("/IBank/A_1<55>") getData("/IBank/A_1<54>") getData("/IBank/A_1<53>") getData("/IBank/A_1<52>") getData("/IBank/A_1<51>") getData("/IBank/A_1<50>") getData("/IBank/A_1<49>") getData("/IBank/A_1<48>") getData("/IBank/A_1<47>") getData("/IBank/A_1<46>") getData("/IBank/A_1<45>") getData("/IBank/A_1<44>") getData("/IBank/A_1<43>") getData("/IBank/A_1<42>") getData("/IBank/A_1<41>") getData("/IBank/A_1<40>") getData("/IBank/A_1<39>") getData("/IBank/A_1<38>") getData("/IBank/A_1<37>") getData("/IBank/A_1<36>") getData("/IBank/A_1<35>") getData("/IBank/A_1<34>") getData("/IBank/A_1<33>") getData("/IBank/A_1<32>") getData("/IBank/A_1<31>") getData("/IBank/A_1<30>") getData("/IBank/A_1<29>") getData("/IBank/A_1<28>") getData("/IBank/A_1<27>") getData("/IBank/A_1<26>") getData("/IBank/A_1<25>") getData("/IBank/A_1<24>") getData("/IBank/A_1<23>") getData("/IBank/A_1<22>") getData("/IBank/A_1<21>") getData("/IBank/A_1<20>") getData("/IBank/A_1<19>") getData("/IBank/A_1<18>") getData("/IBank/A_1<17>") getData("/IBank/A_1<16>") getData("/IBank/A_1<15>") getData("/IBank/A_1<14>") getData("/IBank/A_1<13>") getData("/IBank/A_1<12>") getData("/IBank/A_1<11>") getData("/IBank/A_1<10>") getData("/IBank/A_1<9>") getData("/IBank/A_1<8>") getData("/IBank/A_1<7>") getData("/IBank/A_1<6>") getData("/IBank/A_1<5>") getData("/IBank/A_1<4>") getData("/IBank/A_1<3>") getData("/IBank/A_1<2>") getData("/IBank/A_1<1>") getData("/IBank/A_1<0>") getData("/IBank/I20/Out1<3>") getData("/IBank/I20/Out1<2>") getData("/IBank/I20/Out1<1>") getData("/IBank/I20/Out1<0>") getData("/IBank/I20/Out0<3>") getData("/IBank/I20/Out0<2>") getData("/IBank/I20/Out0<1>") getData("/IBank/I20/Out0<0>") getData("/IBank/I20/BpAck<0>") getData("/IBank/I20/BpAck<1>") getData("/IBank/I20/BpAck<2>") getData("/IBank/I20/BpAck<3>") getData("/IBank/I20/wack<0>") getData("/IBank/I20/wack<1>") getData("/IBank/I20/wack<2>") getData("/IBank/I20/I24/Lack") getData("/IBank/I20/wack<3>") )
modelFile(
    '("/software/cadence/ncsu-FreePDK15/hspice_16nm_hp.include" "")
)
run()
selectResult( 'tran )
plot(getData("/vdd!") getData("/WriteDataT<9>") getData("/WriteDataT<8>") getData("/WriteDataT<7>") getData("/WriteDataT<6>") getData("/WriteDataT<5>") getData("/WriteDataT<4>") getData("/WriteDataT<3>") getData("/WriteDataT<31>") getData("/WriteDataT<30>") getData("/WriteDataT<2>") getData("/WriteDataT<29>") getData("/WriteDataT<28>") getData("/WriteDataT<27>") getData("/WriteDataT<26>") getData("/WriteDataT<25>") getData("/WriteDataT<24>") getData("/WriteDataT<23>") getData("/WriteDataT<22>") getData("/WriteDataT<21>") getData("/WriteDataT<20>") getData("/WriteDataT<1>") getData("/WriteDataT<19>") getData("/WriteDataT<18>") getData("/WriteDataT<17>") getData("/WriteDataT<16>") getData("/WriteDataT<15>") getData("/WriteDataT<14>") getData("/WriteDataT<13>") getData("/WriteDataT<12>") getData("/WriteDataT<11>") getData("/WriteDataT<10>") getData("/WriteDataT<0>") getData("/WriteData<31:0>") getData("/WriteAck<7:0>") getData("/WAck<1>") getData("/WAck<0>") getData("/V1/PLUS") getData("/V1/MINUS") getData("/V0/PLUS") getData("/V0/MINUS") getData("/ReadData<31:0>") getData("/ReaDataT<7>") getData("/ReaDataT<6>") getData("/ReaDataT<5>") getData("/ReaDataT<4>") getData("/ReaDataT<3>") getData("/ReaDataT<2>") getData("/ReaDataT<1>") getData("/ReaDataT<0>") getData("/RWT<1>") getData("/RWT<0>") getData("/RW<1:0>") getData("/RD_Ack<7:0>") getData("/IBank/~R1_1<3>") getData("/IBank/~R1_1<2>") getData("/IBank/~R1_1<1>") getData("/IBank/~R1_1<0>") getData("/IBank/~R0_1<3>") getData("/IBank/~R0_1<2>") getData("/IBank/~R0_1<1>") getData("/IBank/~R0_1<0>") getData("/IBank/W1_1<3>") getData("/IBank/W1_1<2>") getData("/IBank/W1_1<1>") getData("/IBank/W1_1<0>") getData("/IBank/W0_1<3>") getData("/IBank/W0_1<2>") getData("/IBank/W0_1<1>") getData("/IBank/W0_1<0>") getData("/IBank/S_1<7>") getData("/IBank/S_1<6>") getData("/IBank/S_1<5>") getData("/IBank/S_1<4>") getData("/IBank/S_1<3>") getData("/IBank/S_1<2>") getData("/IBank/S_1<1>") getData("/IBank/S_1<0>") getData("/IBank/I20/Wen") getData("/IBank/I20/R1p<3>") getData("/IBank/I20/R1p<2>") getData("/IBank/I20/R1p<1>") getData("/IBank/I20/R1p<0>") getData("/IBank/I20/R0p<3>") getData("/IBank/I20/R0p<2>") getData("/IBank/I20/R0p<1>") getData("/IBank/I20/R0p<0>") getData("/IBank/I20/B1p<3>") getData("/IBank/I20/B1p<2>") getData("/IBank/I20/B1p<1>") getData("/IBank/I20/B1p<0>") getData("/IBank/I20/B0p<3>") getData("/IBank/I20/B0p<2>") getData("/IBank/I20/B0p<1>") getData("/IBank/I20/B0p<0>") getData("/IBank/G01") getData("/IBank/B1_1<3>") getData("/IBank/B1_1<2>") getData("/IBank/B1_1<1>") getData("/IBank/B1_1<0>") getData("/IBank/B0_1<3>") getData("/IBank/B0_1<2>") getData("/IBank/B0_1<1>") getData("/IBank/B0_1<0>") getData("/AckT") getData("/Ack") getData("/AT<9>") getData("/AT<8>") getData("/AT<7>") getData("/AT<6>") getData("/AT<5>") getData("/AT<4>") getData("/AT<3>") getData("/AT<2>") getData("/AT<1>") getData("/AT<19>") getData("/AT<18>") getData("/AT<17>") getData("/AT<16>") getData("/AT<15>") getData("/AT<14>") getData("/AT<13>") getData("/AT<12>") getData("/AT<11>") getData("/AT<10>") getData("/AT<0>") getData("/A<19:0>") getData("/IBank/A_1<63>") getData("/IBank/A_1<62>") getData("/IBank/A_1<61>") getData("/IBank/A_1<60>") getData("/IBank/A_1<59>") getData("/IBank/A_1<58>") getData("/IBank/A_1<57>") getData("/IBank/A_1<56>") getData("/IBank/A_1<55>") getData("/IBank/A_1<54>") getData("/IBank/A_1<53>") getData("/IBank/A_1<52>") getData("/IBank/A_1<51>") getData("/IBank/A_1<50>") getData("/IBank/A_1<49>") getData("/IBank/A_1<48>") getData("/IBank/A_1<47>") getData("/IBank/A_1<46>") getData("/IBank/A_1<45>") getData("/IBank/A_1<44>") getData("/IBank/A_1<43>") getData("/IBank/A_1<42>") getData("/IBank/A_1<41>") getData("/IBank/A_1<40>") getData("/IBank/A_1<39>") getData("/IBank/A_1<38>") getData("/IBank/A_1<37>") getData("/IBank/A_1<36>") getData("/IBank/A_1<35>") getData("/IBank/A_1<34>") getData("/IBank/A_1<33>") getData("/IBank/A_1<32>") getData("/IBank/A_1<31>") getData("/IBank/A_1<30>") getData("/IBank/A_1<29>") getData("/IBank/A_1<28>") getData("/IBank/A_1<27>") getData("/IBank/A_1<26>") getData("/IBank/A_1<25>") getData("/IBank/A_1<24>") getData("/IBank/A_1<23>") getData("/IBank/A_1<22>") getData("/IBank/A_1<21>") getData("/IBank/A_1<20>") getData("/IBank/A_1<19>") getData("/IBank/A_1<18>") getData("/IBank/A_1<17>") getData("/IBank/A_1<16>") getData("/IBank/A_1<15>") getData("/IBank/A_1<14>") getData("/IBank/A_1<13>") getData("/IBank/A_1<12>") getData("/IBank/A_1<11>") getData("/IBank/A_1<10>") getData("/IBank/A_1<9>") getData("/IBank/A_1<8>") getData("/IBank/A_1<7>") getData("/IBank/A_1<6>") getData("/IBank/A_1<5>") getData("/IBank/A_1<4>") getData("/IBank/A_1<3>") getData("/IBank/A_1<2>") getData("/IBank/A_1<1>") getData("/IBank/A_1<0>") getData("/IBank/I20/Out1<3>") getData("/IBank/I20/Out1<2>") getData("/IBank/I20/Out1<1>") getData("/IBank/I20/Out1<0>") getData("/IBank/I20/Out0<3>") getData("/IBank/I20/Out0<2>") getData("/IBank/I20/Out0<1>") getData("/IBank/I20/Out0<0>") getData("/IBank/I20/BpAck<0>") getData("/IBank/I20/BpAck<1>") getData("/IBank/I20/BpAck<2>") getData("/IBank/I20/BpAck<3>") getData("/IBank/I20/wack<0>") getData("/IBank/I20/wack<1>") getData("/IBank/I20/wack<2>") getData("/IBank/I20/I24/Lack") getData("/IBank/I20/wack<3>") )
modelFile(
    '("/software/cadence/ncsu-FreePDK15/hspice_16nm_hp.include" "")
)
run()
selectResult( 'tran )
plot(getData("/vdd!") getData("/WriteDataT<9>") getData("/WriteDataT<8>") getData("/WriteDataT<7>") getData("/WriteDataT<6>") getData("/WriteDataT<5>") getData("/WriteDataT<4>") getData("/WriteDataT<3>") getData("/WriteDataT<31>") getData("/WriteDataT<30>") getData("/WriteDataT<2>") getData("/WriteDataT<29>") getData("/WriteDataT<28>") getData("/WriteDataT<27>") getData("/WriteDataT<26>") getData("/WriteDataT<25>") getData("/WriteDataT<24>") getData("/WriteDataT<23>") getData("/WriteDataT<22>") getData("/WriteDataT<21>") getData("/WriteDataT<20>") getData("/WriteDataT<1>") getData("/WriteDataT<19>") getData("/WriteDataT<18>") getData("/WriteDataT<17>") getData("/WriteDataT<16>") getData("/WriteDataT<15>") getData("/WriteDataT<14>") getData("/WriteDataT<13>") getData("/WriteDataT<12>") getData("/WriteDataT<11>") getData("/WriteDataT<10>") getData("/WriteDataT<0>") getData("/WriteData<31:0>") getData("/WriteAck<7:0>") getData("/WAck<1>") getData("/WAck<0>") getData("/V1/PLUS") getData("/V1/MINUS") getData("/V0/PLUS") getData("/V0/MINUS") getData("/ReadData<31:0>") getData("/ReaDataT<7>") getData("/ReaDataT<6>") getData("/ReaDataT<5>") getData("/ReaDataT<4>") getData("/ReaDataT<3>") getData("/ReaDataT<2>") getData("/ReaDataT<1>") getData("/ReaDataT<0>") getData("/RWT<1>") getData("/RWT<0>") getData("/RW<1:0>") getData("/RD_Ack<7:0>") getData("/IBank/~R1_1<3>") getData("/IBank/~R1_1<2>") getData("/IBank/~R1_1<1>") getData("/IBank/~R1_1<0>") getData("/IBank/~R0_1<3>") getData("/IBank/~R0_1<2>") getData("/IBank/~R0_1<1>") getData("/IBank/~R0_1<0>") getData("/IBank/W1_1<3>") getData("/IBank/W1_1<2>") getData("/IBank/W1_1<1>") getData("/IBank/W1_1<0>") getData("/IBank/W0_1<3>") getData("/IBank/W0_1<2>") getData("/IBank/W0_1<1>") getData("/IBank/W0_1<0>") getData("/IBank/S_1<7>") getData("/IBank/S_1<6>") getData("/IBank/S_1<5>") getData("/IBank/S_1<4>") getData("/IBank/S_1<3>") getData("/IBank/S_1<2>") getData("/IBank/S_1<1>") getData("/IBank/S_1<0>") getData("/IBank/I20/Wen") getData("/IBank/I20/R1p<3>") getData("/IBank/I20/R1p<2>") getData("/IBank/I20/R1p<1>") getData("/IBank/I20/R1p<0>") getData("/IBank/I20/R0p<3>") getData("/IBank/I20/R0p<2>") getData("/IBank/I20/R0p<1>") getData("/IBank/I20/R0p<0>") getData("/IBank/I20/B1p<3>") getData("/IBank/I20/B1p<2>") getData("/IBank/I20/B1p<1>") getData("/IBank/I20/B1p<0>") getData("/IBank/I20/B0p<3>") getData("/IBank/I20/B0p<2>") getData("/IBank/I20/B0p<1>") getData("/IBank/I20/B0p<0>") getData("/IBank/G01") getData("/IBank/B1_1<3>") getData("/IBank/B1_1<2>") getData("/IBank/B1_1<1>") getData("/IBank/B1_1<0>") getData("/IBank/B0_1<3>") getData("/IBank/B0_1<2>") getData("/IBank/B0_1<1>") getData("/IBank/B0_1<0>") getData("/AckT") getData("/Ack") getData("/AT<9>") getData("/AT<8>") getData("/AT<7>") getData("/AT<6>") getData("/AT<5>") getData("/AT<4>") getData("/AT<3>") getData("/AT<2>") getData("/AT<1>") getData("/AT<19>") getData("/AT<18>") getData("/AT<17>") getData("/AT<16>") getData("/AT<15>") getData("/AT<14>") getData("/AT<13>") getData("/AT<12>") getData("/AT<11>") getData("/AT<10>") getData("/AT<0>") getData("/A<19:0>") getData("/IBank/A_1<63>") getData("/IBank/A_1<62>") getData("/IBank/A_1<61>") getData("/IBank/A_1<60>") getData("/IBank/A_1<59>") getData("/IBank/A_1<58>") getData("/IBank/A_1<57>") getData("/IBank/A_1<56>") getData("/IBank/A_1<55>") getData("/IBank/A_1<54>") getData("/IBank/A_1<53>") getData("/IBank/A_1<52>") getData("/IBank/A_1<51>") getData("/IBank/A_1<50>") getData("/IBank/A_1<49>") getData("/IBank/A_1<48>") getData("/IBank/A_1<47>") getData("/IBank/A_1<46>") getData("/IBank/A_1<45>") getData("/IBank/A_1<44>") getData("/IBank/A_1<43>") getData("/IBank/A_1<42>") getData("/IBank/A_1<41>") getData("/IBank/A_1<40>") getData("/IBank/A_1<39>") getData("/IBank/A_1<38>") getData("/IBank/A_1<37>") getData("/IBank/A_1<36>") getData("/IBank/A_1<35>") getData("/IBank/A_1<34>") getData("/IBank/A_1<33>") getData("/IBank/A_1<32>") getData("/IBank/A_1<31>") getData("/IBank/A_1<30>") getData("/IBank/A_1<29>") getData("/IBank/A_1<28>") getData("/IBank/A_1<27>") getData("/IBank/A_1<26>") getData("/IBank/A_1<25>") getData("/IBank/A_1<24>") getData("/IBank/A_1<23>") getData("/IBank/A_1<22>") getData("/IBank/A_1<21>") getData("/IBank/A_1<20>") getData("/IBank/A_1<19>") getData("/IBank/A_1<18>") getData("/IBank/A_1<17>") getData("/IBank/A_1<16>") getData("/IBank/A_1<15>") getData("/IBank/A_1<14>") getData("/IBank/A_1<13>") getData("/IBank/A_1<12>") getData("/IBank/A_1<11>") getData("/IBank/A_1<10>") getData("/IBank/A_1<9>") getData("/IBank/A_1<8>") getData("/IBank/A_1<7>") getData("/IBank/A_1<6>") getData("/IBank/A_1<5>") getData("/IBank/A_1<4>") getData("/IBank/A_1<3>") getData("/IBank/A_1<2>") getData("/IBank/A_1<1>") getData("/IBank/A_1<0>") getData("/IBank/I20/Out1<3>") getData("/IBank/I20/Out1<2>") getData("/IBank/I20/Out1<1>") getData("/IBank/I20/Out1<0>") getData("/IBank/I20/Out0<3>") getData("/IBank/I20/Out0<2>") getData("/IBank/I20/Out0<1>") getData("/IBank/I20/Out0<0>") getData("/IBank/I20/BpAck<0>") getData("/IBank/I20/BpAck<1>") getData("/IBank/I20/BpAck<2>") getData("/IBank/I20/BpAck<3>") getData("/IBank/I20/wack<0>") getData("/IBank/I20/wack<1>") getData("/IBank/I20/wack<2>") getData("/IBank/I20/I24/Lack") getData("/IBank/I20/wack<3>") )
