simulator( 'spectreVerilog )
design(	 "/net/kafka/nfs/rstdenis/Cadence/simulation/6T_BANK_Test/spectreVerilog/config/netlist/analog/netlist")
resultsDir( "/net/kafka/nfs/rstdenis/Cadence/simulation/6T_BANK_Test/spectreVerilog/config" )
modelFile(
    '("/software/cadence/ncsu-FreePDK15/hspice_16nm_hp.include" "")
)
analysis('tran ?stop "10n"  ?errpreset "conservative"  )
desVar(	  "vdd" .850	)
desVar(	  "vcc" .850	)
envOption(
	'mspSetupNetlistSimPrecisionUnit  "ps"
	'mspSetupNetlistSimTimeUnit  "ps"
	'mspSetupNetlistSwitchRC  t
	'userCmdLineOption  "+multithread"
	'analysisOrder  list("tran")
)
option(	'temp  "30.0"
)
saveOption( ?simOutputFormat "psfxl" )
save( 'i "/V0/MINUS" "/V1/MINUS" )
converge( 'ic "/WriteDataT<0>" "0" )
converge( 'ic "/WriteDataT<1>" "0" )
converge( 'ic "/WriteDataT<2>" "0" )
converge( 'ic "/WriteDataT<3>" "0" )
converge( 'ic "/WriteDataT<4>" "0" )
converge( 'ic "/WriteDataT<5>" "0" )
converge( 'ic "/WriteDataT<6>" "0" )
converge( 'ic "/WriteDataT<7>" "0" )
converge( 'ic "/WriteDataT<8>" "0" )
converge( 'ic "/WriteDataT<9>" "0" )
converge( 'ic "/WriteDataT<10>" "0" )
converge( 'ic "/WriteDataT<11>" "0" )
converge( 'ic "/WriteDataT<12>" "0" )
converge( 'ic "/WriteDataT<13>" "0" )
converge( 'ic "/WriteDataT<14>" "0" )
converge( 'ic "/WriteDataT<15>" "0" )
converge( 'ic "/WriteDataT<16>" "0" )
converge( 'ic "/WriteDataT<17>" "0" )
converge( 'ic "/WriteDataT<18>" "0" )
converge( 'ic "/WriteDataT<19>" "0" )
converge( 'ic "/WriteDataT<20>" "0" )
converge( 'ic "/WriteDataT<21>" "0" )
converge( 'ic "/WriteDataT<22>" "0" )
converge( 'ic "/WriteDataT<23>" "0" )
converge( 'ic "/WriteDataT<24>" "0" )
converge( 'ic "/WriteDataT<25>" "0" )
converge( 'ic "/WriteDataT<26>" "0" )
converge( 'ic "/WriteDataT<27>" "0" )
converge( 'ic "/WriteDataT<28>" "0" )
converge( 'ic "/WriteDataT<29>" "0" )
converge( 'ic "/WriteDataT<30>" "0" )
converge( 'ic "/WriteDataT<31>" "0" )
converge( 'ic "/I10/A<19:0>" "0" )
converge( 'ic "/I10/RW<1:0>" "0" )
converge( 'ic "/I10/RD_Ack<7:0>" "0" )
converge( 'ic "/ReaDataT<0>" "0" )
converge( 'ic "/ReaDataT<1>" "0" )
converge( 'ic "/ReaDataT<2>" "0" )
converge( 'ic "/ReaDataT<3>" "0" )
converge( 'ic "/ReaDataT<4>" "0" )
converge( 'ic "/ReaDataT<5>" "0" )
converge( 'ic "/ReaDataT<6>" "0" )
converge( 'ic "/ReaDataT<7>" "0" )
converge( 'ic "/ReaDataT<8>" "0" )
converge( 'ic "/ReaDataT<9>" "0" )
converge( 'ic "/ReaDataT<10>" "0" )
converge( 'ic "/ReaDataT<11>" "0" )
converge( 'ic "/ReaDataT<12>" "0" )
converge( 'ic "/ReaDataT<13>" "0" )
converge( 'ic "/ReaDataT<14>" "0" )
converge( 'ic "/ReaDataT<15>" "0" )
converge( 'ic "/ReaDataT<16>" "0" )
converge( 'ic "/ReaDataT<17>" "0" )
converge( 'ic "/ReaDataT<18>" "0" )
converge( 'ic "/ReaDataT<19>" "0" )
converge( 'ic "/ReaDataT<20>" "0" )
converge( 'ic "/ReaDataT<21>" "0" )
converge( 'ic "/ReaDataT<22>" "0" )
converge( 'ic "/ReaDataT<23>" "0" )
converge( 'ic "/ReaDataT<24>" "0" )
converge( 'ic "/ReaDataT<25>" "0" )
converge( 'ic "/ReaDataT<26>" "0" )
converge( 'ic "/ReaDataT<27>" "0" )
converge( 'ic "/ReaDataT<28>" "0" )
converge( 'ic "/ReaDataT<29>" "0" )
converge( 'ic "/ReaDataT<30>" "0" )
converge( 'ic "/ReaDataT<31>" "0" )
temp( 30.0 )
run()
selectResult( 'tran )
plot(getData("/A<19:0>") getData("/~A<19:0>") getData("/RW<1:0>") getData("/Ack") getData("/AT<19>") getData("/AT<18>") getData("/AT<17>") getData("/AT<16>") getData("/AT<15>") getData("/AT<14>") getData("/AT<13>") getData("/AT<12>") getData("/AT<11>") getData("/AT<10>") getData("/AT<9>") getData("/AT<8>") getData("/AT<7>") getData("/AT<6>") getData("/AT<5>") getData("/AT<4>") getData("/AT<3>") getData("/AT<2>") getData("/AT<1>") getData("/AT<0>") getData("/~RW<1:0>") getData("/RWT<1>") getData("/RWT<0>") getData("/V0/MINUS") getData("/V1/MINUS") getData("/WriteAck<7:0>") getData("/WriteData<31:0>") getData("/WriteDataT<31>") getData("/WriteDataT<30>") getData("/WriteDataT<29>") getData("/WriteDataT<28>") getData("/WriteDataT<27>") getData("/WriteDataT<26>") getData("/WriteDataT<25>") getData("/WriteDataT<24>") getData("/WriteDataT<23>") getData("/WriteDataT<22>") getData("/WriteDataT<21>") getData("/WriteDataT<20>") getData("/WriteDataT<19>") getData("/WriteDataT<18>") getData("/WriteDataT<17>") getData("/WriteDataT<16>") getData("/WriteDataT<15>") getData("/WriteDataT<14>") getData("/WriteDataT<13>") getData("/WriteDataT<12>") getData("/WriteDataT<11>") getData("/WriteDataT<10>") getData("/WriteDataT<9>") getData("/WriteDataT<8>") getData("/WriteDataT<7>") getData("/WriteDataT<6>") getData("/WriteDataT<5>") getData("/WriteDataT<4>") getData("/WriteDataT<3>") getData("/WriteDataT<2>") getData("/WriteDataT<1>") getData("/WriteDataT<0>") getData("/RD_Ack<7:0>") getData("/ReadData<31:0>") getData("/I10/~R0_1<3>") getData("/I10/~R0_1<2>") getData("/I10/~R0_1<1>") getData("/I10/~R0_1<0>") getData("/I10/B0_1<3>") getData("/I10/B0_1<2>") getData("/I10/B0_1<1>") getData("/I10/B0_1<0>") getData("/I10/B1_1<3>") getData("/I10/B1_1<2>") getData("/I10/B1_1<1>") getData("/I10/B1_1<0>") getData("/I10/W1_1<3>") getData("/I10/W1_1<2>") getData("/I10/W1_1<1>") getData("/I10/W1_1<0>") getData("/I10/W0_1<3>") getData("/I10/W0_1<2>") getData("/I10/W0_1<1>") getData("/I10/W0_1<0>") getData("/I10/G01") getData("/I10/~R1_1<3>") getData("/I10/~R1_1<2>") getData("/I10/~R1_1<1>") getData("/I10/~R1_1<0>") getData("/I10/A_1<63>") getData("/I10/A_1<62>") getData("/I10/A_1<61>") getData("/I10/A_1<60>") getData("/I10/A_1<59>") getData("/I10/A_1<58>") getData("/I10/A_1<57>") getData("/I10/A_1<56>") getData("/I10/A_1<55>") getData("/I10/A_1<54>") getData("/I10/A_1<53>") getData("/I10/A_1<52>") getData("/I10/A_1<51>") getData("/I10/A_1<50>") getData("/I10/A_1<49>") getData("/I10/A_1<48>") getData("/I10/A_1<47>") getData("/I10/A_1<46>") getData("/I10/A_1<45>") getData("/I10/A_1<44>") getData("/I10/A_1<43>") getData("/I10/A_1<42>") getData("/I10/A_1<41>") getData("/I10/A_1<40>") getData("/I10/A_1<39>") getData("/I10/A_1<38>") getData("/I10/A_1<37>") getData("/I10/A_1<36>") getData("/I10/A_1<35>") getData("/I10/A_1<34>") getData("/I10/A_1<33>") getData("/I10/A_1<32>") getData("/I10/A_1<31>") getData("/I10/A_1<30>") getData("/I10/A_1<29>") getData("/I10/A_1<28>") getData("/I10/A_1<27>") getData("/I10/A_1<26>") getData("/I10/A_1<25>") getData("/I10/A_1<24>") getData("/I10/A_1<23>") getData("/I10/A_1<22>") getData("/I10/A_1<21>") getData("/I10/A_1<20>") getData("/I10/A_1<19>") getData("/I10/A_1<18>") getData("/I10/A_1<17>") getData("/I10/A_1<16>") getData("/I10/A_1<15>") getData("/I10/A_1<14>") getData("/I10/A_1<13>") getData("/I10/A_1<12>") getData("/I10/A_1<11>") getData("/I10/A_1<10>") getData("/I10/A_1<9>") getData("/I10/A_1<8>") getData("/I10/A_1<7>") getData("/I10/A_1<6>") getData("/I10/A_1<5>") getData("/I10/A_1<4>") getData("/I10/A_1<3>") getData("/I10/A_1<2>") getData("/I10/A_1<1>") getData("/I10/A_1<0>") getData("/I10/S_1<7>") getData("/I10/S_1<6>") getData("/I10/S_1<5>") getData("/I10/S_1<4>") getData("/I10/S_1<3>") getData("/I10/S_1<2>") getData("/I10/S_1<1>") getData("/I10/S_1<0>") getData("/AckT") getData("/I10/ck<1>") getData("/I10/ck<0>") getData("/I10/ValAddr") getData("/I10/ck<3>") getData("/I10/ck<2>") getData("/I10/I20/Out0<3>") getData("/I10/I20/Out0<2>") getData("/I10/I20/Out0<1>") getData("/I10/I20/Out0<0>") getData("/I10/I20/Out1<3>") getData("/I10/I20/Out1<2>") getData("/I10/I20/Out1<1>") getData("/I10/I20/Out1<0>") )
modelFile(
    '("/software/cadence/ncsu-FreePDK15/hspice_16nm_hp.include" "")
)
desVar(	  "vcc" "vdd"	)
desVar(	  "vdd" .500	)
run()
selectResult( 'tran )
plot(getData("/A<19:0>") getData("/~A<19:0>") getData("/RW<1:0>") getData("/Ack") getData("/AT<19>") getData("/AT<18>") getData("/AT<17>") getData("/AT<16>") getData("/AT<15>") getData("/AT<14>") getData("/AT<13>") getData("/AT<12>") getData("/AT<11>") getData("/AT<10>") getData("/AT<9>") getData("/AT<8>") getData("/AT<7>") getData("/AT<6>") getData("/AT<5>") getData("/AT<4>") getData("/AT<3>") getData("/AT<2>") getData("/AT<1>") getData("/AT<0>") getData("/~RW<1:0>") getData("/RWT<1>") getData("/RWT<0>") getData("/V0/MINUS") getData("/V1/MINUS") getData("/WriteAck<7:0>") getData("/WriteData<31:0>") getData("/WriteDataT<31>") getData("/WriteDataT<30>") getData("/WriteDataT<29>") getData("/WriteDataT<28>") getData("/WriteDataT<27>") getData("/WriteDataT<26>") getData("/WriteDataT<25>") getData("/WriteDataT<24>") getData("/WriteDataT<23>") getData("/WriteDataT<22>") getData("/WriteDataT<21>") getData("/WriteDataT<20>") getData("/WriteDataT<19>") getData("/WriteDataT<18>") getData("/WriteDataT<17>") getData("/WriteDataT<16>") getData("/WriteDataT<15>") getData("/WriteDataT<14>") getData("/WriteDataT<13>") getData("/WriteDataT<12>") getData("/WriteDataT<11>") getData("/WriteDataT<10>") getData("/WriteDataT<9>") getData("/WriteDataT<8>") getData("/WriteDataT<7>") getData("/WriteDataT<6>") getData("/WriteDataT<5>") getData("/WriteDataT<4>") getData("/WriteDataT<3>") getData("/WriteDataT<2>") getData("/WriteDataT<1>") getData("/WriteDataT<0>") getData("/RD_Ack<7:0>") getData("/ReadData<31:0>") getData("/I10/~R0_1<3>") getData("/I10/~R0_1<2>") getData("/I10/~R0_1<1>") getData("/I10/~R0_1<0>") getData("/I10/B0_1<3>") getData("/I10/B0_1<2>") getData("/I10/B0_1<1>") getData("/I10/B0_1<0>") getData("/I10/B1_1<3>") getData("/I10/B1_1<2>") getData("/I10/B1_1<1>") getData("/I10/B1_1<0>") getData("/I10/W1_1<3>") getData("/I10/W1_1<2>") getData("/I10/W1_1<1>") getData("/I10/W1_1<0>") getData("/I10/W0_1<3>") getData("/I10/W0_1<2>") getData("/I10/W0_1<1>") getData("/I10/W0_1<0>") getData("/I10/G01") getData("/I10/~R1_1<3>") getData("/I10/~R1_1<2>") getData("/I10/~R1_1<1>") getData("/I10/~R1_1<0>") getData("/I10/A_1<63>") getData("/I10/A_1<62>") getData("/I10/A_1<61>") getData("/I10/A_1<60>") getData("/I10/A_1<59>") getData("/I10/A_1<58>") getData("/I10/A_1<57>") getData("/I10/A_1<56>") getData("/I10/A_1<55>") getData("/I10/A_1<54>") getData("/I10/A_1<53>") getData("/I10/A_1<52>") getData("/I10/A_1<51>") getData("/I10/A_1<50>") getData("/I10/A_1<49>") getData("/I10/A_1<48>") getData("/I10/A_1<47>") getData("/I10/A_1<46>") getData("/I10/A_1<45>") getData("/I10/A_1<44>") getData("/I10/A_1<43>") getData("/I10/A_1<42>") getData("/I10/A_1<41>") getData("/I10/A_1<40>") getData("/I10/A_1<39>") getData("/I10/A_1<38>") getData("/I10/A_1<37>") getData("/I10/A_1<36>") getData("/I10/A_1<35>") getData("/I10/A_1<34>") getData("/I10/A_1<33>") getData("/I10/A_1<32>") getData("/I10/A_1<31>") getData("/I10/A_1<30>") getData("/I10/A_1<29>") getData("/I10/A_1<28>") getData("/I10/A_1<27>") getData("/I10/A_1<26>") getData("/I10/A_1<25>") getData("/I10/A_1<24>") getData("/I10/A_1<23>") getData("/I10/A_1<22>") getData("/I10/A_1<21>") getData("/I10/A_1<20>") getData("/I10/A_1<19>") getData("/I10/A_1<18>") getData("/I10/A_1<17>") getData("/I10/A_1<16>") getData("/I10/A_1<15>") getData("/I10/A_1<14>") getData("/I10/A_1<13>") getData("/I10/A_1<12>") getData("/I10/A_1<11>") getData("/I10/A_1<10>") getData("/I10/A_1<9>") getData("/I10/A_1<8>") getData("/I10/A_1<7>") getData("/I10/A_1<6>") getData("/I10/A_1<5>") getData("/I10/A_1<4>") getData("/I10/A_1<3>") getData("/I10/A_1<2>") getData("/I10/A_1<1>") getData("/I10/A_1<0>") getData("/I10/S_1<7>") getData("/I10/S_1<6>") getData("/I10/S_1<5>") getData("/I10/S_1<4>") getData("/I10/S_1<3>") getData("/I10/S_1<2>") getData("/I10/S_1<1>") getData("/I10/S_1<0>") getData("/AckT") getData("/I10/ck<1>") getData("/I10/ck<0>") getData("/I10/ValAddr") getData("/I10/ck<3>") getData("/I10/ck<2>") getData("/I10/I20/Out0<3>") getData("/I10/I20/Out0<2>") getData("/I10/I20/Out0<1>") getData("/I10/I20/Out0<0>") getData("/I10/I20/Out1<3>") getData("/I10/I20/Out1<2>") getData("/I10/I20/Out1<1>") getData("/I10/I20/Out1<0>") )
modelFile(
    '("/software/cadence/ncsu-FreePDK15/hspice_16nm_hp.include" "")
)
run()
selectResult( 'tran )
plot(getData("/A<19:0>") getData("/~A<19:0>") getData("/RW<1:0>") getData("/Ack") getData("/AT<19>") getData("/AT<18>") getData("/AT<17>") getData("/AT<16>") getData("/AT<15>") getData("/AT<14>") getData("/AT<13>") getData("/AT<12>") getData("/AT<11>") getData("/AT<10>") getData("/AT<9>") getData("/AT<8>") getData("/AT<7>") getData("/AT<6>") getData("/AT<5>") getData("/AT<4>") getData("/AT<3>") getData("/AT<2>") getData("/AT<1>") getData("/AT<0>") getData("/~RW<1:0>") getData("/RWT<1>") getData("/RWT<0>") getData("/V0/MINUS") getData("/V1/MINUS") getData("/WriteAck<7:0>") getData("/WriteData<31:0>") getData("/WriteDataT<31>") getData("/WriteDataT<30>") getData("/WriteDataT<29>") getData("/WriteDataT<28>") getData("/WriteDataT<27>") getData("/WriteDataT<26>") getData("/WriteDataT<25>") getData("/WriteDataT<24>") getData("/WriteDataT<23>") getData("/WriteDataT<22>") getData("/WriteDataT<21>") getData("/WriteDataT<20>") getData("/WriteDataT<19>") getData("/WriteDataT<18>") getData("/WriteDataT<17>") getData("/WriteDataT<16>") getData("/WriteDataT<15>") getData("/WriteDataT<14>") getData("/WriteDataT<13>") getData("/WriteDataT<12>") getData("/WriteDataT<11>") getData("/WriteDataT<10>") getData("/WriteDataT<9>") getData("/WriteDataT<8>") getData("/WriteDataT<7>") getData("/WriteDataT<6>") getData("/WriteDataT<5>") getData("/WriteDataT<4>") getData("/WriteDataT<3>") getData("/WriteDataT<2>") getData("/WriteDataT<1>") getData("/WriteDataT<0>") getData("/RD_Ack<7:0>") getData("/ReadData<31:0>") getData("/I10/~R0_1<3>") getData("/I10/~R0_1<2>") getData("/I10/~R0_1<1>") getData("/I10/~R0_1<0>") getData("/I10/B0_1<3>") getData("/I10/B0_1<2>") getData("/I10/B0_1<1>") getData("/I10/B0_1<0>") getData("/I10/B1_1<3>") getData("/I10/B1_1<2>") getData("/I10/B1_1<1>") getData("/I10/B1_1<0>") getData("/I10/W1_1<3>") getData("/I10/W1_1<2>") getData("/I10/W1_1<1>") getData("/I10/W1_1<0>") getData("/I10/W0_1<3>") getData("/I10/W0_1<2>") getData("/I10/W0_1<1>") getData("/I10/W0_1<0>") getData("/I10/G01") getData("/I10/~R1_1<3>") getData("/I10/~R1_1<2>") getData("/I10/~R1_1<1>") getData("/I10/~R1_1<0>") getData("/I10/A_1<63>") getData("/I10/A_1<62>") getData("/I10/A_1<61>") getData("/I10/A_1<60>") getData("/I10/A_1<59>") getData("/I10/A_1<58>") getData("/I10/A_1<57>") getData("/I10/A_1<56>") getData("/I10/A_1<55>") getData("/I10/A_1<54>") getData("/I10/A_1<53>") getData("/I10/A_1<52>") getData("/I10/A_1<51>") getData("/I10/A_1<50>") getData("/I10/A_1<49>") getData("/I10/A_1<48>") getData("/I10/A_1<47>") getData("/I10/A_1<46>") getData("/I10/A_1<45>") getData("/I10/A_1<44>") getData("/I10/A_1<43>") getData("/I10/A_1<42>") getData("/I10/A_1<41>") getData("/I10/A_1<40>") getData("/I10/A_1<39>") getData("/I10/A_1<38>") getData("/I10/A_1<37>") getData("/I10/A_1<36>") getData("/I10/A_1<35>") getData("/I10/A_1<34>") getData("/I10/A_1<33>") getData("/I10/A_1<32>") getData("/I10/A_1<31>") getData("/I10/A_1<30>") getData("/I10/A_1<29>") getData("/I10/A_1<28>") getData("/I10/A_1<27>") getData("/I10/A_1<26>") getData("/I10/A_1<25>") getData("/I10/A_1<24>") getData("/I10/A_1<23>") getData("/I10/A_1<22>") getData("/I10/A_1<21>") getData("/I10/A_1<20>") getData("/I10/A_1<19>") getData("/I10/A_1<18>") getData("/I10/A_1<17>") getData("/I10/A_1<16>") getData("/I10/A_1<15>") getData("/I10/A_1<14>") getData("/I10/A_1<13>") getData("/I10/A_1<12>") getData("/I10/A_1<11>") getData("/I10/A_1<10>") getData("/I10/A_1<9>") getData("/I10/A_1<8>") getData("/I10/A_1<7>") getData("/I10/A_1<6>") getData("/I10/A_1<5>") getData("/I10/A_1<4>") getData("/I10/A_1<3>") getData("/I10/A_1<2>") getData("/I10/A_1<1>") getData("/I10/A_1<0>") getData("/I10/S_1<7>") getData("/I10/S_1<6>") getData("/I10/S_1<5>") getData("/I10/S_1<4>") getData("/I10/S_1<3>") getData("/I10/S_1<2>") getData("/I10/S_1<1>") getData("/I10/S_1<0>") getData("/AckT") getData("/I10/ck<1>") getData("/I10/ck<0>") getData("/I10/ValAddr") getData("/I10/ck<3>") getData("/I10/ck<2>") getData("/I10/I20/Out0<3>") getData("/I10/I20/Out0<2>") getData("/I10/I20/Out0<1>") getData("/I10/I20/Out0<0>") getData("/I10/I20/Out1<3>") getData("/I10/I20/Out1<2>") getData("/I10/I20/Out1<1>") getData("/I10/I20/Out1<0>") )
modelFile(
    '("/software/cadence/ncsu-FreePDK15/hspice_16nm_hp.include" "")
)
run()
selectResult( 'tran )
plot(getData("/A<19:0>") getData("/~A<19:0>") getData("/RW<1:0>") getData("/Ack") getData("/AT<19>") getData("/AT<18>") getData("/AT<17>") getData("/AT<16>") getData("/AT<15>") getData("/AT<14>") getData("/AT<13>") getData("/AT<12>") getData("/AT<11>") getData("/AT<10>") getData("/AT<9>") getData("/AT<8>") getData("/AT<7>") getData("/AT<6>") getData("/AT<5>") getData("/AT<4>") getData("/AT<3>") getData("/AT<2>") getData("/AT<1>") getData("/AT<0>") getData("/~RW<1:0>") getData("/RWT<1>") getData("/RWT<0>") getData("/V0/MINUS") getData("/V1/MINUS") getData("/WriteAck<7:0>") getData("/WriteData<31:0>") getData("/WriteDataT<31>") getData("/WriteDataT<30>") getData("/WriteDataT<29>") getData("/WriteDataT<28>") getData("/WriteDataT<27>") getData("/WriteDataT<26>") getData("/WriteDataT<25>") getData("/WriteDataT<24>") getData("/WriteDataT<23>") getData("/WriteDataT<22>") getData("/WriteDataT<21>") getData("/WriteDataT<20>") getData("/WriteDataT<19>") getData("/WriteDataT<18>") getData("/WriteDataT<17>") getData("/WriteDataT<16>") getData("/WriteDataT<15>") getData("/WriteDataT<14>") getData("/WriteDataT<13>") getData("/WriteDataT<12>") getData("/WriteDataT<11>") getData("/WriteDataT<10>") getData("/WriteDataT<9>") getData("/WriteDataT<8>") getData("/WriteDataT<7>") getData("/WriteDataT<6>") getData("/WriteDataT<5>") getData("/WriteDataT<4>") getData("/WriteDataT<3>") getData("/WriteDataT<2>") getData("/WriteDataT<1>") getData("/WriteDataT<0>") getData("/RD_Ack<7:0>") getData("/ReadData<31:0>") getData("/I10/~R0_1<3>") getData("/I10/~R0_1<2>") getData("/I10/~R0_1<1>") getData("/I10/~R0_1<0>") getData("/I10/B0_1<3>") getData("/I10/B0_1<2>") getData("/I10/B0_1<1>") getData("/I10/B0_1<0>") getData("/I10/B1_1<3>") getData("/I10/B1_1<2>") getData("/I10/B1_1<1>") getData("/I10/B1_1<0>") getData("/I10/W1_1<3>") getData("/I10/W1_1<2>") getData("/I10/W1_1<1>") getData("/I10/W1_1<0>") getData("/I10/W0_1<3>") getData("/I10/W0_1<2>") getData("/I10/W0_1<1>") getData("/I10/W0_1<0>") getData("/I10/G01") getData("/I10/~R1_1<3>") getData("/I10/~R1_1<2>") getData("/I10/~R1_1<1>") getData("/I10/~R1_1<0>") getData("/I10/A_1<63>") getData("/I10/A_1<62>") getData("/I10/A_1<61>") getData("/I10/A_1<60>") getData("/I10/A_1<59>") getData("/I10/A_1<58>") getData("/I10/A_1<57>") getData("/I10/A_1<56>") getData("/I10/A_1<55>") getData("/I10/A_1<54>") getData("/I10/A_1<53>") getData("/I10/A_1<52>") getData("/I10/A_1<51>") getData("/I10/A_1<50>") getData("/I10/A_1<49>") getData("/I10/A_1<48>") getData("/I10/A_1<47>") getData("/I10/A_1<46>") getData("/I10/A_1<45>") getData("/I10/A_1<44>") getData("/I10/A_1<43>") getData("/I10/A_1<42>") getData("/I10/A_1<41>") getData("/I10/A_1<40>") getData("/I10/A_1<39>") getData("/I10/A_1<38>") getData("/I10/A_1<37>") getData("/I10/A_1<36>") getData("/I10/A_1<35>") getData("/I10/A_1<34>") getData("/I10/A_1<33>") getData("/I10/A_1<32>") getData("/I10/A_1<31>") getData("/I10/A_1<30>") getData("/I10/A_1<29>") getData("/I10/A_1<28>") getData("/I10/A_1<27>") getData("/I10/A_1<26>") getData("/I10/A_1<25>") getData("/I10/A_1<24>") getData("/I10/A_1<23>") getData("/I10/A_1<22>") getData("/I10/A_1<21>") getData("/I10/A_1<20>") getData("/I10/A_1<19>") getData("/I10/A_1<18>") getData("/I10/A_1<17>") getData("/I10/A_1<16>") getData("/I10/A_1<15>") getData("/I10/A_1<14>") getData("/I10/A_1<13>") getData("/I10/A_1<12>") getData("/I10/A_1<11>") getData("/I10/A_1<10>") getData("/I10/A_1<9>") getData("/I10/A_1<8>") getData("/I10/A_1<7>") getData("/I10/A_1<6>") getData("/I10/A_1<5>") getData("/I10/A_1<4>") getData("/I10/A_1<3>") getData("/I10/A_1<2>") getData("/I10/A_1<1>") getData("/I10/A_1<0>") getData("/I10/S_1<7>") getData("/I10/S_1<6>") getData("/I10/S_1<5>") getData("/I10/S_1<4>") getData("/I10/S_1<3>") getData("/I10/S_1<2>") getData("/I10/S_1<1>") getData("/I10/S_1<0>") getData("/AckT") getData("/I10/ck<1>") getData("/I10/ck<0>") getData("/I10/ValAddr") getData("/I10/ck<3>") getData("/I10/ck<2>") getData("/I10/I20/Out0<3>") getData("/I10/I20/Out0<2>") getData("/I10/I20/Out0<1>") getData("/I10/I20/Out0<0>") getData("/I10/I20/Out1<3>") getData("/I10/I20/Out1<2>") getData("/I10/I20/Out1<1>") getData("/I10/I20/Out1<0>") )
modelFile(
    '("/software/cadence/ncsu-FreePDK15/hspice_16nm_hp.include" "")
)
run()
selectResult( 'tran )
plot(getData("/A<19:0>") getData("/~A<19:0>") getData("/RW<1:0>") getData("/Ack") getData("/AT<19>") getData("/AT<18>") getData("/AT<17>") getData("/AT<16>") getData("/AT<15>") getData("/AT<14>") getData("/AT<13>") getData("/AT<12>") getData("/AT<11>") getData("/AT<10>") getData("/AT<9>") getData("/AT<8>") getData("/AT<7>") getData("/AT<6>") getData("/AT<5>") getData("/AT<4>") getData("/AT<3>") getData("/AT<2>") getData("/AT<1>") getData("/AT<0>") getData("/~RW<1:0>") getData("/RWT<1>") getData("/RWT<0>") getData("/V0/MINUS") getData("/V1/MINUS") getData("/WriteAck<7:0>") getData("/WriteData<31:0>") getData("/WriteDataT<31>") getData("/WriteDataT<30>") getData("/WriteDataT<29>") getData("/WriteDataT<28>") getData("/WriteDataT<27>") getData("/WriteDataT<26>") getData("/WriteDataT<25>") getData("/WriteDataT<24>") getData("/WriteDataT<23>") getData("/WriteDataT<22>") getData("/WriteDataT<21>") getData("/WriteDataT<20>") getData("/WriteDataT<19>") getData("/WriteDataT<18>") getData("/WriteDataT<17>") getData("/WriteDataT<16>") getData("/WriteDataT<15>") getData("/WriteDataT<14>") getData("/WriteDataT<13>") getData("/WriteDataT<12>") getData("/WriteDataT<11>") getData("/WriteDataT<10>") getData("/WriteDataT<9>") getData("/WriteDataT<8>") getData("/WriteDataT<7>") getData("/WriteDataT<6>") getData("/WriteDataT<5>") getData("/WriteDataT<4>") getData("/WriteDataT<3>") getData("/WriteDataT<2>") getData("/WriteDataT<1>") getData("/WriteDataT<0>") getData("/RD_Ack<7:0>") getData("/ReadData<31:0>") getData("/I10/~R0_1<3>") getData("/I10/~R0_1<2>") getData("/I10/~R0_1<1>") getData("/I10/~R0_1<0>") getData("/I10/B0_1<3>") getData("/I10/B0_1<2>") getData("/I10/B0_1<1>") getData("/I10/B0_1<0>") getData("/I10/B1_1<3>") getData("/I10/B1_1<2>") getData("/I10/B1_1<1>") getData("/I10/B1_1<0>") getData("/I10/W1_1<3>") getData("/I10/W1_1<2>") getData("/I10/W1_1<1>") getData("/I10/W1_1<0>") getData("/I10/W0_1<3>") getData("/I10/W0_1<2>") getData("/I10/W0_1<1>") getData("/I10/W0_1<0>") getData("/I10/G01") getData("/I10/~R1_1<3>") getData("/I10/~R1_1<2>") getData("/I10/~R1_1<1>") getData("/I10/~R1_1<0>") getData("/I10/A_1<63>") getData("/I10/A_1<62>") getData("/I10/A_1<61>") getData("/I10/A_1<60>") getData("/I10/A_1<59>") getData("/I10/A_1<58>") getData("/I10/A_1<57>") getData("/I10/A_1<56>") getData("/I10/A_1<55>") getData("/I10/A_1<54>") getData("/I10/A_1<53>") getData("/I10/A_1<52>") getData("/I10/A_1<51>") getData("/I10/A_1<50>") getData("/I10/A_1<49>") getData("/I10/A_1<48>") getData("/I10/A_1<47>") getData("/I10/A_1<46>") getData("/I10/A_1<45>") getData("/I10/A_1<44>") getData("/I10/A_1<43>") getData("/I10/A_1<42>") getData("/I10/A_1<41>") getData("/I10/A_1<40>") getData("/I10/A_1<39>") getData("/I10/A_1<38>") getData("/I10/A_1<37>") getData("/I10/A_1<36>") getData("/I10/A_1<35>") getData("/I10/A_1<34>") getData("/I10/A_1<33>") getData("/I10/A_1<32>") getData("/I10/A_1<31>") getData("/I10/A_1<30>") getData("/I10/A_1<29>") getData("/I10/A_1<28>") getData("/I10/A_1<27>") getData("/I10/A_1<26>") getData("/I10/A_1<25>") getData("/I10/A_1<24>") getData("/I10/A_1<23>") getData("/I10/A_1<22>") getData("/I10/A_1<21>") getData("/I10/A_1<20>") getData("/I10/A_1<19>") getData("/I10/A_1<18>") getData("/I10/A_1<17>") getData("/I10/A_1<16>") getData("/I10/A_1<15>") getData("/I10/A_1<14>") getData("/I10/A_1<13>") getData("/I10/A_1<12>") getData("/I10/A_1<11>") getData("/I10/A_1<10>") getData("/I10/A_1<9>") getData("/I10/A_1<8>") getData("/I10/A_1<7>") getData("/I10/A_1<6>") getData("/I10/A_1<5>") getData("/I10/A_1<4>") getData("/I10/A_1<3>") getData("/I10/A_1<2>") getData("/I10/A_1<1>") getData("/I10/A_1<0>") getData("/I10/S_1<7>") getData("/I10/S_1<6>") getData("/I10/S_1<5>") getData("/I10/S_1<4>") getData("/I10/S_1<3>") getData("/I10/S_1<2>") getData("/I10/S_1<1>") getData("/I10/S_1<0>") getData("/AckT") getData("/I10/ck<1>") getData("/I10/ck<0>") getData("/I10/ValAddr") getData("/I10/ck<3>") getData("/I10/ck<2>") getData("/I10/I20/Out0<3>") getData("/I10/I20/Out0<2>") getData("/I10/I20/Out0<1>") getData("/I10/I20/Out0<0>") getData("/I10/I20/Out1<3>") getData("/I10/I20/Out1<2>") getData("/I10/I20/Out1<1>") getData("/I10/I20/Out1<0>") )
