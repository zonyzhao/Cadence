simulator( 'spectreVerilog )
design(	 "/net/kafka/nfs/rstdenis/Cadence/simulation/6T_BANK_Test/spectreVerilog/config/netlist/analog/netlist")
resultsDir( "/net/kafka/nfs/rstdenis/Cadence/simulation/6T_BANK_Test/spectreVerilog/config" )
modelFile(
    '("/software/cadence/ncsu-FreePDK15/hspice_16nm_hp.include" "")
)
analysis('tran ?stop "6n "  ?errpreset "conservative"  )
desVar(	  "vcc" "vdd"	)
desVar(	  "vdd" .7	)
envOption(
	'mspSetupNetlistSimPrecisionUnit  "ps"
	'mspSetupNetlistSimTimeUnit  "ps"
	'mspSetupNetlistSwitchRC  t
	'analysisOrder  list("tran")
)
option(	'narrate  "yes"
	'inventory  "detailed"
	'multithread  "on"
	'temp  "30.0"
)
saveOption( ?simOutputFormat "psfxl" )
save( 'v "/vdd!" "/vcc!" )
save( 'i "/V1/PLUS" "/V1/MINUS" "/V0/PLUS" "/V0/MINUS" )
converge( 'ic "/IBank/G01" "0" )
converge( 'ic "/IBank/W0_1<0>" "0" )
converge( 'ic "/IBank/W0_1<1>" "0" )
converge( 'ic "/IBank/W0_1<2>" "0" )
converge( 'ic "/IBank/W0_1<3>" "0" )
converge( 'ic "/IBank/W1_1<0>" "0" )
converge( 'ic "/IBank/W1_1<1>" "0" )
converge( 'ic "/IBank/W1_1<2>" "0" )
converge( 'ic "/IBank/W1_1<3>" "0" )
converge( 'ic "/IBank/B1_1<0>" "0" )
converge( 'ic "/IBank/B1_1<1>" "0" )
converge( 'ic "/IBank/B1_1<2>" "0" )
converge( 'ic "/IBank/B1_1<3>" "0" )
converge( 'ic "/IBank/B0_1<0>" "0" )
converge( 'ic "/IBank/B0_1<1>" "0" )
converge( 'ic "/IBank/B0_1<2>" "0" )
converge( 'ic "/IBank/B0_1<3>" "0" )
converge( 'ic "/IBank/G02" "0" )
converge( 'ic "/IBank/W0_2<0>" "0" )
converge( 'ic "/IBank/W0_2<1>" "0" )
converge( 'ic "/IBank/W0_2<2>" "0" )
converge( 'ic "/IBank/W0_2<3>" "0" )
converge( 'ic "/IBank/W1_2<0>" "0" )
converge( 'ic "/IBank/W1_2<1>" "0" )
converge( 'ic "/IBank/W1_2<2>" "0" )
converge( 'ic "/IBank/W1_2<3>" "0" )
converge( 'ic "/IBank/B0_2<0>" "0" )
converge( 'ic "/IBank/B0_2<1>" "0" )
converge( 'ic "/IBank/B0_2<2>" "0" )
converge( 'ic "/IBank/B0_2<3>" "0" )
converge( 'ic "/IBank/B1_2<0>" "0" )
converge( 'ic "/IBank/B1_2<1>" "0" )
converge( 'ic "/IBank/B1_2<2>" "0" )
converge( 'ic "/IBank/B1_2<3>" "0" )
converge( 'ic "/AT<17>" "0" )
converge( 'ic "/AT<18>" "0" )
converge( 'ic "/AT<19>" "0" )
converge( 'ic "/IBank/AvAck<1>" "0" )
converge( 'ic "/IBank/AvAck<2>" "0" )
converge( 'ic "/IBank/AvAck<3>" "0" )
converge( 'ic "/AT<12>" "0" )
converge( 'ic "/AT<13>" "0" )
converge( 'ic "/AT<14>" "0" )
converge( 'ic "/AT<15>" "0" )
converge( 'ic "/AT<8>" "0" )
converge( 'ic "/AT<9>" "0" )
converge( 'ic "/AT<10>" "0" )
converge( 'ic "/AT<11>" "0" )
converge( 'ic "/AT<0>" "0" )
converge( 'ic "/AT<1>" "0" )
converge( 'ic "/AT<2>" "0" )
converge( 'ic "/AT<3>" "0" )
converge( 'ic "/AT<4>" "0" )
converge( 'ic "/AT<5>" "0" )
converge( 'ic "/AT<6>" "0" )
converge( 'ic "/AT<7>" "0" )
converge( 'ic "/IBank/AvAck<0>" "0" )
converge( 'ic "/AT<16>" "0" )
converge( 'ic "/IBank/S_1<0>" "0" )
converge( 'ic "/IBank/S_1<1>" "0" )
converge( 'ic "/IBank/S_1<2>" "0" )
converge( 'ic "/IBank/S_1<3>" "0" )
converge( 'ic "/IBank/S_1<4>" "0" )
converge( 'ic "/IBank/S_1<5>" "0" )
converge( 'ic "/IBank/S_1<6>" "0" )
converge( 'ic "/IBank/S_1<7>" "0" )
converge( 'ic "/IBank/A_1<0>" "0" )
converge( 'ic "/IBank/A_1<1>" "0" )
converge( 'ic "/IBank/A_1<2>" "0" )
converge( 'ic "/IBank/A_1<3>" "0" )
converge( 'ic "/IBank/A_1<4>" "0" )
converge( 'ic "/IBank/A_1<5>" "0" )
converge( 'ic "/IBank/A_1<6>" "0" )
converge( 'ic "/IBank/A_1<7>" "0" )
converge( 'ic "/IBank/A_1<8>" "0" )
converge( 'ic "/IBank/A_1<9>" "0" )
converge( 'ic "/IBank/A_1<10>" "0" )
converge( 'ic "/IBank/A_1<11>" "0" )
converge( 'ic "/IBank/A_1<12>" "0" )
converge( 'ic "/IBank/A_1<13>" "0" )
converge( 'ic "/IBank/A_1<14>" "0" )
converge( 'ic "/IBank/A_1<15>" "0" )
converge( 'ic "/IBank/A_1<16>" "0" )
converge( 'ic "/IBank/A_1<17>" "0" )
converge( 'ic "/IBank/A_1<18>" "0" )
converge( 'ic "/IBank/A_1<19>" "0" )
converge( 'ic "/IBank/A_1<20>" "0" )
converge( 'ic "/IBank/A_1<21>" "0" )
converge( 'ic "/IBank/A_1<22>" "0" )
converge( 'ic "/IBank/A_1<23>" "0" )
converge( 'ic "/IBank/A_1<24>" "0" )
converge( 'ic "/IBank/A_1<25>" "0" )
converge( 'ic "/IBank/A_1<26>" "0" )
converge( 'ic "/IBank/A_1<27>" "0" )
converge( 'ic "/IBank/A_1<28>" "0" )
converge( 'ic "/IBank/A_1<29>" "0" )
converge( 'ic "/IBank/A_1<30>" "0" )
converge( 'ic "/IBank/A_1<31>" "0" )
converge( 'ic "/IBank/A_1<32>" "0" )
converge( 'ic "/IBank/A_1<33>" "0" )
converge( 'ic "/IBank/A_1<34>" "0" )
converge( 'ic "/IBank/A_1<35>" "0" )
converge( 'ic "/IBank/A_1<36>" "0" )
converge( 'ic "/IBank/A_1<37>" "0" )
converge( 'ic "/IBank/A_1<38>" "0" )
converge( 'ic "/IBank/A_1<39>" "0" )
converge( 'ic "/IBank/A_1<40>" "0" )
converge( 'ic "/IBank/A_1<41>" "0" )
converge( 'ic "/IBank/A_1<42>" "0" )
converge( 'ic "/IBank/A_1<43>" "0" )
converge( 'ic "/IBank/A_1<44>" "0" )
converge( 'ic "/IBank/A_1<45>" "0" )
converge( 'ic "/IBank/A_1<46>" "0" )
converge( 'ic "/IBank/A_1<47>" "0" )
converge( 'ic "/IBank/A_1<48>" "0" )
converge( 'ic "/IBank/A_1<49>" "0" )
converge( 'ic "/IBank/A_1<50>" "0" )
converge( 'ic "/IBank/A_1<51>" "0" )
converge( 'ic "/IBank/A_1<52>" "0" )
converge( 'ic "/IBank/A_1<53>" "0" )
converge( 'ic "/IBank/A_1<54>" "0" )
converge( 'ic "/IBank/A_1<55>" "0" )
converge( 'ic "/IBank/A_1<56>" "0" )
converge( 'ic "/IBank/A_1<57>" "0" )
converge( 'ic "/IBank/A_1<58>" "0" )
converge( 'ic "/IBank/A_1<59>" "0" )
converge( 'ic "/IBank/A_1<60>" "0" )
converge( 'ic "/IBank/A_1<61>" "0" )
converge( 'ic "/IBank/A_1<62>" "0" )
converge( 'ic "/IBank/A_1<63>" "0" )
converge( 'ic "/RWT<0>" "0" )
converge( 'ic "/RWT<1>" "0" )
converge( 'ic "/IBank/RW<1:0>" "0" )
converge( 'ic "/IBank/ValAddr" "0" )
converge( 'ic "/IBank/ck<0>" "0" )
converge( 'ic "/IBank/ck<1>" "0" )
converge( 'ic "/IBank/Reset" "0" )
converge( 'ic "/IBank/ck<2>" "0" )
converge( 'ic "/IBank/ck<3>" "0" )
converge( 'ic "/IBank/G03" "0" )
converge( 'ic "/IBank/W1_3<0>" "0" )
converge( 'ic "/IBank/W1_3<1>" "0" )
converge( 'ic "/IBank/W1_3<2>" "0" )
converge( 'ic "/IBank/W1_3<3>" "0" )
converge( 'ic "/IBank/W0_3<0>" "0" )
converge( 'ic "/IBank/W0_3<1>" "0" )
converge( 'ic "/IBank/W0_3<2>" "0" )
converge( 'ic "/IBank/W0_3<3>" "0" )
converge( 'ic "/IBank/B0_3<0>" "0" )
converge( 'ic "/IBank/B0_3<1>" "0" )
converge( 'ic "/IBank/B0_3<2>" "0" )
converge( 'ic "/IBank/B0_3<3>" "0" )
converge( 'ic "/IBank/B1_3<0>" "0" )
converge( 'ic "/IBank/B1_3<1>" "0" )
converge( 'ic "/IBank/B1_3<2>" "0" )
converge( 'ic "/IBank/B1_3<3>" "0" )
converge( 'ic "/IBank/W0_4<0>" "0" )
converge( 'ic "/IBank/W0_4<1>" "0" )
converge( 'ic "/IBank/W0_4<2>" "0" )
converge( 'ic "/IBank/W0_4<3>" "0" )
converge( 'ic "/IBank/W1_4<0>" "0" )
converge( 'ic "/IBank/W1_4<1>" "0" )
converge( 'ic "/IBank/W1_4<2>" "0" )
converge( 'ic "/IBank/W1_4<3>" "0" )
converge( 'ic "/IBank/B0_4<0>" "0" )
converge( 'ic "/IBank/B0_4<1>" "0" )
converge( 'ic "/IBank/B0_4<2>" "0" )
converge( 'ic "/IBank/B0_4<3>" "0" )
converge( 'ic "/IBank/B1_4<0>" "0" )
converge( 'ic "/IBank/B1_4<1>" "0" )
converge( 'ic "/IBank/B1_4<2>" "0" )
converge( 'ic "/IBank/B1_4<3>" "0" )
converge( 'ic "/IBank/G04" "0" )
converge( 'ic "/IBank/net042" "0" )
converge( 'ic "/WriteDataT<8>" "0" )
converge( 'ic "/WriteDataT<9>" "0" )
converge( 'ic "/WriteDataT<10>" "0" )
converge( 'ic "/WriteDataT<11>" "0" )
converge( 'ic "/WriteDataT<12>" "0" )
converge( 'ic "/WriteDataT<13>" "0" )
converge( 'ic "/WriteDataT<14>" "0" )
converge( 'ic "/WriteDataT<15>" "0" )
converge( 'ic "/WriteDataT<16>" "0" )
converge( 'ic "/WriteDataT<17>" "0" )
converge( 'ic "/WriteDataT<18>" "0" )
converge( 'ic "/WriteDataT<19>" "0" )
converge( 'ic "/WriteDataT<20>" "0" )
converge( 'ic "/WriteDataT<21>" "0" )
converge( 'ic "/WriteDataT<22>" "0" )
converge( 'ic "/WriteDataT<23>" "0" )
converge( 'ic "/WriteDataT<24>" "0" )
converge( 'ic "/WriteDataT<25>" "0" )
converge( 'ic "/WriteDataT<26>" "0" )
converge( 'ic "/WriteDataT<27>" "0" )
converge( 'ic "/WriteDataT<28>" "0" )
converge( 'ic "/WriteDataT<29>" "0" )
converge( 'ic "/WriteDataT<30>" "0" )
converge( 'ic "/WriteDataT<31>" "0" )
converge( 'ic "/ReaDataT<8>" "0" )
converge( 'ic "/ReaDataT<9>" "0" )
converge( 'ic "/ReaDataT<10>" "0" )
converge( 'ic "/ReaDataT<11>" "0" )
converge( 'ic "/ReaDataT<12>" "0" )
converge( 'ic "/ReaDataT<13>" "0" )
converge( 'ic "/ReaDataT<14>" "0" )
converge( 'ic "/ReaDataT<15>" "0" )
converge( 'ic "/ReaDataT<16>" "0" )
converge( 'ic "/ReaDataT<17>" "0" )
converge( 'ic "/ReaDataT<18>" "0" )
converge( 'ic "/ReaDataT<19>" "0" )
converge( 'ic "/ReaDataT<20>" "0" )
converge( 'ic "/ReaDataT<21>" "0" )
converge( 'ic "/ReaDataT<22>" "0" )
converge( 'ic "/ReaDataT<23>" "0" )
converge( 'ic "/ReaDataT<24>" "0" )
converge( 'ic "/ReaDataT<25>" "0" )
converge( 'ic "/ReaDataT<26>" "0" )
converge( 'ic "/ReaDataT<27>" "0" )
converge( 'ic "/ReaDataT<28>" "0" )
converge( 'ic "/ReaDataT<29>" "0" )
converge( 'ic "/ReaDataT<30>" "0" )
converge( 'ic "/ReaDataT<31>" "0" )
converge( 'ic "/ReadDataAckT<0>" "0" )
converge( 'ic "/ReadDataAckT<1>" "0" )
converge( 'ic "/WriteDataT<0>" "0" )
converge( 'ic "/WriteDataT<1>" "0" )
converge( 'ic "/WriteDataT<2>" "0" )
converge( 'ic "/WriteDataT<3>" "0" )
converge( 'ic "/WriteDataT<4>" "0" )
converge( 'ic "/WriteDataT<5>" "0" )
converge( 'ic "/WriteDataT<6>" "0" )
converge( 'ic "/WriteDataT<7>" "0" )
converge( 'ic "/WDataAckT<0>" "0" )
converge( 'ic "/WDataAckT<1>" "0" )
converge( 'ic "/ReaDataT<4>" "0" )
converge( 'ic "/ReaDataT<5>" "0" )
converge( 'ic "/ReaDataT<6>" "0" )
converge( 'ic "/ReaDataT<7>" "0" )
converge( 'ic "/ReaDataT<0>" "0" )
converge( 'ic "/ReaDataT<1>" "0" )
converge( 'ic "/ReaDataT<2>" "0" )
converge( 'ic "/ReaDataT<3>" "0" )
converge( 'ic "/WDataAckT<2>" "0" )
converge( 'ic "/WDataAckT<3>" "0" )
converge( 'ic "/ReadDataAckT<2>" "0" )
converge( 'ic "/ReadDataAckT<3>" "0" )
converge( 'ic "/WDataAckT<4>" "0" )
converge( 'ic "/WDataAckT<5>" "0" )
converge( 'ic "/ReadDataAckT<4>" "0" )
converge( 'ic "/ReadDataAckT<5>" "0" )
converge( 'ic "/WDataAckT<6>" "0" )
converge( 'ic "/WDataAckT<7>" "0" )
converge( 'ic "/ReadDataAckT<6>" "0" )
converge( 'ic "/ReadDataAckT<7>" "0" )
converge( 'ic "/IBank/~R1_1<0>" "vdd" )
converge( 'ic "/IBank/~R1_1<1>" "vdd" )
converge( 'ic "/IBank/~R1_1<2>" "vdd" )
converge( 'ic "/IBank/~R1_1<3>" "vdd" )
converge( 'ic "/IBank/~R0_1<0>" "vdd" )
converge( 'ic "/IBank/~R0_1<1>" "vdd" )
converge( 'ic "/IBank/~R0_1<2>" "vdd" )
converge( 'ic "/IBank/~R0_1<3>" "vdd" )
converge( 'ic "/IBank/~R0_2<0>" "vdd" )
converge( 'ic "/IBank/~R0_2<1>" "vdd" )
converge( 'ic "/IBank/~R0_2<2>" "vdd" )
converge( 'ic "/IBank/~R0_2<3>" "vdd" )
converge( 'ic "/IBank/~R1_2<0>" "vdd" )
converge( 'ic "/IBank/~R1_2<1>" "vdd" )
converge( 'ic "/IBank/~R1_2<2>" "vdd" )
converge( 'ic "/IBank/~R1_2<3>" "vdd" )
converge( 'ic "/IBank/~R0_3<0>" "vdd" )
converge( 'ic "/IBank/~R0_3<1>" "vdd" )
converge( 'ic "/IBank/~R0_3<2>" "vdd" )
converge( 'ic "/IBank/~R0_3<3>" "vdd" )
converge( 'ic "/IBank/~R1_3<0>" "vdd" )
converge( 'ic "/IBank/~R1_3<1>" "vdd" )
converge( 'ic "/IBank/~R1_3<2>" "vdd" )
converge( 'ic "/IBank/~R1_3<3>" "vdd" )
converge( 'ic "/IBank/~R0_4<0>" "vdd" )
converge( 'ic "/IBank/~R0_4<1>" "vdd" )
converge( 'ic "/IBank/~R0_4<2>" "vdd" )
converge( 'ic "/IBank/~R0_4<3>" "vdd" )
converge( 'ic "/IBank/~R1_4<0>" "vdd" )
converge( 'ic "/IBank/~R1_4<1>" "vdd" )
converge( 'ic "/IBank/~R1_4<2>" "vdd" )
converge( 'ic "/IBank/~R1_4<3>" "vdd" )
converge( 'ic "/AckT" "0" )
converge( 'ic "/CtrlAckT<0>" "vdd" )
converge( 'ic "/CtrlAckT<1>" "vdd" )
converge( 'ic "/CtrlAckT<2>" "vdd" )
converge( 'ic "/CtrlAckT<3>" "vdd" )
converge( 'ic "/CtrlAckT<4>" "vdd" )
converge( 'ic "/IBank/A_2<0>" "0" )
converge( 'ic "/IBank/A_2<1>" "0" )
converge( 'ic "/IBank/A_2<2>" "0" )
converge( 'ic "/IBank/A_2<3>" "0" )
converge( 'ic "/IBank/A_2<4>" "0" )
converge( 'ic "/IBank/A_2<5>" "0" )
converge( 'ic "/IBank/A_2<6>" "0" )
converge( 'ic "/IBank/A_2<7>" "0" )
converge( 'ic "/IBank/A_2<8>" "0" )
converge( 'ic "/IBank/A_2<9>" "0" )
converge( 'ic "/IBank/A_2<10>" "0" )
converge( 'ic "/IBank/A_2<11>" "0" )
converge( 'ic "/IBank/A_2<12>" "0" )
converge( 'ic "/IBank/A_2<13>" "0" )
converge( 'ic "/IBank/A_2<14>" "0" )
converge( 'ic "/IBank/A_2<15>" "0" )
converge( 'ic "/IBank/A_2<16>" "0" )
converge( 'ic "/IBank/A_2<17>" "0" )
converge( 'ic "/IBank/A_2<18>" "0" )
converge( 'ic "/IBank/A_2<19>" "0" )
converge( 'ic "/IBank/A_2<20>" "0" )
converge( 'ic "/IBank/A_2<21>" "0" )
converge( 'ic "/IBank/A_2<22>" "0" )
converge( 'ic "/IBank/A_2<23>" "0" )
converge( 'ic "/IBank/A_2<24>" "0" )
converge( 'ic "/IBank/A_2<25>" "0" )
converge( 'ic "/IBank/A_2<26>" "0" )
converge( 'ic "/IBank/A_2<27>" "0" )
converge( 'ic "/IBank/A_2<28>" "0" )
converge( 'ic "/IBank/A_2<29>" "0" )
converge( 'ic "/IBank/A_2<30>" "0" )
converge( 'ic "/IBank/A_2<31>" "0" )
converge( 'ic "/IBank/A_2<32>" "0" )
converge( 'ic "/IBank/A_2<33>" "0" )
converge( 'ic "/IBank/A_2<34>" "0" )
converge( 'ic "/IBank/A_2<35>" "0" )
converge( 'ic "/IBank/A_2<36>" "0" )
converge( 'ic "/IBank/A_2<37>" "0" )
converge( 'ic "/IBank/A_2<38>" "0" )
converge( 'ic "/IBank/A_2<39>" "0" )
converge( 'ic "/IBank/A_2<40>" "0" )
converge( 'ic "/IBank/A_2<41>" "0" )
converge( 'ic "/IBank/A_2<42>" "0" )
converge( 'ic "/IBank/A_2<43>" "0" )
converge( 'ic "/IBank/A_2<44>" "0" )
converge( 'ic "/IBank/A_2<45>" "0" )
converge( 'ic "/IBank/A_2<46>" "0" )
converge( 'ic "/IBank/A_2<47>" "0" )
converge( 'ic "/IBank/A_2<48>" "0" )
converge( 'ic "/IBank/A_2<49>" "0" )
converge( 'ic "/IBank/A_2<50>" "0" )
converge( 'ic "/IBank/A_2<51>" "0" )
converge( 'ic "/IBank/A_2<52>" "0" )
converge( 'ic "/IBank/A_2<53>" "0" )
converge( 'ic "/IBank/A_2<54>" "0" )
converge( 'ic "/IBank/A_2<55>" "0" )
converge( 'ic "/IBank/A_2<56>" "0" )
converge( 'ic "/IBank/A_2<57>" "0" )
converge( 'ic "/IBank/A_2<58>" "0" )
converge( 'ic "/IBank/A_2<59>" "0" )
converge( 'ic "/IBank/A_2<60>" "0" )
converge( 'ic "/IBank/A_2<61>" "0" )
converge( 'ic "/IBank/A_2<62>" "0" )
converge( 'ic "/IBank/A_2<63>" "0" )
converge( 'ic "/IBank/S_2<0>" "0" )
converge( 'ic "/IBank/S_2<1>" "0" )
converge( 'ic "/IBank/S_2<2>" "0" )
converge( 'ic "/IBank/S_2<3>" "0" )
converge( 'ic "/IBank/S_2<4>" "0" )
converge( 'ic "/IBank/S_2<5>" "0" )
converge( 'ic "/IBank/S_2<6>" "0" )
converge( 'ic "/IBank/S_2<7>" "0" )
converge( 'ic "/IBank/A_3<0>" "0" )
converge( 'ic "/IBank/A_3<1>" "0" )
converge( 'ic "/IBank/A_3<2>" "0" )
converge( 'ic "/IBank/A_3<3>" "0" )
converge( 'ic "/IBank/A_3<4>" "0" )
converge( 'ic "/IBank/A_3<5>" "0" )
converge( 'ic "/IBank/A_3<6>" "0" )
converge( 'ic "/IBank/A_3<7>" "0" )
converge( 'ic "/IBank/A_3<8>" "0" )
converge( 'ic "/IBank/A_3<9>" "0" )
converge( 'ic "/IBank/A_3<10>" "0" )
converge( 'ic "/IBank/A_3<11>" "0" )
converge( 'ic "/IBank/A_3<12>" "0" )
converge( 'ic "/IBank/A_3<13>" "0" )
converge( 'ic "/IBank/A_3<14>" "0" )
converge( 'ic "/IBank/A_3<15>" "0" )
converge( 'ic "/IBank/A_3<16>" "0" )
converge( 'ic "/IBank/A_3<17>" "0" )
converge( 'ic "/IBank/A_3<18>" "0" )
converge( 'ic "/IBank/A_3<19>" "0" )
converge( 'ic "/IBank/A_3<20>" "0" )
converge( 'ic "/IBank/A_3<21>" "0" )
converge( 'ic "/IBank/A_3<22>" "0" )
converge( 'ic "/IBank/A_3<23>" "0" )
converge( 'ic "/IBank/A_3<24>" "0" )
converge( 'ic "/IBank/A_3<25>" "0" )
converge( 'ic "/IBank/A_3<26>" "0" )
converge( 'ic "/IBank/A_3<27>" "0" )
converge( 'ic "/IBank/A_3<28>" "0" )
converge( 'ic "/IBank/A_3<29>" "0" )
converge( 'ic "/IBank/A_3<30>" "0" )
converge( 'ic "/IBank/A_3<31>" "0" )
converge( 'ic "/IBank/A_3<32>" "0" )
converge( 'ic "/IBank/A_3<33>" "0" )
converge( 'ic "/IBank/A_3<34>" "0" )
converge( 'ic "/IBank/A_3<35>" "0" )
converge( 'ic "/IBank/A_3<36>" "0" )
converge( 'ic "/IBank/A_3<37>" "0" )
converge( 'ic "/IBank/A_3<38>" "0" )
converge( 'ic "/IBank/A_3<39>" "0" )
converge( 'ic "/IBank/A_3<40>" "0" )
converge( 'ic "/IBank/A_3<41>" "0" )
converge( 'ic "/IBank/A_3<42>" "0" )
converge( 'ic "/IBank/A_3<43>" "0" )
converge( 'ic "/IBank/A_3<44>" "0" )
converge( 'ic "/IBank/A_3<45>" "0" )
converge( 'ic "/IBank/A_3<46>" "0" )
converge( 'ic "/IBank/A_3<47>" "0" )
converge( 'ic "/IBank/A_3<48>" "0" )
converge( 'ic "/IBank/A_3<49>" "0" )
converge( 'ic "/IBank/A_3<50>" "0" )
converge( 'ic "/IBank/A_3<51>" "0" )
converge( 'ic "/IBank/A_3<52>" "0" )
converge( 'ic "/IBank/A_3<53>" "0" )
converge( 'ic "/IBank/A_3<54>" "0" )
converge( 'ic "/IBank/A_3<55>" "0" )
converge( 'ic "/IBank/A_3<56>" "0" )
converge( 'ic "/IBank/A_3<57>" "0" )
converge( 'ic "/IBank/A_3<58>" "0" )
converge( 'ic "/IBank/A_3<59>" "0" )
converge( 'ic "/IBank/A_3<60>" "0" )
converge( 'ic "/IBank/A_3<61>" "0" )
converge( 'ic "/IBank/A_3<62>" "0" )
converge( 'ic "/IBank/A_3<63>" "0" )
converge( 'ic "/IBank/S_3<0>" "0" )
converge( 'ic "/IBank/S_3<1>" "0" )
converge( 'ic "/IBank/S_3<2>" "0" )
converge( 'ic "/IBank/S_3<3>" "0" )
converge( 'ic "/IBank/S_3<4>" "0" )
converge( 'ic "/IBank/S_3<5>" "0" )
converge( 'ic "/IBank/S_3<6>" "0" )
converge( 'ic "/IBank/S_3<7>" "0" )
converge( 'ic "/IBank/A_4<0>" "0" )
converge( 'ic "/IBank/A_4<1>" "0" )
converge( 'ic "/IBank/A_4<2>" "0" )
converge( 'ic "/IBank/A_4<3>" "0" )
converge( 'ic "/IBank/A_4<4>" "0" )
converge( 'ic "/IBank/A_4<5>" "0" )
converge( 'ic "/IBank/A_4<6>" "0" )
converge( 'ic "/IBank/A_4<7>" "0" )
converge( 'ic "/IBank/A_4<8>" "0" )
converge( 'ic "/IBank/A_4<9>" "0" )
converge( 'ic "/IBank/A_4<10>" "0" )
converge( 'ic "/IBank/A_4<11>" "0" )
converge( 'ic "/IBank/A_4<12>" "0" )
converge( 'ic "/IBank/A_4<13>" "0" )
converge( 'ic "/IBank/A_4<14>" "0" )
converge( 'ic "/IBank/A_4<15>" "0" )
converge( 'ic "/IBank/A_4<16>" "0" )
converge( 'ic "/IBank/A_4<17>" "0" )
converge( 'ic "/IBank/A_4<18>" "0" )
converge( 'ic "/IBank/A_4<19>" "0" )
converge( 'ic "/IBank/A_4<20>" "0" )
converge( 'ic "/IBank/A_4<21>" "0" )
converge( 'ic "/IBank/A_4<22>" "0" )
converge( 'ic "/IBank/A_4<23>" "0" )
converge( 'ic "/IBank/A_4<24>" "0" )
converge( 'ic "/IBank/A_4<25>" "0" )
converge( 'ic "/IBank/A_4<26>" "0" )
converge( 'ic "/IBank/A_4<27>" "0" )
converge( 'ic "/IBank/A_4<28>" "0" )
converge( 'ic "/IBank/A_4<29>" "0" )
converge( 'ic "/IBank/A_4<30>" "0" )
converge( 'ic "/IBank/A_4<31>" "0" )
converge( 'ic "/IBank/A_4<32>" "0" )
converge( 'ic "/IBank/A_4<33>" "0" )
converge( 'ic "/IBank/A_4<34>" "0" )
converge( 'ic "/IBank/A_4<35>" "0" )
converge( 'ic "/IBank/A_4<36>" "0" )
converge( 'ic "/IBank/A_4<37>" "0" )
converge( 'ic "/IBank/A_4<38>" "0" )
converge( 'ic "/IBank/A_4<39>" "0" )
converge( 'ic "/IBank/A_4<40>" "0" )
converge( 'ic "/IBank/A_4<41>" "0" )
converge( 'ic "/IBank/A_4<42>" "0" )
converge( 'ic "/IBank/A_4<43>" "0" )
converge( 'ic "/IBank/A_4<44>" "0" )
converge( 'ic "/IBank/A_4<45>" "0" )
converge( 'ic "/IBank/A_4<46>" "0" )
converge( 'ic "/IBank/A_4<47>" "0" )
converge( 'ic "/IBank/A_4<48>" "0" )
converge( 'ic "/IBank/A_4<49>" "0" )
converge( 'ic "/IBank/A_4<50>" "0" )
converge( 'ic "/IBank/A_4<51>" "0" )
converge( 'ic "/IBank/A_4<52>" "0" )
converge( 'ic "/IBank/A_4<53>" "0" )
converge( 'ic "/IBank/A_4<54>" "0" )
converge( 'ic "/IBank/A_4<55>" "0" )
converge( 'ic "/IBank/A_4<56>" "0" )
converge( 'ic "/IBank/A_4<57>" "0" )
converge( 'ic "/IBank/A_4<58>" "0" )
converge( 'ic "/IBank/A_4<59>" "0" )
converge( 'ic "/IBank/A_4<60>" "0" )
converge( 'ic "/IBank/A_4<61>" "0" )
converge( 'ic "/IBank/A_4<62>" "0" )
converge( 'ic "/IBank/A_4<63>" "0" )
converge( 'ic "/IBank/S_4<0>" "0" )
converge( 'ic "/IBank/S_4<1>" "0" )
converge( 'ic "/IBank/S_4<2>" "0" )
converge( 'ic "/IBank/S_4<3>" "0" )
converge( 'ic "/IBank/S_4<4>" "0" )
converge( 'ic "/IBank/S_4<5>" "0" )
converge( 'ic "/IBank/S_4<6>" "0" )
converge( 'ic "/IBank/S_4<7>" "0" )
converge( 'ic "/IBank/IDATA0/wack<0>" "0" )
converge( 'ic "/IBank/IDATA0/wack<1>" "0" )
converge( 'ic "/IBank/IDATA0/Wen" "0" )
converge( 'ic "/IBank/IDATA0/wack<2>" "0" )
converge( 'ic "/IBank/IDATA0/wack<3>" "0" )
converge( 'ic "/IBank/IDATA0/nB0<2>" "0" )
converge( 'ic "/IBank/IDATA0/nB0<3>" "0" )
converge( 'ic "/IBank/IDATA0/nB1<2>" "0" )
converge( 'ic "/IBank/IDATA0/nB1<3>" "0" )
converge( 'ic "/IBank/IDATA0/nB0<0>" "0" )
converge( 'ic "/IBank/IDATA0/nB0<1>" "0" )
converge( 'ic "/IBank/IDATA0/nB1<0>" "0" )
converge( 'ic "/IBank/IDATA0/nB1<1>" "0" )
converge( 'ic "/IBank/IDATA0/Lack<0>" "0" )
converge( 'ic "/IBank/IDATA0/Lack<1>" "0" )
converge( 'ic "/IBank/IDATA0/Lack<2>" "0" )
converge( 'ic "/IBank/IDATA0/Lack<3>" "0" )
converge( 'ic "/IBank/IDATA0/R1<0>" "0" )
converge( 'ic "/IBank/IDATA0/R1<1>" "0" )
converge( 'ic "/IBank/IDATA0/R1<2>" "0" )
converge( 'ic "/IBank/IDATA0/R1<3>" "0" )
converge( 'ic "/IBank/IDATA0/R0<0>" "0" )
converge( 'ic "/IBank/IDATA0/R0<1>" "0" )
converge( 'ic "/IBank/IDATA0/R0<2>" "0" )
converge( 'ic "/IBank/IDATA0/R0<3>" "0" )
converge( 'ic "/IBank/IDATA0/R1q<0>" "0" )
converge( 'ic "/IBank/IDATA0/R1q<1>" "0" )
converge( 'ic "/IBank/IDATA0/R1q<2>" "0" )
converge( 'ic "/IBank/IDATA0/R1q<3>" "0" )
converge( 'ic "/IBank/IDATA0/R0q<0>" "0" )
converge( 'ic "/IBank/IDATA0/R0q<1>" "0" )
converge( 'ic "/IBank/IDATA0/R0q<2>" "0" )
converge( 'ic "/IBank/IDATA0/R0q<3>" "0" )
converge( 'ic "/IBank/IDATA0/RpAck<0>" "vdd" )
converge( 'ic "/IBank/IDATA0/RpAck<1>" "vdd" )
converge( 'ic "/IBank/IDATA0/RpAck<2>" "vdd" )
converge( 'ic "/IBank/IDATA0/RpAck<3>" "vdd" )
converge( 'ic "/IBank/IDATA0/IWPCHB0<1>/net027" "vdd" )
converge( 'ic "/IBank/IDATA0/IWPCHB0<1>/inAck" "vdd" )
converge( 'ic "/IBank/IDATA0/IWPCHB0<1>/oE" "vdd" )
converge( 'ic "/IBank/IDATA0/IWWCHB0/~Out0<1>" "vdd" )
converge( 'ic "/IBank/IDATA0/IWWCHB0/~Out1<1>" "vdd" )
converge( 'ic "/IBank/IDATA0/IWWCHB0/~Out0<0>" "vdd" )
converge( 'ic "/IBank/IDATA0/IWWCHB0/~Out1<0>" "vdd" )
converge( 'ic "/IBank/IDATA0/IWWCHB0/b1<0>" "vdd" )
converge( 'ic "/IBank/IDATA0/IWWCHB0/b0<1>" "vdd" )
converge( 'ic "/IBank/IDATA0/IWWCHB0/b1<1>" "vdd" )
converge( 'ic "/IBank/IDATA0/IWWCHB0/b0<0>" "vdd" )
converge( 'ic "/IBank/IDATA0/IWWCHB0/nxa" "vdd" )
converge( 'ic "/IBank/IDATA0/IWWCHB0/n<3>" "0" )
converge( 'ic "/IBank/IDATA0/IWWCHB0/n<2>" "0" )
converge( 'ic "/IBank/IDATA0/IWWCHB0/n<1>" "0" )
converge( 'ic "/IBank/IDATA0/IWWCHB0/n<0>" "0" )
converge( 'ic "/IBank/ICHUNK0/IARRAY0/ISRAM0/I7/I3/Q0" "0" )
converge( 'ic "/IBank/ICHUNK0/IARRAY0/ISRAM0/I7/I3/Q1" "vdd" )
temp( 30.0 )
run()
selectResult( 'tran )
plot(getData("/vdd!") getData("/vcc!") getData("/WriteDataT<3>") getData("/WriteDataT<2>") getData("/WriteDataT<1>") getData("/WriteDataT<0>") getData("/WDataAckT<7>") getData("/WDataAckT<6>") getData("/WDataAckT<5>") getData("/WDataAckT<4>") getData("/WDataAckT<3>") getData("/WDataAckT<2>") getData("/WDataAckT<1>") getData("/WDataAckT<0>") getData("/V1/PLUS") getData("/V1/MINUS") getData("/V0/PLUS") getData("/V0/MINUS") getData("/ReadDataAckT<7>") getData("/ReadDataAckT<6>") getData("/ReadDataAckT<5>") getData("/ReadDataAckT<4>") getData("/ReadDataAckT<3>") getData("/ReadDataAckT<2>") getData("/ReadDataAckT<1>") getData("/ReadDataAckT<0>") getData("/ReadDataAck<7:0>") getData("/ReaDataT<3>") getData("/ReaDataT<2>") getData("/ReaDataT<1>") getData("/ReaDataT<0>") getData("/RWT<1>") getData("/RWT<0>") getData("/IBank/~R1_1<3>") getData("/IBank/~R1_1<2>") getData("/IBank/~R1_1<1>") getData("/IBank/~R1_1<0>") getData("/IBank/~R0_1<3>") getData("/IBank/~R0_1<2>") getData("/IBank/~R0_1<1>") getData("/IBank/~R0_1<0>") getData("/IBank/outAck") getData("/IBank/ck<3>") getData("/IBank/ck<2>") getData("/IBank/ck<1>") getData("/IBank/ck<0>") getData("/IBank/W1_1<3>") getData("/IBank/W1_1<2>") getData("/IBank/W1_1<1>") getData("/IBank/W1_1<0>") getData("/IBank/W0_1<3>") getData("/IBank/W0_1<2>") getData("/IBank/W0_1<1>") getData("/IBank/W0_1<0>") getData("/IBank/ValAddr") getData("/IBank/S_1<7>") getData("/IBank/S_1<6>") getData("/IBank/S_1<5>") getData("/IBank/S_1<4>") getData("/IBank/S_1<3>") getData("/IBank/S_1<2>") getData("/IBank/S_1<1>") getData("/IBank/S_1<0>") getData("/IBank/Reset") getData("/IBank/G01") getData("/IBank/B1_1<3>") getData("/IBank/B1_1<2>") getData("/IBank/B1_1<1>") getData("/IBank/B1_1<0>") getData("/IBank/B0_1<3>") getData("/IBank/B0_1<2>") getData("/IBank/B0_1<1>") getData("/IBank/B0_1<0>") getData("/IBank/AvAck<3>") getData("/IBank/AvAck<2>") getData("/IBank/AvAck<1>") getData("/IBank/AvAck<0>") getData("/IBank/A_1<9>") getData("/IBank/A_1<8>") getData("/IBank/A_1<7>") getData("/IBank/A_1<6>") getData("/IBank/A_1<63>") getData("/IBank/A_1<62>") getData("/IBank/A_1<61>") getData("/IBank/A_1<60>") getData("/IBank/A_1<5>") getData("/IBank/A_1<59>") getData("/IBank/A_1<58>") getData("/IBank/A_1<57>") getData("/IBank/A_1<56>") getData("/IBank/A_1<55>") getData("/IBank/A_1<54>") getData("/IBank/A_1<53>") getData("/IBank/A_1<52>") getData("/IBank/A_1<51>") getData("/IBank/A_1<50>") getData("/IBank/A_1<4>") getData("/IBank/A_1<49>") getData("/IBank/A_1<48>") getData("/IBank/A_1<47>") getData("/IBank/A_1<46>") getData("/IBank/A_1<45>") getData("/IBank/A_1<44>") getData("/IBank/A_1<43>") getData("/IBank/A_1<42>") getData("/IBank/A_1<41>") getData("/IBank/A_1<40>") getData("/IBank/A_1<3>") getData("/IBank/A_1<39>") getData("/IBank/A_1<38>") getData("/IBank/A_1<37>") getData("/IBank/A_1<36>") getData("/IBank/A_1<35>") getData("/IBank/A_1<34>") getData("/IBank/A_1<33>") getData("/IBank/A_1<32>") getData("/IBank/A_1<31>") getData("/IBank/A_1<30>") getData("/IBank/A_1<2>") getData("/IBank/A_1<29>") getData("/IBank/A_1<28>") getData("/IBank/A_1<27>") getData("/IBank/A_1<26>") getData("/IBank/A_1<25>") getData("/IBank/A_1<24>") getData("/IBank/A_1<23>") getData("/IBank/A_1<22>") getData("/IBank/A_1<21>") getData("/IBank/A_1<20>") getData("/IBank/A_1<1>") getData("/IBank/A_1<19>") getData("/IBank/A_1<18>") getData("/IBank/A_1<17>") getData("/IBank/A_1<16>") getData("/IBank/A_1<15>") getData("/IBank/A_1<14>") getData("/IBank/A_1<13>") getData("/IBank/A_1<12>") getData("/IBank/A_1<11>") getData("/IBank/A_1<10>") getData("/IBank/A_1<0>") getData("/Ack") getData("/AT<9>") getData("/AT<8>") getData("/AT<7>") getData("/AT<6>") getData("/AT<5>") getData("/AT<4>") getData("/AT<3>") getData("/AT<2>") getData("/AT<1>") getData("/AT<19>") getData("/AT<18>") getData("/AT<17>") getData("/AT<16>") getData("/AT<15>") getData("/AT<14>") getData("/AT<13>") getData("/AT<12>") getData("/AT<11>") getData("/AT<10>") getData("/AT<0>") getData("/WriteData<31:0>") getData("/WriteDataAck<7:0>") getData("/A<19:0>") getData("/RW<1:0>") getData("/Ctrl_Ack<4:0>") getData("/ReadData<31:0>") )
resultsDir( "/tmp2/Cadence/simulation/6T_BANK_Test/spectreVerilog/config" )
modelFile(
    '("/software/cadence/ncsu-FreePDK15/hspice_16nm_hp.include" "")
)
run()
selectResult( 'tran )
plot(getData("/vdd!") getData("/vcc!") getData("/WriteDataT<3>") getData("/WriteDataT<2>") getData("/WriteDataT<1>") getData("/WriteDataT<0>") getData("/WDataAckT<7>") getData("/WDataAckT<6>") getData("/WDataAckT<5>") getData("/WDataAckT<4>") getData("/WDataAckT<3>") getData("/WDataAckT<2>") getData("/WDataAckT<1>") getData("/WDataAckT<0>") getData("/V1/PLUS") getData("/V1/MINUS") getData("/V0/PLUS") getData("/V0/MINUS") getData("/ReadDataAckT<7>") getData("/ReadDataAckT<6>") getData("/ReadDataAckT<5>") getData("/ReadDataAckT<4>") getData("/ReadDataAckT<3>") getData("/ReadDataAckT<2>") getData("/ReadDataAckT<1>") getData("/ReadDataAckT<0>") getData("/ReadDataAck<7:0>") getData("/ReaDataT<3>") getData("/ReaDataT<2>") getData("/ReaDataT<1>") getData("/ReaDataT<0>") getData("/RWT<1>") getData("/RWT<0>") getData("/IBank/~R1_1<3>") getData("/IBank/~R1_1<2>") getData("/IBank/~R1_1<1>") getData("/IBank/~R1_1<0>") getData("/IBank/~R0_1<3>") getData("/IBank/~R0_1<2>") getData("/IBank/~R0_1<1>") getData("/IBank/~R0_1<0>") getData("/IBank/outAck") getData("/IBank/ck<3>") getData("/IBank/ck<2>") getData("/IBank/ck<1>") getData("/IBank/ck<0>") getData("/IBank/W1_1<3>") getData("/IBank/W1_1<2>") getData("/IBank/W1_1<1>") getData("/IBank/W1_1<0>") getData("/IBank/W0_1<3>") getData("/IBank/W0_1<2>") getData("/IBank/W0_1<1>") getData("/IBank/W0_1<0>") getData("/IBank/ValAddr") getData("/IBank/S_1<7>") getData("/IBank/S_1<6>") getData("/IBank/S_1<5>") getData("/IBank/S_1<4>") getData("/IBank/S_1<3>") getData("/IBank/S_1<2>") getData("/IBank/S_1<1>") getData("/IBank/S_1<0>") getData("/IBank/Reset") getData("/IBank/G01") getData("/IBank/B1_1<3>") getData("/IBank/B1_1<2>") getData("/IBank/B1_1<1>") getData("/IBank/B1_1<0>") getData("/IBank/B0_1<3>") getData("/IBank/B0_1<2>") getData("/IBank/B0_1<1>") getData("/IBank/B0_1<0>") getData("/IBank/AvAck<3>") getData("/IBank/AvAck<2>") getData("/IBank/AvAck<1>") getData("/IBank/AvAck<0>") getData("/IBank/A_1<9>") getData("/IBank/A_1<8>") getData("/IBank/A_1<7>") getData("/IBank/A_1<6>") getData("/IBank/A_1<63>") getData("/IBank/A_1<62>") getData("/IBank/A_1<61>") getData("/IBank/A_1<60>") getData("/IBank/A_1<5>") getData("/IBank/A_1<59>") getData("/IBank/A_1<58>") getData("/IBank/A_1<57>") getData("/IBank/A_1<56>") getData("/IBank/A_1<55>") getData("/IBank/A_1<54>") getData("/IBank/A_1<53>") getData("/IBank/A_1<52>") getData("/IBank/A_1<51>") getData("/IBank/A_1<50>") getData("/IBank/A_1<4>") getData("/IBank/A_1<49>") getData("/IBank/A_1<48>") getData("/IBank/A_1<47>") getData("/IBank/A_1<46>") getData("/IBank/A_1<45>") getData("/IBank/A_1<44>") getData("/IBank/A_1<43>") getData("/IBank/A_1<42>") getData("/IBank/A_1<41>") getData("/IBank/A_1<40>") getData("/IBank/A_1<3>") getData("/IBank/A_1<39>") getData("/IBank/A_1<38>") getData("/IBank/A_1<37>") getData("/IBank/A_1<36>") getData("/IBank/A_1<35>") getData("/IBank/A_1<34>") getData("/IBank/A_1<33>") getData("/IBank/A_1<32>") getData("/IBank/A_1<31>") getData("/IBank/A_1<30>") getData("/IBank/A_1<2>") getData("/IBank/A_1<29>") getData("/IBank/A_1<28>") getData("/IBank/A_1<27>") getData("/IBank/A_1<26>") getData("/IBank/A_1<25>") getData("/IBank/A_1<24>") getData("/IBank/A_1<23>") getData("/IBank/A_1<22>") getData("/IBank/A_1<21>") getData("/IBank/A_1<20>") getData("/IBank/A_1<1>") getData("/IBank/A_1<19>") getData("/IBank/A_1<18>") getData("/IBank/A_1<17>") getData("/IBank/A_1<16>") getData("/IBank/A_1<15>") getData("/IBank/A_1<14>") getData("/IBank/A_1<13>") getData("/IBank/A_1<12>") getData("/IBank/A_1<11>") getData("/IBank/A_1<10>") getData("/IBank/A_1<0>") getData("/Ack") getData("/AT<9>") getData("/AT<8>") getData("/AT<7>") getData("/AT<6>") getData("/AT<5>") getData("/AT<4>") getData("/AT<3>") getData("/AT<2>") getData("/AT<1>") getData("/AT<19>") getData("/AT<18>") getData("/AT<17>") getData("/AT<16>") getData("/AT<15>") getData("/AT<14>") getData("/AT<13>") getData("/AT<12>") getData("/AT<11>") getData("/AT<10>") getData("/AT<0>") getData("/WriteData<31:0>") getData("/WriteDataAck<7:0>") getData("/A<19:0>") getData("/RW<1:0>") getData("/Ctrl_Ack<4:0>") getData("/ReadData<31:0>") )
modelFile(
    '("/software/cadence/ncsu-FreePDK15/hspice_16nm_hp.include" "")
)
analysis('tran ?stop "12n "  )
run()
selectResult( 'tran )
plot(getData("/vdd!") getData("/vcc!") getData("/WriteDataT<3>") getData("/WriteDataT<2>") getData("/WriteDataT<1>") getData("/WriteDataT<0>") getData("/WDataAckT<7>") getData("/WDataAckT<6>") getData("/WDataAckT<5>") getData("/WDataAckT<4>") getData("/WDataAckT<3>") getData("/WDataAckT<2>") getData("/WDataAckT<1>") getData("/WDataAckT<0>") getData("/V1/PLUS") getData("/V1/MINUS") getData("/V0/PLUS") getData("/V0/MINUS") getData("/ReadDataAckT<7>") getData("/ReadDataAckT<6>") getData("/ReadDataAckT<5>") getData("/ReadDataAckT<4>") getData("/ReadDataAckT<3>") getData("/ReadDataAckT<2>") getData("/ReadDataAckT<1>") getData("/ReadDataAckT<0>") getData("/ReadDataAck<7:0>") getData("/ReaDataT<3>") getData("/ReaDataT<2>") getData("/ReaDataT<1>") getData("/ReaDataT<0>") getData("/RWT<1>") getData("/RWT<0>") getData("/IBank/~R1_1<3>") getData("/IBank/~R1_1<2>") getData("/IBank/~R1_1<1>") getData("/IBank/~R1_1<0>") getData("/IBank/~R0_1<3>") getData("/IBank/~R0_1<2>") getData("/IBank/~R0_1<1>") getData("/IBank/~R0_1<0>") getData("/IBank/outAck") getData("/IBank/ck<3>") getData("/IBank/ck<2>") getData("/IBank/ck<1>") getData("/IBank/ck<0>") getData("/IBank/W1_1<3>") getData("/IBank/W1_1<2>") getData("/IBank/W1_1<1>") getData("/IBank/W1_1<0>") getData("/IBank/W0_1<3>") getData("/IBank/W0_1<2>") getData("/IBank/W0_1<1>") getData("/IBank/W0_1<0>") getData("/IBank/ValAddr") getData("/IBank/S_1<7>") getData("/IBank/S_1<6>") getData("/IBank/S_1<5>") getData("/IBank/S_1<4>") getData("/IBank/S_1<3>") getData("/IBank/S_1<2>") getData("/IBank/S_1<1>") getData("/IBank/S_1<0>") getData("/IBank/Reset") getData("/IBank/G01") getData("/IBank/B1_1<3>") getData("/IBank/B1_1<2>") getData("/IBank/B1_1<1>") getData("/IBank/B1_1<0>") getData("/IBank/B0_1<3>") getData("/IBank/B0_1<2>") getData("/IBank/B0_1<1>") getData("/IBank/B0_1<0>") getData("/IBank/AvAck<3>") getData("/IBank/AvAck<2>") getData("/IBank/AvAck<1>") getData("/IBank/AvAck<0>") getData("/IBank/A_1<9>") getData("/IBank/A_1<8>") getData("/IBank/A_1<7>") getData("/IBank/A_1<6>") getData("/IBank/A_1<63>") getData("/IBank/A_1<62>") getData("/IBank/A_1<61>") getData("/IBank/A_1<60>") getData("/IBank/A_1<5>") getData("/IBank/A_1<59>") getData("/IBank/A_1<58>") getData("/IBank/A_1<57>") getData("/IBank/A_1<56>") getData("/IBank/A_1<55>") getData("/IBank/A_1<54>") getData("/IBank/A_1<53>") getData("/IBank/A_1<52>") getData("/IBank/A_1<51>") getData("/IBank/A_1<50>") getData("/IBank/A_1<4>") getData("/IBank/A_1<49>") getData("/IBank/A_1<48>") getData("/IBank/A_1<47>") getData("/IBank/A_1<46>") getData("/IBank/A_1<45>") getData("/IBank/A_1<44>") getData("/IBank/A_1<43>") getData("/IBank/A_1<42>") getData("/IBank/A_1<41>") getData("/IBank/A_1<40>") getData("/IBank/A_1<3>") getData("/IBank/A_1<39>") getData("/IBank/A_1<38>") getData("/IBank/A_1<37>") getData("/IBank/A_1<36>") getData("/IBank/A_1<35>") getData("/IBank/A_1<34>") getData("/IBank/A_1<33>") getData("/IBank/A_1<32>") getData("/IBank/A_1<31>") getData("/IBank/A_1<30>") getData("/IBank/A_1<2>") getData("/IBank/A_1<29>") getData("/IBank/A_1<28>") getData("/IBank/A_1<27>") getData("/IBank/A_1<26>") getData("/IBank/A_1<25>") getData("/IBank/A_1<24>") getData("/IBank/A_1<23>") getData("/IBank/A_1<22>") getData("/IBank/A_1<21>") getData("/IBank/A_1<20>") getData("/IBank/A_1<1>") getData("/IBank/A_1<19>") getData("/IBank/A_1<18>") getData("/IBank/A_1<17>") getData("/IBank/A_1<16>") getData("/IBank/A_1<15>") getData("/IBank/A_1<14>") getData("/IBank/A_1<13>") getData("/IBank/A_1<12>") getData("/IBank/A_1<11>") getData("/IBank/A_1<10>") getData("/IBank/A_1<0>") getData("/Ack") getData("/AT<9>") getData("/AT<8>") getData("/AT<7>") getData("/AT<6>") getData("/AT<5>") getData("/AT<4>") getData("/AT<3>") getData("/AT<2>") getData("/AT<1>") getData("/AT<19>") getData("/AT<18>") getData("/AT<17>") getData("/AT<16>") getData("/AT<15>") getData("/AT<14>") getData("/AT<13>") getData("/AT<12>") getData("/AT<11>") getData("/AT<10>") getData("/AT<0>") getData("/WriteData<31:0>") getData("/WriteDataAck<7:0>") getData("/A<19:0>") getData("/RW<1:0>") getData("/Ctrl_Ack<4:0>") getData("/ReadData<31:0>") )
modelFile(
    '("/software/cadence/ncsu-FreePDK15/hspice_16nm_hp.include" "")
)
run()
selectResult( 'tran )
plot(getData("/vdd!") getData("/vcc!") getData("/WriteDataT<3>") getData("/WriteDataT<2>") getData("/WriteDataT<1>") getData("/WriteDataT<0>") getData("/WDataAckT<7>") getData("/WDataAckT<6>") getData("/WDataAckT<5>") getData("/WDataAckT<4>") getData("/WDataAckT<3>") getData("/WDataAckT<2>") getData("/WDataAckT<1>") getData("/WDataAckT<0>") getData("/V1/PLUS") getData("/V1/MINUS") getData("/V0/PLUS") getData("/V0/MINUS") getData("/ReadDataAckT<7>") getData("/ReadDataAckT<6>") getData("/ReadDataAckT<5>") getData("/ReadDataAckT<4>") getData("/ReadDataAckT<3>") getData("/ReadDataAckT<2>") getData("/ReadDataAckT<1>") getData("/ReadDataAckT<0>") getData("/ReadDataAck<7:0>") getData("/ReaDataT<3>") getData("/ReaDataT<2>") getData("/ReaDataT<1>") getData("/ReaDataT<0>") getData("/RWT<1>") getData("/RWT<0>") getData("/IBank/~R1_1<3>") getData("/IBank/~R1_1<2>") getData("/IBank/~R1_1<1>") getData("/IBank/~R1_1<0>") getData("/IBank/~R0_1<3>") getData("/IBank/~R0_1<2>") getData("/IBank/~R0_1<1>") getData("/IBank/~R0_1<0>") getData("/IBank/outAck") getData("/IBank/ck<3>") getData("/IBank/ck<2>") getData("/IBank/ck<1>") getData("/IBank/ck<0>") getData("/IBank/W1_1<3>") getData("/IBank/W1_1<2>") getData("/IBank/W1_1<1>") getData("/IBank/W1_1<0>") getData("/IBank/W0_1<3>") getData("/IBank/W0_1<2>") getData("/IBank/W0_1<1>") getData("/IBank/W0_1<0>") getData("/IBank/ValAddr") getData("/IBank/S_1<7>") getData("/IBank/S_1<6>") getData("/IBank/S_1<5>") getData("/IBank/S_1<4>") getData("/IBank/S_1<3>") getData("/IBank/S_1<2>") getData("/IBank/S_1<1>") getData("/IBank/S_1<0>") getData("/IBank/Reset") getData("/IBank/G01") getData("/IBank/B1_1<3>") getData("/IBank/B1_1<2>") getData("/IBank/B1_1<1>") getData("/IBank/B1_1<0>") getData("/IBank/B0_1<3>") getData("/IBank/B0_1<2>") getData("/IBank/B0_1<1>") getData("/IBank/B0_1<0>") getData("/IBank/AvAck<3>") getData("/IBank/AvAck<2>") getData("/IBank/AvAck<1>") getData("/IBank/AvAck<0>") getData("/IBank/A_1<9>") getData("/IBank/A_1<8>") getData("/IBank/A_1<7>") getData("/IBank/A_1<6>") getData("/IBank/A_1<63>") getData("/IBank/A_1<62>") getData("/IBank/A_1<61>") getData("/IBank/A_1<60>") getData("/IBank/A_1<5>") getData("/IBank/A_1<59>") getData("/IBank/A_1<58>") getData("/IBank/A_1<57>") getData("/IBank/A_1<56>") getData("/IBank/A_1<55>") getData("/IBank/A_1<54>") getData("/IBank/A_1<53>") getData("/IBank/A_1<52>") getData("/IBank/A_1<51>") getData("/IBank/A_1<50>") getData("/IBank/A_1<4>") getData("/IBank/A_1<49>") getData("/IBank/A_1<48>") getData("/IBank/A_1<47>") getData("/IBank/A_1<46>") getData("/IBank/A_1<45>") getData("/IBank/A_1<44>") getData("/IBank/A_1<43>") getData("/IBank/A_1<42>") getData("/IBank/A_1<41>") getData("/IBank/A_1<40>") getData("/IBank/A_1<3>") getData("/IBank/A_1<39>") getData("/IBank/A_1<38>") getData("/IBank/A_1<37>") getData("/IBank/A_1<36>") getData("/IBank/A_1<35>") getData("/IBank/A_1<34>") getData("/IBank/A_1<33>") getData("/IBank/A_1<32>") getData("/IBank/A_1<31>") getData("/IBank/A_1<30>") getData("/IBank/A_1<2>") getData("/IBank/A_1<29>") getData("/IBank/A_1<28>") getData("/IBank/A_1<27>") getData("/IBank/A_1<26>") getData("/IBank/A_1<25>") getData("/IBank/A_1<24>") getData("/IBank/A_1<23>") getData("/IBank/A_1<22>") getData("/IBank/A_1<21>") getData("/IBank/A_1<20>") getData("/IBank/A_1<1>") getData("/IBank/A_1<19>") getData("/IBank/A_1<18>") getData("/IBank/A_1<17>") getData("/IBank/A_1<16>") getData("/IBank/A_1<15>") getData("/IBank/A_1<14>") getData("/IBank/A_1<13>") getData("/IBank/A_1<12>") getData("/IBank/A_1<11>") getData("/IBank/A_1<10>") getData("/IBank/A_1<0>") getData("/Ack") getData("/AT<9>") getData("/AT<8>") getData("/AT<7>") getData("/AT<6>") getData("/AT<5>") getData("/AT<4>") getData("/AT<3>") getData("/AT<2>") getData("/AT<1>") getData("/AT<19>") getData("/AT<18>") getData("/AT<17>") getData("/AT<16>") getData("/AT<15>") getData("/AT<14>") getData("/AT<13>") getData("/AT<12>") getData("/AT<11>") getData("/AT<10>") getData("/AT<0>") getData("/WriteData<31:0>") getData("/WriteDataAck<7:0>") getData("/A<19:0>") getData("/RW<1:0>") getData("/Ctrl_Ack<4:0>") getData("/ReadData<31:0>") )
resultsDir( "/net/kafka/nfs/rstdenis/Cadence/simulation/6T_BANK_Test/spectreVerilog/config" )
modelFile(
    '("/software/cadence/ncsu-FreePDK15/hspice_16nm_hp.include" "")
)
run()
selectResult( 'tran )
plot(getData("/vdd!") getData("/vcc!") getData("/WriteDataT<3>") getData("/WriteDataT<2>") getData("/WriteDataT<1>") getData("/WriteDataT<0>") getData("/WDataAckT<7>") getData("/WDataAckT<6>") getData("/WDataAckT<5>") getData("/WDataAckT<4>") getData("/WDataAckT<3>") getData("/WDataAckT<2>") getData("/WDataAckT<1>") getData("/WDataAckT<0>") getData("/V1/PLUS") getData("/V1/MINUS") getData("/V0/PLUS") getData("/V0/MINUS") getData("/ReadDataAckT<7>") getData("/ReadDataAckT<6>") getData("/ReadDataAckT<5>") getData("/ReadDataAckT<4>") getData("/ReadDataAckT<3>") getData("/ReadDataAckT<2>") getData("/ReadDataAckT<1>") getData("/ReadDataAckT<0>") getData("/ReadDataAck<7:0>") getData("/ReaDataT<3>") getData("/ReaDataT<2>") getData("/ReaDataT<1>") getData("/ReaDataT<0>") getData("/RWT<1>") getData("/RWT<0>") getData("/IBank/~R1_1<3>") getData("/IBank/~R1_1<2>") getData("/IBank/~R1_1<1>") getData("/IBank/~R1_1<0>") getData("/IBank/~R0_1<3>") getData("/IBank/~R0_1<2>") getData("/IBank/~R0_1<1>") getData("/IBank/~R0_1<0>") getData("/IBank/outAck") getData("/IBank/ck<3>") getData("/IBank/ck<2>") getData("/IBank/ck<1>") getData("/IBank/ck<0>") getData("/IBank/W1_1<3>") getData("/IBank/W1_1<2>") getData("/IBank/W1_1<1>") getData("/IBank/W1_1<0>") getData("/IBank/W0_1<3>") getData("/IBank/W0_1<2>") getData("/IBank/W0_1<1>") getData("/IBank/W0_1<0>") getData("/IBank/ValAddr") getData("/IBank/S_1<7>") getData("/IBank/S_1<6>") getData("/IBank/S_1<5>") getData("/IBank/S_1<4>") getData("/IBank/S_1<3>") getData("/IBank/S_1<2>") getData("/IBank/S_1<1>") getData("/IBank/S_1<0>") getData("/IBank/Reset") getData("/IBank/G01") getData("/IBank/B1_1<3>") getData("/IBank/B1_1<2>") getData("/IBank/B1_1<1>") getData("/IBank/B1_1<0>") getData("/IBank/B0_1<3>") getData("/IBank/B0_1<2>") getData("/IBank/B0_1<1>") getData("/IBank/B0_1<0>") getData("/IBank/AvAck<3>") getData("/IBank/AvAck<2>") getData("/IBank/AvAck<1>") getData("/IBank/AvAck<0>") getData("/IBank/A_1<9>") getData("/IBank/A_1<8>") getData("/IBank/A_1<7>") getData("/IBank/A_1<6>") getData("/IBank/A_1<63>") getData("/IBank/A_1<62>") getData("/IBank/A_1<61>") getData("/IBank/A_1<60>") getData("/IBank/A_1<5>") getData("/IBank/A_1<59>") getData("/IBank/A_1<58>") getData("/IBank/A_1<57>") getData("/IBank/A_1<56>") getData("/IBank/A_1<55>") getData("/IBank/A_1<54>") getData("/IBank/A_1<53>") getData("/IBank/A_1<52>") getData("/IBank/A_1<51>") getData("/IBank/A_1<50>") getData("/IBank/A_1<4>") getData("/IBank/A_1<49>") getData("/IBank/A_1<48>") getData("/IBank/A_1<47>") getData("/IBank/A_1<46>") getData("/IBank/A_1<45>") getData("/IBank/A_1<44>") getData("/IBank/A_1<43>") getData("/IBank/A_1<42>") getData("/IBank/A_1<41>") getData("/IBank/A_1<40>") getData("/IBank/A_1<3>") getData("/IBank/A_1<39>") getData("/IBank/A_1<38>") getData("/IBank/A_1<37>") getData("/IBank/A_1<36>") getData("/IBank/A_1<35>") getData("/IBank/A_1<34>") getData("/IBank/A_1<33>") getData("/IBank/A_1<32>") getData("/IBank/A_1<31>") getData("/IBank/A_1<30>") getData("/IBank/A_1<2>") getData("/IBank/A_1<29>") getData("/IBank/A_1<28>") getData("/IBank/A_1<27>") getData("/IBank/A_1<26>") getData("/IBank/A_1<25>") getData("/IBank/A_1<24>") getData("/IBank/A_1<23>") getData("/IBank/A_1<22>") getData("/IBank/A_1<21>") getData("/IBank/A_1<20>") getData("/IBank/A_1<1>") getData("/IBank/A_1<19>") getData("/IBank/A_1<18>") getData("/IBank/A_1<17>") getData("/IBank/A_1<16>") getData("/IBank/A_1<15>") getData("/IBank/A_1<14>") getData("/IBank/A_1<13>") getData("/IBank/A_1<12>") getData("/IBank/A_1<11>") getData("/IBank/A_1<10>") getData("/IBank/A_1<0>") getData("/Ack") getData("/AT<9>") getData("/AT<8>") getData("/AT<7>") getData("/AT<6>") getData("/AT<5>") getData("/AT<4>") getData("/AT<3>") getData("/AT<2>") getData("/AT<1>") getData("/AT<19>") getData("/AT<18>") getData("/AT<17>") getData("/AT<16>") getData("/AT<15>") getData("/AT<14>") getData("/AT<13>") getData("/AT<12>") getData("/AT<11>") getData("/AT<10>") getData("/AT<0>") getData("/WriteData<31:0>") getData("/WriteDataAck<7:0>") getData("/A<19:0>") getData("/RW<1:0>") getData("/Ctrl_Ack<4:0>") getData("/ReadData<31:0>") )
