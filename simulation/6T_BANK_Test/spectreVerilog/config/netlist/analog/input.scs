// Design: 16nm_Tests/6T_BANK_Test
simulator lang=spectre
global 0 vdd! vcc!
parameters vdd=.7 vcc=vdd
include "/software/cadence/ncsu-FreePDK15/hspice_16nm_hp.include"

// 16nm/6T/schematic
//system verilogNetlist schematic cmos.sch cmos_sch veriloga ahdl
subckt _sub119 A B0 B1
    M5 (Q0 Q1 0 0) nfet w=120n l=20n nfin=2 m=1 degradation=no
    M4 (Q1 Q0 0 0) nfet w=120n l=20n nfin=2 m=1 degradation=no
    M1 (Q1 A B1 0) nfet w=60n l=20n nfin=1 m=1 degradation=no
    M0 (Q0 A B0 0) nfet w=60n l=20n nfin=1 m=1 degradation=no
    M3 (Q0 Q1 vdd! vdd!) pfet w=50n l=20n nfin=1 m=1 degradation=yes
    M2 (Q1 Q0 vdd! vdd!) pfet w=50n l=20n nfin=1 m=1 degradation=yes
ends _sub119

// 16nm/6T_4x/schematic
//system verilogNetlist schematic cmos.sch cmos_sch veriloga ahdl
subckt _sub120 A_3 A_2 A_1 A_0 B0 B1
    I3 (A_0 B0 B1) _sub119
    I2 (A_1 B0 B1) _sub119
    I1 (A_2 B0 B1) _sub119
    I0 (A_3 B0 B1) _sub119
ends _sub120

// 16nm/6T_32x/schematic
//system verilogNetlist schematic cmos.sch cmos_sch veriloga ahdl
subckt _sub121 A_31 A_30 A_29 A_28 A_27 A_26 A_25 A_24 A_23 A_22 A_21 A_20 A_19 A_18 A_17 A_16 A_15 A_14 A_13 A_12 A_11 A_10 A_9 A_8 A_7 A_6 A_5 A_4 A_3 A_2 A_1 A_0 B0 B1
    I7 (A_3 A_2 A_1 A_0 B0 B1) _sub120
    I6 (A_7 A_6 A_5 A_4 B0 B1) _sub120
    I5 (A_11 A_10 A_9 A_8 B0 B1) _sub120
    I4 (A_15 A_14 A_13 A_12 B0 B1) _sub120
    I3 (A_19 A_18 A_17 A_16 B0 B1) _sub120
    I2 (A_23 A_22 A_21 A_20 B0 B1) _sub120
    I1 (A_27 A_26 A_25 A_24 B0 B1) _sub120
    I0 (A_31 A_30 A_29 A_28 B0 B1) _sub120
ends _sub121

// 16nm/6T_32x_CTRL/schematic
//system verilogNetlist schematic cmos.sch cmos_sch veriloga ahdl
subckt _sub122 B0 B1 S W0 W1
    M10 (B1 B0 net22 vdd!) pfet w=100n l=20n nfin=1 m=1 degradation=yes
    M9 (net22 W0 vdd! vdd!) pfet w=100n l=20n nfin=1 m=1 degradation=yes
    M8 (B0 B1 net23 vdd!) pfet w=100n l=20n nfin=1 m=1 degradation=yes
    M7 (net23 W1 vdd! vdd!) pfet w=100n l=20n nfin=1 m=1 degradation=yes
    M2 (B1 S vdd! vdd!) pfet w=50n l=20n nfin=1 m=1 degradation=yes
    M0 (B0 S vdd! vdd!) pfet w=50n l=20n nfin=1 m=1 degradation=yes
    M6 (B1 W0 net24 0) nfet w=120n l=20n nfin=2 m=1 degradation=no
    M5 (net24 S 0 0) nfet w=120n l=20n nfin=2 m=1 degradation=no
    M4 (net25 S 0 0) nfet w=120n l=20n nfin=2 m=1 degradation=no
    M3 (B0 W1 net25 0) nfet w=120n l=20n nfin=2 m=1 degradation=no
ends _sub122

// 16nm/nand4_1x/schematic
//system verilogNetlist schematic cmos.sch cmos_sch veriloga ahdl
subckt nand4_1x A B C D Y
    M5 (Y D vdd! vdd!) pfet w=100n l=20n nfin=1 m=1 degradation=no
    M4 (Y C vdd! vdd!) pfet w=100n l=20n nfin=1 m=1 degradation=no
    M1 (Y B vdd! vdd!) pfet w=100n l=20n nfin=1 m=1 degradation=no
    M0 (Y A vdd! vdd!) pfet w=100n l=20n nfin=1 m=1 degradation=no
    M7 (net23 D 0 0) nfet w=240n l=20n nfin=1 m=1 degradation=no
    M6 (net25 C net23 0) nfet w=240n l=20n nfin=1 m=1 degradation=no
    M3 (net24 B net25 0) nfet w=240n l=20n nfin=1 m=1 degradation=no
    M2 (Y A net24 0) nfet w=240n l=20n nfin=1 m=1 degradation=no
ends nand4_1x

// 16nm/6T_32x4/schematic
//system verilogNetlist schematic cmos.sch cmos_sch veriloga ahdl
subckt _sub123 A_31 A_30 A_29 A_28 A_27 A_26 A_25 A_24 A_23 A_22 A_21 A_20 A_19 A_18 A_17 A_16 A_15 A_14 A_13 A_12 A_11 A_10 A_9 A_8 A_7 A_6 A_5 A_4 A_3 A_2 A_1 A_0 B0 B1 S_3 S_2 S_1 S_0 W0 W1 SM0 SM1
    I3 (A_31 A_30 A_29 A_28 A_27 A_26 A_25 A_24 A_23 A_22 A_21 A_20 A_19 A_18 A_17 A_16 A_15 A_14 A_13 A_12 A_11 A_10 A_9 A_8 A_7 A_6 A_5 A_4 A_3 A_2 A_1 A_0 B0P4 B1P4) _sub121
    I1 (A_31 A_30 A_29 A_28 A_27 A_26 A_25 A_24 A_23 A_22 A_21 A_20 A_19 A_18 A_17 A_16 A_15 A_14 A_13 A_12 A_11 A_10 A_9 A_8 A_7 A_6 A_5 A_4 A_3 A_2 A_1 A_0 B0P2 B1P2) _sub121
    I2 (A_31 A_30 A_29 A_28 A_27 A_26 A_25 A_24 A_23 A_22 A_21 A_20 A_19 A_18 A_17 A_16 A_15 A_14 A_13 A_12 A_11 A_10 A_9 A_8 A_7 A_6 A_5 A_4 A_3 A_2 A_1 A_0 B0P3 B1P3) _sub121
    I0 (A_31 A_30 A_29 A_28 A_27 A_26 A_25 A_24 A_23 A_22 A_21 A_20 A_19 A_18 A_17 A_16 A_15 A_14 A_13 A_12 A_11 A_10 A_9 A_8 A_7 A_6 A_5 A_4 A_3 A_2 A_1 A_0 B0P1 B1P1) _sub121
    M0 (B0P1 B0 net67 0) nfet w=120n l=20n nfin=1 m=1 degradation=no
    M1 (net67 S_0 0 0) nfet w=120n l=20n nfin=1 m=1 degradation=no
    M2 (net66 S_0 0 0) nfet w=120n l=20n nfin=1 m=1 degradation=no
    M8 (B1P2 B1 net65 0) nfet w=120n l=20n nfin=1 m=1 degradation=no
    M9 (net65 S_1 0 0) nfet w=120n l=20n nfin=1 m=1 degradation=no
    M10 (net64 S_1 0 0) nfet w=120n l=20n nfin=1 m=1 degradation=no
    M11 (B0P2 B0 net64 0) nfet w=120n l=20n nfin=1 m=1 degradation=no
    M12 (B0P3 B0 net63 0) nfet w=120n l=20n nfin=1 m=1 degradation=no
    M13 (net63 S_2 0 0) nfet w=120n l=20n nfin=1 m=1 degradation=no
    M14 (net62 S_2 0 0) nfet w=120n l=20n nfin=1 m=1 degradation=no
    M15 (B1P3 B1 net62 0) nfet w=120n l=20n nfin=1 m=1 degradation=no
    M16 (B1P4 B1 net61 0) nfet w=120n l=20n nfin=1 m=1 degradation=no
    M17 (net61 S_3 0 0) nfet w=120n l=20n nfin=1 m=1 degradation=no
    M18 (net60 S_3 0 0) nfet w=120n l=20n nfin=1 m=1 degradation=no
    M19 (B0P4 B0 net60 0) nfet w=120n l=20n nfin=1 m=1 degradation=no
    M3 (B1P1 B1 net66 0) nfet w=120n l=20n nfin=1 m=1 degradation=no
    I4 (B0P1 B1P1 S_0 W0 W1) _sub122
    I5 (B0P2 B1P2 S_1 W0 W1) _sub122
    I6 (B0P3 B1P3 S_2 W0 W1) _sub122
    I7 (B0P4 B1P4 S_3 W0 W1) _sub122
    I11 (B1P1 B1P2 B1P3 B1P4 SM1) nand4_1x
    I10 (B0P1 B0P2 B0P3 B0P4 SM0) nand4_1x
    C7 (B1P4 0) capacitor c=75a m=1
    C6 (B1P2 0) capacitor c=75a m=1
    C5 (B1P3 0) capacitor c=75a m=1
    C4 (B0P4 0) capacitor c=75a m=1
    C3 (B0P3 0) capacitor c=75a m=1
    C2 (B0P2 0) capacitor c=75a m=1
    C1 (B1P1 0) capacitor c=75a m=1
    C0 (B0P1 0) capacitor c=75a m=1
ends _sub123

// 16nm/6T_SetRead/schematic
//system verilogNetlist schematic cmos.sch cmos_sch veriloga ahdl
subckt _sub124 Go SM0_0 SM0_1 SM1_0 SM1_1 \~R0 \~R1
    M5 (\~R0 SM0_0 net18 0) nfet w=60n l=20n nfin=1 m=1 degradation=no
    M3 (\~R0 SM0_1 net18 0) nfet w=60n l=20n nfin=1 m=1 degradation=no
    M2 (net18 Go 0 0) nfet w=120n l=20n nfin=2 m=1 degradation=no
    M1 (\~R1 SM1_1 net18 0) nfet w=60n l=20n nfin=1 m=1 degradation=no
    M0 (\~R1 SM1_0 net18 0) nfet w=60n l=20n nfin=1 m=1 degradation=no
ends _sub124

// 16nm/6T_CHUNK/schematic
//system verilogNetlist schematic cmos.sch cmos_sch veriloga ahdl
subckt _sub125 A_63 A_62 A_61 A_60 A_59 A_58 A_57 A_56 A_55 A_54 A_53 A_52 A_51 A_50 A_49 A_48 A_47 A_46 A_45 A_44 A_43 A_42 A_41 A_40 A_39 A_38 A_37 A_36 A_35 A_34 A_33 A_32 A_31 A_30 A_29 A_28 A_27 A_26 A_25 A_24 A_23 A_22 A_21 A_20 A_19 A_18 A_17 A_16 A_15 A_14 A_13 A_12 A_11 A_10 A_9 A_8 A_7 A_6 A_5 A_4 A_3 A_2 A_1 A_0 B0_3 B0_2 B0_1 B0_0 B1_3 B1_2 B1_1 B1_0 Go S_7 S_6 S_5 S_4 S_3 S_2 S_1 S_0 W0_3 W0_2 W0_1 W0_0 W1_3 W1_2 W1_1 W1_0 \~R0_3 \~R0_2 \~R0_1 \~R0_0 \~R1_3 \~R1_2 \~R1_1 \~R1_0
    I11 (A_63 A_62 A_61 A_60 A_59 A_58 A_57 A_56 A_55 A_54 A_53 A_52 A_51 A_50 A_49 A_48 A_47 A_46 A_45 A_44 A_43 A_42 A_41 A_40 A_39 A_38 A_37 A_36 A_35 A_34 A_33 A_32 B0_3 B1_3 S_7 S_6 S_5 S_4 W0_3 W1_3 SM0_1_bit3 SM1_1_bit3) _sub123
    I10 (A_63 A_62 A_61 A_60 A_59 A_58 A_57 A_56 A_55 A_54 A_53 A_52 A_51 A_50 A_49 A_48 A_47 A_46 A_45 A_44 A_43 A_42 A_41 A_40 A_39 A_38 A_37 A_36 A_35 A_34 A_33 A_32 B0_2 B1_2 S_7 S_6 S_5 S_4 W0_2 W1_2 SM0_1_bit2 SM1_1_bit2) _sub123
    I9 (A_63 A_62 A_61 A_60 A_59 A_58 A_57 A_56 A_55 A_54 A_53 A_52 A_51 A_50 A_49 A_48 A_47 A_46 A_45 A_44 A_43 A_42 A_41 A_40 A_39 A_38 A_37 A_36 A_35 A_34 A_33 A_32 B0_1 B1_1 S_7 S_6 S_5 S_4 W0_1 W1_1 SM0_1_bit1 SM1_1_bit1) _sub123
    I8 (A_63 A_62 A_61 A_60 A_59 A_58 A_57 A_56 A_55 A_54 A_53 A_52 A_51 A_50 A_49 A_48 A_47 A_46 A_45 A_44 A_43 A_42 A_41 A_40 A_39 A_38 A_37 A_36 A_35 A_34 A_33 A_32 B0_0 B1_0 S_7 S_6 S_5 S_4 W0_0 W1_0 SM0_1_bit0 SM1_1_bit0) _sub123
    I3 (A_31 A_30 A_29 A_28 A_27 A_26 A_25 A_24 A_23 A_22 A_21 A_20 A_19 A_18 A_17 A_16 A_15 A_14 A_13 A_12 A_11 A_10 A_9 A_8 A_7 A_6 A_5 A_4 A_3 A_2 A_1 A_0 B0_3 B1_3 S_3 S_2 S_1 S_0 W0_3 W1_3 SM0_0_bit3 SM1_0_bit3) _sub123
    I2 (A_31 A_30 A_29 A_28 A_27 A_26 A_25 A_24 A_23 A_22 A_21 A_20 A_19 A_18 A_17 A_16 A_15 A_14 A_13 A_12 A_11 A_10 A_9 A_8 A_7 A_6 A_5 A_4 A_3 A_2 A_1 A_0 B0_2 B1_2 S_3 S_2 S_1 S_0 W0_2 W1_2 SM0_0_bit2 SM1_0_bit2) _sub123
    I1 (A_31 A_30 A_29 A_28 A_27 A_26 A_25 A_24 A_23 A_22 A_21 A_20 A_19 A_18 A_17 A_16 A_15 A_14 A_13 A_12 A_11 A_10 A_9 A_8 A_7 A_6 A_5 A_4 A_3 A_2 A_1 A_0 B0_1 B1_1 S_3 S_2 S_1 S_0 W0_1 W1_1 SM0_0_bit1 SM1_0_bit1) _sub123
    I0 (A_31 A_30 A_29 A_28 A_27 A_26 A_25 A_24 A_23 A_22 A_21 A_20 A_19 A_18 A_17 A_16 A_15 A_14 A_13 A_12 A_11 A_10 A_9 A_8 A_7 A_6 A_5 A_4 A_3 A_2 A_1 A_0 B0_0 B1_0 S_3 S_2 S_1 S_0 W0_0 W1_0 SM0_0_bit0 SM1_0_bit0) _sub123
    I7 (Go SM0_0_bit3 SM0_1_bit3 SM1_0_bit3 SM1_1_bit3 \~R0_3 \~R1_3) _sub124
    I6 (Go SM0_0_bit2 SM0_1_bit2 SM1_0_bit2 SM1_1_bit2 \~R0_2 \~R1_2) _sub124
    I5 (Go SM0_0_bit1 SM0_1_bit1 SM1_0_bit1 SM1_1_bit1 \~R0_1 \~R1_1) _sub124
    I4 (Go SM0_0_bit0 SM0_1_bit0 SM1_0_bit0 SM1_1_bit0 \~R0_0 \~R1_0) _sub124
ends _sub125

// 16nm/nand_1x/schematic
//system verilogNetlist schematic cmos.sch cmos_sch veriloga ahdl
subckt nand_1x A B Y
    M1 (Y B vdd! vdd!) pfet w=100n l=20n nfin=1 m=1 degradation=no
    M0 (Y A vdd! vdd!) pfet w=100n l=20n nfin=1 m=1 degradation=no
    M3 (net22 B 0 0) nfet w=120n l=20n nfin=1 m=1 degradation=no
    M2 (Y A net22 0) nfet w=120n l=20n nfin=1 m=1 degradation=no
ends nand_1x

// 16nm/nor_1x/schematic
//system verilogNetlist schematic cmos.sch cmos_sch veriloga ahdl
subckt nor_1x A B Y
    M3 (Y B or_pd_ps vdd!) pfet w=200n l=20n nfin=1 m=1 degradation=yes
    M2 (or_pd_ps A vdd! vdd!) pfet w=200n l=20n nfin=1 m=1 degradation=yes
    M1 (Y B 0 0) nfet w=60n l=20n nfin=1 m=1 degradation=no
    M0 (Y A 0 0) nfet w=60n l=20n nfin=1 m=1 degradation=no
ends nor_1x

// 16nm/inv_1x/schematic
//system verilogNetlist schematic cmos.sch cmos_sch veriloga ahdl
subckt inv_1x A Y
    M0 (Y A 0 0) nfet w=60n l=20n nfin=1 m=1 degradation=no
    M1 (Y A vdd! vdd!) pfet w=100n l=20n nfin=1 m=1 degradation=no
ends inv_1x

// 16nm/TH22~/schematic
//system verilogNetlist schematic cmos.sch cmos_sch veriloga ahdl
subckt _sub126 A B Y
    I6 (net010 Y) inv_1x
    M5 (net010 net5 0 0) nfet w=48n l=16n nfin=1 m=1 degradation=no
    M4 (net5 net010 net9 0) nfet w=48n l=16n nfin=1 m=1 degradation=no
    M3 (net9 B 0 0) nfet w=48n l=16n nfin=1 m=1 degradation=no
    M2 (net9 A 0 0) nfet w=48n l=16n nfin=1 m=1 degradation=no
    M1 (net5 B net17 0) nfet w=80n l=16n nfin=1 m=1 degradation=no
    M0 (net17 A 0 0) nfet w=80n l=16n nfin=1 m=1 degradation=no
    M11 (net010 net5 vdd! vdd!) pfet w=80n l=16n nfin=1 m=1 degradation=yes
    M10 (net5 B net032 vdd!) pfet w=160n l=16n nfin=1 m=1 degradation=yes
    M9 (net032 A vdd! vdd!) pfet w=160n l=16n nfin=1 m=1 degradation=yes
    M8 (net037 B vdd! vdd!) pfet w=80n l=16n nfin=1 m=1 degradation=yes
    M7 (net037 A vdd! vdd!) pfet w=80n l=16n nfin=1 m=1 degradation=yes
    M6 (net5 net010 net037 vdd!) pfet w=80n l=16n nfin=1 m=1 degradation=yes
ends _sub126

// 16nm/WCHB/schematic
//system verilogNetlist schematic cmos.sch cmos_sch veriloga ahdl
subckt WCHB L0 L1 Lack R0 R1 Rack
    I2 (net09 net010 net21) nand_1x
    I5 (net21 Lack) inv_1x
    I4 (net09 R1) inv_1x
    I3 (net010 R0) inv_1x
    I1 (Rack L1 net09) _sub126
    I0 (L0 Rack net010) _sub126
ends WCHB

// 16nm/TH44/schematic
//system verilogNetlist schematic cmos.sch cmos_sch veriloga ahdl
subckt TH44 A B C D Y
    M19 (net13 A 0 0) nfet w=120n l=20n nfin=1 m=1 degradation=no
    M18 (net13 B 0 0) nfet w=120n l=20n nfin=1 m=1 degradation=no
    M17 (net13 C 0 0) nfet w=120n l=20n nfin=1 m=1 degradation=no
    M16 (net13 D 0 0) nfet w=120n l=20n nfin=1 m=1 degradation=no
    M15 (Y net19 0 0) nfet w=60n l=20n nfin=1 m=1 degradation=no
    M14 (net42 A 0 0) nfet w=240n l=20n nfin=1 m=1 degradation=no
    M13 (net43 B net42 0) nfet w=240n l=20n nfin=1 m=1 degradation=no
    M12 (net44 C net43 0) nfet w=240n l=20n nfin=1 m=1 degradation=no
    M11 (net19 D net44 0) nfet w=240n l=20n nfin=1 m=1 degradation=no
    M10 (net19 Y net13 0) nfet w=120n l=20n nfin=1 m=1 degradation=no
    M9 (Y net19 vdd! vdd!) pfet w=100n l=20n nfin=1 m=1 degradation=yes
    M8 (net19 Y net15 vdd!) pfet w=200n l=20n nfin=1 m=1 degradation=yes
    M7 (net15 D vdd! vdd!) pfet w=200n l=20n nfin=1 m=1 degradation=yes
    M6 (net15 C vdd! vdd!) pfet w=200n l=20n nfin=1 m=1 degradation=yes
    M5 (net15 B vdd! vdd!) pfet w=200n l=20n nfin=1 m=1 degradation=yes
    M4 (net15 A vdd! vdd!) pfet w=200n l=20n nfin=1 m=1 degradation=yes
    M3 (net19 D net45 vdd!) pfet w=320n l=20n nfin=1 m=1 degradation=yes
    M2 (net45 C net46 vdd!) pfet w=320n l=20n nfin=1 m=1 degradation=yes
    M1 (net46 B net47 vdd!) pfet w=320n l=20n nfin=1 m=1 degradation=yes
    M0 (net47 A vdd! vdd!) pfet w=320n l=20n nfin=1 m=1 degradation=yes
ends TH44

// 16nm/or_1x/schematic
//system verilogNetlist schematic cmos.sch cmos_sch veriloga ahdl
subckt or_1x A B Y
    I6 (A B AnorB) nor_1x
    I7 (AnorB Y) inv_1x
ends or_1x

// 16nm/and_1x/schematic
//system verilogNetlist schematic cmos.sch cmos_sch veriloga ahdl
subckt and_1x A B Y
    I7 (A B ntYbar) nand_1x
    I6 (ntYbar Y) inv_1x
ends and_1x

// 16nm/TH22/schematic
//system verilogNetlist schematic cmos.sch cmos_sch veriloga ahdl
subckt TH22 A B Y
    M5 (Y net5 0 0) nfet w=60n l=20n nfin=1 m=1 degradation=no
    M4 (net5 Y net9 0) nfet w=120n l=20n nfin=1 m=1 degradation=no
    M3 (net9 B 0 0) nfet w=120n l=20n nfin=1 m=1 degradation=no
    M2 (net9 A 0 0) nfet w=120n l=20n nfin=1 m=1 degradation=no
    M1 (net5 B net17 0) nfet w=120n l=20n nfin=1 m=1 degradation=no
    M0 (net17 A 0 0) nfet w=120n l=20n nfin=1 m=1 degradation=no
    M11 (Y net5 vdd! vdd!) pfet w=100n l=20n nfin=1 m=1 degradation=yes
    M10 (net5 B net032 vdd!) pfet w=200n l=20n nfin=1 m=1 degradation=yes
    M9 (net032 A vdd! vdd!) pfet w=200n l=20n nfin=1 m=1 degradation=yes
    M8 (net037 B vdd! vdd!) pfet w=200n l=20n nfin=1 m=1 degradation=yes
    M7 (net037 A vdd! vdd!) pfet w=200n l=20n nfin=1 m=1 degradation=yes
    M6 (net5 Y net037 vdd!) pfet w=200n l=20n nfin=1 m=1 degradation=yes
ends TH22

// 16nm/inv_weak_1x/schematic
//system verilogNetlist schematic cmos.sch cmos_sch veriloga ahdl
subckt inv_weak_1x A Y
    M2 (net13 vdd! 0 0) nfet w=60n l=20n nfin=1 ls=105n m=1 degradation=no
    M0 (Y A net13 0) nfet w=60n l=20n nfin=1 ls=105n m=1 degradation=no
    M3 (net14 0 vdd! vdd!) pfet w=100n l=20n nfin=1 m=1 degradation=yes
    M1 (Y A net14 vdd!) pfet w=100n l=20n nfin=1 m=1 degradation=yes
ends inv_weak_1x

// 16nm/PCHB_FIFO/schematic
//system verilogNetlist schematic cmos.sch cmos_sch veriloga ahdl
subckt PCHB_FIFO Ai Ai\+1 R0i R0i\+1 R1i R1i\+1
    I30 (Ai\+1 net025) inv_1x
    I5 (net029 R1i\+1) inv_1x
    I4 (net18 R0i\+1) inv_1x
    I12 (net016 net020 Ai) _sub126
    M5 (net026 net014 0 0) nfet w=60n l=20n nfin=1 m=1 degradation=no
    M4 (net22 net014 0 0) nfet w=60n l=20n nfin=1 m=1 degradation=no
    M3 (net029 R1i net026 0) nfet w=60n l=20n nfin=1 m=1 degradation=no
    M2 (net18 R0i net22 0) nfet w=60n l=20n nfin=1 m=1 degradation=no
    M1 (net029 net014 vdd! vdd!) pfet w=200n l=20n nfin=1 m=1 degradation=yes
    M0 (net18 net014 vdd! vdd!) pfet w=200n l=20n nfin=1 m=1 degradation=yes
    I6 (net029 net18 net016) nand_1x
    I9 (R0i R1i net020) or_1x
    I2 (R0i\+1 net18) inv_weak_1x
    I3 (R1i\+1 net029) inv_weak_1x
    I11 (Ai net025 net014) TH22
ends PCHB_FIFO

// 16nm/WCHB~/schematic
//system verilogNetlist schematic cmos.sch cmos_sch veriloga ahdl
subckt _sub127 L0 L1 Lack Rack \~R0 \~R1
    I2 (\~R1 \~R0 Lack) and_1x
    I1 (Rack L1 \~R1) _sub126
    I0 (L0 Rack \~R0) _sub126
ends _sub127

// 16nm/6T_DATA/schematic
//system verilogNetlist schematic cmos.sch cmos_sch veriloga ahdl
subckt _sub128 Ack B0_3 B0_2 B0_1 B0_0 B1_3 B1_2 B1_1 B1_0 Go R1_1of4_3 R1_1of4_2 R1_1of4_1 R1_1of4_0 R2_1of4_3 R2_1of4_2 R2_1of4_1 R2_1of4_0 RW_1 RW_0 Reset ValAddr W0_3 W0_2 W0_1 W0_0 W1_3 W1_2 W1_1 W1_0 W1_1of4_3 W1_1of4_2 W1_1of4_1 W1_1of4_0 W2_1of4_3 W2_1of4_2 W2_1of4_1 W2_1of4_0 AckThruBot AckThruTop RAck_1 RAck_0 WAck_1 WAck_0 \~R0_3 \~R0_2 \~R0_1 \~R0_0 \~R1_3 \~R1_2 \~R1_1 \~R1_0
    I46 (net047 net046 Ack) nand_1x
    I45 (net030 RW_0 net047) nand_1x
    I44 (RW_1 net054 net046) nand_1x
    I54 (Out0_2 Out1_3 R2_1of4_2) nor_1x
    I53 (Out0_3 Out0_2 R2_1of4_3) nor_1x
    I52 (Out0_3 Out1_2 R2_1of4_1) nor_1x
    I51 (Out1_3 Out1_2 R2_1of4_0) nor_1x
    I50 (Out0_1 Out0_0 R1_1of4_3) nor_1x
    I49 (Out1_1 Out0_0 R1_1of4_2) nor_1x
    I47 (Out1_1 Out1_0 R1_1of4_0) nor_1x
    I48 (Out1_0 Out0_1 R1_1of4_1) nor_1x
    I21 (nOr_1 nOr_0 wack_0 B0p_0 B1p_0 BpAck_0) WCHB
    I24 (nOr_7 nOr_6 wack_3 B0p_3 B1p_3 BpAck_3) WCHB
    I23 (nOr_5 nOr_4 wack_2 B0p_2 B1p_2 BpAck_2) WCHB
    I22 (nOr_3 nOr_2 wack_1 B0p_1 B1p_1 BpAck_1) WCHB
    I43 (Lack_3 Lack_2 Lack_1 Lack_0 net054) TH44
    I29 (wack_3 wack_2 wack_1 wack_0 net030) TH44
    I18 (W2_1of4_2 W2_1of4_3 nOr_7) or_1x
    I17 (W2_1of4_0 W2_1of4_1 nOr_6) or_1x
    I11 (W1_1of4_2 W1_1of4_3 nOr_3) or_1x
    I10 (W1_1of4_0 W1_1of4_1 nOr_2) or_1x
    I16 (W2_1of4_1 W2_1of4_3 nOr_5) or_1x
    I15 (W2_1of4_0 W2_1of4_2 nOr_4) or_1x
    I1 (W1_1of4_1 W1_1of4_3 nOr_1) or_1x
    I0 (W1_1of4_0 W1_1of4_2 nOr_0) or_1x
    I37_3 (B0_3 Wen W0_3) and_1x
    I37_2 (B0_2 Wen W0_2) and_1x
    I37_1 (B0_1 Wen W0_1) and_1x
    I37_0 (B0_0 Wen W0_0) and_1x
    I36_3 (Wen B1_3 W1_3) and_1x
    I36_2 (Wen B1_2 W1_2) and_1x
    I36_1 (Wen B1_1 W1_1) and_1x
    I36_0 (Wen B1_0 W1_0) and_1x
    M1_3 (\~R1_3 Go vdd! vdd!) pfet w=100n l=20n nfin=1 m=1 degradation=yes
    M1_2 (\~R1_2 Go vdd! vdd!) pfet w=100n l=20n nfin=1 m=1 degradation=yes
    M1_1 (\~R1_1 Go vdd! vdd!) pfet w=100n l=20n nfin=1 m=1 degradation=yes
    M1_0 (\~R1_0 Go vdd! vdd!) pfet w=100n l=20n nfin=1 m=1 degradation=yes
    M0_3 (\~R0_3 Go vdd! vdd!) pfet w=100n l=20n nfin=1 m=1 degradation=yes
    M0_2 (\~R0_2 Go vdd! vdd!) pfet w=100n l=20n nfin=1 m=1 degradation=yes
    M0_1 (\~R0_1 Go vdd! vdd!) pfet w=100n l=20n nfin=1 m=1 degradation=yes
    M0_0 (\~R0_0 Go vdd! vdd!) pfet w=100n l=20n nfin=1 m=1 degradation=yes
    I35_3 (\~R1_3 R1_3) inv_1x
    I35_2 (\~R1_2 R1_2) inv_1x
    I35_1 (\~R1_1 R1_1) inv_1x
    I35_0 (\~R1_0 R1_0) inv_1x
    I34_3 (\~R0_3 R0_3) inv_1x
    I34_2 (\~R0_2 R0_2) inv_1x
    I34_1 (\~R0_1 R0_1) inv_1x
    I34_0 (\~R0_0 R0_0) inv_1x
    I64 (RAck_0 Rack_0) iprobe
    I63 (RAck_0 Rack_1) iprobe
    I62 (RAck_1 Rack_2) iprobe
    I56 (AckThruBot AckThruTop) iprobe
    I61 (RAck_1 Rack_3) iprobe
    I65 (RW_0 ValAddr Wen) TH22
    I58 (wack_1 wack_0 WAck_0) TH22
    I38 (ValAddr RW_1 Go) TH22
    I57 (wack_2 wack_3 WAck_1) TH22
    I71 (BpAck_3 Wen B0p_3 B0_3 B1p_3 B1_3) PCHB_FIFO
    I68 (BpAck_0 Wen B0p_0 B0_0 B1p_0 B1_0) PCHB_FIFO
    I69 (BpAck_1 Wen B0p_1 B0_1 B1p_1 B1_1) PCHB_FIFO
    I70 (BpAck_2 Wen B0p_2 B0_2 B1p_2 B1_2) PCHB_FIFO
    I72_3 (Lack_3 RAckp_3 R0_3 R0p_3 R1_3 R1p_3) PCHB_FIFO
    I72_2 (Lack_2 RAckp_2 R0_2 R0p_2 R1_2 R1p_2) PCHB_FIFO
    I72_1 (Lack_1 RAckp_1 R0_1 R0p_1 R1_1 R1p_1) PCHB_FIFO
    I72_0 (Lack_0 RAckp_0 R0_0 R0p_0 R1_0 R1p_0) PCHB_FIFO
    I67_3 (R0p_3 R1p_3 RAckp_3 Rack_3 Out0_3 Out1_3) _sub127
    I67_2 (R0p_2 R1p_2 RAckp_2 Rack_2 Out0_2 Out1_2) _sub127
    I67_1 (R0p_1 R1p_1 RAckp_1 Rack_1 Out0_1 Out1_1) _sub127
    I67_0 (R0p_0 R1p_0 RAckp_0 Rack_0 Out0_0 Out1_0) _sub127
ends _sub128

// 16nm/nor4_1x/schematic
//system verilogNetlist schematic cmos.sch cmos_sch veriloga ahdl
subckt nor4_1x A B C D Y
    M5 (net017 C net21 vdd!) pfet w=400n l=20n nfin=1 m=1 degradation=yes
    M4 (Y D net017 vdd!) pfet w=400n l=20n nfin=1 m=1 degradation=yes
    M3 (net21 B net018 vdd!) pfet w=400n l=20n nfin=1 m=1 degradation=yes
    M2 (net018 A vdd! vdd!) pfet w=400n l=20n nfin=1 m=1 degradation=yes
    M7 (Y D 0 0) nfet w=60n l=20n nfin=1 m=1 degradation=no
    M6 (Y C 0 0) nfet w=60n l=20n nfin=1 m=1 degradation=no
    M1 (Y A 0 0) nfet w=60n l=20n nfin=1 m=1 degradation=no
    M0 (Y B 0 0) nfet w=60n l=20n nfin=1 m=1 degradation=no
ends nor4_1x

// 16nm/or16_1x/schematic
//system verilogNetlist schematic cmos.sch cmos_sch veriloga ahdl
subckt or16_1x Y X_15 X_14 X_13 X_12 X_11 X_10 X_9 X_8 X_7 X_6 X_5 X_4 X_3 X_2 X_1 X_0
    I2 (nX30 nX74 nX118 nX1512 Y) nand4_1x
    I0 (X_0 X_1 X_2 X_3 nX30) nor4_1x
    I1 (X_4 X_5 X_6 X_7 nX74) nor4_1x
    I3 (X_8 X_9 X_10 X_11 nX118) nor4_1x
    I4 (X_12 X_13 X_14 X_15 nX1512) nor4_1x
ends or16_1x

// 16nm/or4_1x/schematic
//system verilogNetlist schematic cmos.sch cmos_sch veriloga ahdl
subckt or4_1x A B C D Y
    I0 (A B C D net11) nor4_1x
    I1 (net11 Y) inv_1x
ends or4_1x

// 16nm/6T_CONTROL/schematic
//system verilogNetlist schematic cmos.sch cmos_sch veriloga ahdl
subckt _sub129 A_3 A_2 A_1 A_0 A_7 A_6 A_5 A_4 A_11 A_10 A_9 A_8 A_15 A_14 A_13 A_12 A_19 A_18 A_17 A_16 InAck_1 InAck_0 InAck_3 InAck_2 OutAck RW_1 RW_0 Reset ValAddr
    I17 (net8 A_15 A_14 A_13 A_12 A_11 A_10 A_9 A_8 A_7 A_6 A_5 A_4 A_3 A_2 A_1 A_0) or16_1x
    I15 (A_16 A_17 A_18 A_19 net7) or4_1x
    I14 (InAck_0 InAck_1 InAck_2 InAck_3 OutAck) TH44
    I16 (net8 net7 ValAddr) or_1x
ends _sub129

// 16nm/and4_1x/schematic
//system verilogNetlist schematic cmos.sch cmos_sch veriloga ahdl
subckt and4_1x A B C D Y
    I15 (A B C D net1) nand4_1x
    I16 (net1 Y) inv_1x
ends and4_1x

// 16nm/Demux_2e1of4/schematic
//system verilogNetlist schematic cmos.sch cmos_sch veriloga ahdl
subckt Demux_2e1of4 _1of4_1_3 _1of4_1_2 _1of4_1_1 _1of4_1_0 _1of4_2_3 _1of4_2_2 _1of4_2_1 _1of4_2_0 A_15 A_14 A_13 A_12 A_11 A_10 A_9 A_8 A_7 A_6 A_5 A_4 A_3 A_2 A_1 A_0 En EnOut
    I15 (_1of4_1_3 _1of4_2_3 EnOut En A_15) and4_1x
    I14 (_1of4_1_2 _1of4_2_3 EnOut En A_14) and4_1x
    I13 (_1of4_1_1 _1of4_2_3 EnOut En A_13) and4_1x
    I12 (_1of4_1_0 _1of4_2_3 EnOut En A_12) and4_1x
    I11 (_1of4_1_3 _1of4_2_2 EnOut En A_11) and4_1x
    I10 (_1of4_1_2 _1of4_2_2 EnOut En A_10) and4_1x
    I9 (_1of4_1_1 _1of4_2_2 EnOut En A_9) and4_1x
    I8 (_1of4_1_0 _1of4_2_2 EnOut En A_8) and4_1x
    I7 (_1of4_1_3 _1of4_2_1 EnOut En A_7) and4_1x
    I6 (_1of4_1_2 _1of4_2_1 EnOut En A_6) and4_1x
    I5 (_1of4_1_1 _1of4_2_1 EnOut En A_5) and4_1x
    I4 (_1of4_1_0 _1of4_2_1 EnOut En A_4) and4_1x
    I3 (_1of4_1_3 _1of4_2_0 EnOut En A_3) and4_1x
    I2 (_1of4_1_2 _1of4_2_0 EnOut En A_2) and4_1x
    I1 (_1of4_1_1 _1of4_2_0 EnOut En A_1) and4_1x
    I0 (_1of4_1_0 _1of4_2_0 EnOut En A_0) and4_1x
ends Demux_2e1of4

// 16nm/Demux_3e1of4/schematic
//system verilogNetlist schematic cmos.sch cmos_sch veriloga ahdl
subckt Demux_3e1of4 _1of4_1_3 _1of4_1_2 _1of4_1_1 _1of4_1_0 _1of4_2_3 _1of4_2_2 _1of4_2_1 _1of4_2_0 _1of4_3_3 _1of4_3_2 _1of4_3_1 _1of4_3_0 A_63 A_62 A_61 A_60 A_59 A_58 A_57 A_56 A_55 A_54 A_53 A_52 A_51 A_50 A_49 A_48 A_47 A_46 A_45 A_44 A_43 A_42 A_41 A_40 A_39 A_38 A_37 A_36 A_35 A_34 A_33 A_32 A_31 A_30 A_29 A_28 A_27 A_26 A_25 A_24 A_23 A_22 A_21 A_20 A_19 A_18 A_17 A_16 A_15 A_14 A_13 A_12 A_11 A_10 A_9 A_8 A_7 A_6 A_5 A_4 A_3 A_2 A_1 A_0 En
    I3 (_1of4_1_3 _1of4_1_2 _1of4_1_1 _1of4_1_0 _1of4_2_3 _1of4_2_2 _1of4_2_1 _1of4_2_0 A_63 A_62 A_61 A_60 A_59 A_58 A_57 A_56 A_55 A_54 A_53 A_52 A_51 A_50 A_49 A_48 En _1of4_3_3) Demux_2e1of4
    I2 (_1of4_1_3 _1of4_1_2 _1of4_1_1 _1of4_1_0 _1of4_2_3 _1of4_2_2 _1of4_2_1 _1of4_2_0 A_47 A_46 A_45 A_44 A_43 A_42 A_41 A_40 A_39 A_38 A_37 A_36 A_35 A_34 A_33 A_32 En _1of4_3_2) Demux_2e1of4
    I1 (_1of4_1_3 _1of4_1_2 _1of4_1_1 _1of4_1_0 _1of4_2_3 _1of4_2_2 _1of4_2_1 _1of4_2_0 A_31 A_30 A_29 A_28 A_27 A_26 A_25 A_24 A_23 A_22 A_21 A_20 A_19 A_18 A_17 A_16 En _1of4_3_1) Demux_2e1of4
    I0 (_1of4_1_3 _1of4_1_2 _1of4_1_1 _1of4_1_0 _1of4_2_3 _1of4_2_2 _1of4_2_1 _1of4_2_0 A_15 A_14 A_13 A_12 A_11 A_10 A_9 A_8 A_7 A_6 A_5 A_4 A_3 A_2 A_1 A_0 En _1of4_3_0) Demux_2e1of4
ends Demux_3e1of4

// 16nm/nand3_1x/schematic
//system verilogNetlist schematic cmos.sch cmos_sch veriloga ahdl
subckt nand3_1x A B C Y
    M4 (Y C vdd! vdd!) pfet w=100n l=20n nfin=1 m=1 degradation=yes
    M1 (Y B vdd! vdd!) pfet w=100n l=20n nfin=1 m=1 degradation=yes
    M0 (Y A vdd! vdd!) pfet w=100n l=20n nfin=1 m=1 degradation=yes
    M6 (net026 C 0 0) nfet w=180n l=20n nfin=1 m=1 degradation=no
    M3 (net22 B net026 0) nfet w=180n l=20n nfin=1 m=1 degradation=no
    M2 (Y A net22 0) nfet w=180n l=20n nfin=1 m=1 degradation=no
ends nand3_1x

// 16nm/and3_1x/schematic
//system verilogNetlist schematic cmos.sch cmos_sch veriloga ahdl
subckt and3_1x A B C Y
    I6 (A B C net1) nand3_1x
    I7 (net1 Y) inv_1x
ends and3_1x

// 16nm/6T_DEMUX_/schematic
//system verilogNetlist schematic cmos.sch cmos_sch veriloga ahdl
subckt _sub130 _1of4_1_3 _1of4_1_2 _1of4_1_1 _1of4_1_0 _1of4_2_3 _1of4_2_2 _1of4_2_1 _1of4_2_0 _1of4_3_3 _1of4_3_2 _1of4_3_1 _1of4_3_0 _1of4_4_3 _1of4_4_2 _1of4_4_1 _1of4_4_0 A_63 A_62 A_61 A_60 A_59 A_58 A_57 A_56 A_55 A_54 A_53 A_52 A_51 A_50 A_49 A_48 A_47 A_46 A_45 A_44 A_43 A_42 A_41 A_40 A_39 A_38 A_37 A_36 A_35 A_34 A_33 A_32 A_31 A_30 A_29 A_28 A_27 A_26 A_25 A_24 A_23 A_22 A_21 A_20 A_19 A_18 A_17 A_16 A_15 A_14 A_13 A_12 A_11 A_10 A_9 A_8 A_7 A_6 A_5 A_4 A_3 A_2 A_1 A_0 En S_7 S_6 S_5 S_4 S_3 S_2 S_1 S_0
    I0 (_1of4_1_3 _1of4_1_2 _1of4_1_1 _1of4_1_0 _1of4_2_3 _1of4_2_2 _1of4_2_1 _1of4_2_0 _1of4_3_3 _1of4_3_2 _1of4_3_1 _1of4_3_0 A_63 A_62 A_61 A_60 A_59 A_58 A_57 A_56 A_55 A_54 A_53 A_52 A_51 A_50 A_49 A_48 A_47 A_46 A_45 A_44 A_43 A_42 A_41 A_40 A_39 A_38 A_37 A_36 A_35 A_34 A_33 A_32 A_31 A_30 A_29 A_28 A_27 A_26 A_25 A_24 A_23 A_22 A_21 A_20 A_19 A_18 A_17 A_16 A_15 A_14 A_13 A_12 A_11 A_10 A_9 A_8 A_7 A_6 A_5 A_4 A_3 A_2 A_1 A_0 En) Demux_3e1of4
    I1_3 (_1of4_4_3 net23 En S_3) and3_1x
    I1_2 (_1of4_4_2 net23 En S_2) and3_1x
    I1_1 (_1of4_4_1 net23 En S_1) and3_1x
    I1_0 (_1of4_4_0 net23 En S_0) and3_1x
    I2_3 (_1of4_4_3 net22 En S_7) and3_1x
    I2_2 (_1of4_4_2 net22 En S_6) and3_1x
    I2_1 (_1of4_4_1 net22 En S_5) and3_1x
    I2_0 (_1of4_4_0 net22 En S_4) and3_1x
    I4 (_1of4_3_0 _1of4_3_1 net23) or_1x
    I5 (_1of4_3_2 _1of4_3_3 net22) or_1x
ends _sub130

// 16nm/6T_BANK/schematic
//system verilogNetlist schematic cmos.sch cmos_sch veriloga ahdl
subckt _sub131 A_19 A_18 A_17 A_16 A_15 A_14 A_13 A_12 A_11 A_10 A_9 A_8 A_7 A_6 A_5 A_4 A_3 A_2 A_1 A_0 Ack Ctrl_Ack_4 Ctrl_Ack_3 Ctrl_Ack_2 Ctrl_Ack_1 Ctrl_Ack_0 RD_8of32_31 RD_8of32_30 RD_8of32_29 RD_8of32_28 RD_8of32_27 RD_8of32_26 RD_8of32_25 RD_8of32_24 RD_8of32_23 RD_8of32_22 RD_8of32_21 RD_8of32_20 RD_8of32_19 RD_8of32_18 RD_8of32_17 RD_8of32_16 RD_8of32_15 RD_8of32_14 RD_8of32_13 RD_8of32_12 RD_8of32_11 RD_8of32_10 RD_8of32_9 RD_8of32_8 RD_8of32_7 RD_8of32_6 RD_8of32_5 RD_8of32_4 RD_8of32_3 RD_8of32_2 RD_8of32_1 RD_8of32_0 RD_Ack_7 RD_Ack_6 RD_Ack_5 RD_Ack_4 RD_Ack_3 RD_Ack_2 RD_Ack_1 RD_Ack_0 RW_1 RW_0 WD_8of32_31 WD_8of32_30 WD_8of32_29 WD_8of32_28 WD_8of32_27 WD_8of32_26 WD_8of32_25 WD_8of32_24 WD_8of32_23 WD_8of32_22 WD_8of32_21 WD_8of32_20 WD_8of32_19 WD_8of32_18 WD_8of32_17 WD_8of32_16 WD_8of32_15 WD_8of32_14 WD_8of32_13 WD_8of32_12 WD_8of32_11 WD_8of32_10 WD_8of32_9 WD_8of32_8 WD_8of32_7 WD_8of32_6 WD_8of32_5 WD_8of32_4 WD_8of32_3 WD_8of32_2 WD_8of32_1 WD_8of32_0 WD_Ack_7 WD_Ack_6 WD_Ack_5 WD_Ack_4 WD_Ack_3 WD_Ack_2 WD_Ack_1 WD_Ack_0
    I15 (net096_0 net096_1 net096_2 net096_3 net096_4 net096_5 net096_6 net096_7 net096_8 net096_9 net096_10 net096_11 net096_12 net096_13 net096_14 net096_15 net096_16 net096_17 net096_18 net096_19 net096_20 net096_21 net096_22 net096_23 net096_24 net096_25 net096_26 net096_27 net096_28 net096_29 net096_30 net096_31 net096_32 net096_33 net096_34 net096_35 net096_36 net096_37 net096_38 net096_39 net096_40 net096_41 net096_42 net096_43 net096_44 net096_45 net096_46 net096_47 net096_48 net096_49 net096_50 net096_51 net096_52 net096_53 net096_54 net096_55 net096_56 net096_57 net096_58 net096_59 net096_60 net096_61 net096_62 net096_63 B0_4_3 B0_4_2 B0_4_1 B0_4_0 B1_4_3 B1_4_2 B1_4_1 B1_4_0 G04 net068_0 net068_1 net068_2 net068_3 net068_4 net068_5 net068_6 net068_7 W0_4_3 W0_4_2 W0_4_1 W0_4_0 W1_4_3 W1_4_2 W1_4_1 W1_4_0 \~R0_4_3 \~R0_4_2 \~R0_4_1 \~R0_4_0 \~R1_4_3 \~R1_4_2 \~R1_4_1 \~R1_4_0) _sub125
    I14 (net0157_0 net0157_1 net0157_2 net0157_3 net0157_4 net0157_5 net0157_6 net0157_7 net0157_8 net0157_9 net0157_10 net0157_11 net0157_12 net0157_13 net0157_14 net0157_15 net0157_16 net0157_17 net0157_18 net0157_19 net0157_20 net0157_21 net0157_22 net0157_23 net0157_24 net0157_25 net0157_26 net0157_27 net0157_28 net0157_29 net0157_30 net0157_31 net0157_32 net0157_33 net0157_34 net0157_35 net0157_36 net0157_37 net0157_38 net0157_39 net0157_40 net0157_41 net0157_42 net0157_43 net0157_44 net0157_45 net0157_46 net0157_47 net0157_48 net0157_49 net0157_50 net0157_51 net0157_52 net0157_53 net0157_54 net0157_55 net0157_56 net0157_57 net0157_58 net0157_59 net0157_60 net0157_61 net0157_62 net0157_63 B0_4_3 B0_4_2 B0_4_1 B0_4_0 B1_4_3 B1_4_2 B1_4_1 B1_4_0 G04 net0131_0 net0131_1 net0131_2 net0131_3 net0131_4 net0131_5 net0131_6 net0131_7 W0_4_3 W0_4_2 W0_4_1 W0_4_0 W1_4_3 W1_4_2 W1_4_1 W1_4_0 \~R0_4_3 \~R0_4_2 \~R0_4_1 \~R0_4_0 \~R1_4_3 \~R1_4_2 \~R1_4_1 \~R1_4_0) _sub125
    I13 (net087_0 net087_1 net087_2 net087_3 net087_4 net087_5 net087_6 net087_7 net087_8 net087_9 net087_10 net087_11 net087_12 net087_13 net087_14 net087_15 net087_16 net087_17 net087_18 net087_19 net087_20 net087_21 net087_22 net087_23 net087_24 net087_25 net087_26 net087_27 net087_28 net087_29 net087_30 net087_31 net087_32 net087_33 net087_34 net087_35 net087_36 net087_37 net087_38 net087_39 net087_40 net087_41 net087_42 net087_43 net087_44 net087_45 net087_46 net087_47 net087_48 net087_49 net087_50 net087_51 net087_52 net087_53 net087_54 net087_55 net087_56 net087_57 net087_58 net087_59 net087_60 net087_61 net087_62 net087_63 B0_4_3 B0_4_2 B0_4_1 B0_4_0 B1_4_3 B1_4_2 B1_4_1 B1_4_0 G04 net059_0 net059_1 net059_2 net059_3 net059_4 net059_5 net059_6 net059_7 W0_4_3 W0_4_2 W0_4_1 W0_4_0 W1_4_3 W1_4_2 W1_4_1 W1_4_0 \~R0_4_3 \~R0_4_2 \~R0_4_1 \~R0_4_0 \~R1_4_3 \~R1_4_2 \~R1_4_1 \~R1_4_0) _sub125
    I12 (A_1_63 A_1_62 A_1_61 A_1_60 A_1_59 A_1_58 A_1_57 A_1_56 A_1_55 A_1_54 A_1_53 A_1_52 A_1_51 A_1_50 A_1_49 A_1_48 A_1_47 A_1_46 A_1_45 A_1_44 A_1_43 A_1_42 A_1_41 A_1_40 A_1_39 A_1_38 A_1_37 A_1_36 A_1_35 A_1_34 A_1_33 A_1_32 A_1_31 A_1_30 A_1_29 A_1_28 A_1_27 A_1_26 A_1_25 A_1_24 A_1_23 A_1_22 A_1_21 A_1_20 A_1_19 A_1_18 A_1_17 A_1_16 A_1_15 A_1_14 A_1_13 A_1_12 A_1_11 A_1_10 A_1_9 A_1_8 A_1_7 A_1_6 A_1_5 A_1_4 A_1_3 A_1_2 A_1_1 A_1_0 B0_4_3 B0_4_2 B0_4_1 B0_4_0 B1_4_3 B1_4_2 B1_4_1 B1_4_0 G04 S_1_7 S_1_6 S_1_5 S_1_4 S_1_3 S_1_2 S_1_1 S_1_0 W0_4_3 W0_4_2 W0_4_1 W0_4_0 W1_4_3 W1_4_2 W1_4_1 W1_4_0 \~R0_4_3 \~R0_4_2 \~R0_4_1 \~R0_4_0 \~R1_4_3 \~R1_4_2 \~R1_4_1 \~R1_4_0) _sub125
    I11 (net096_0 net096_1 net096_2 net096_3 net096_4 net096_5 net096_6 net096_7 net096_8 net096_9 net096_10 net096_11 net096_12 net096_13 net096_14 net096_15 net096_16 net096_17 net096_18 net096_19 net096_20 net096_21 net096_22 net096_23 net096_24 net096_25 net096_26 net096_27 net096_28 net096_29 net096_30 net096_31 net096_32 net096_33 net096_34 net096_35 net096_36 net096_37 net096_38 net096_39 net096_40 net096_41 net096_42 net096_43 net096_44 net096_45 net096_46 net096_47 net096_48 net096_49 net096_50 net096_51 net096_52 net096_53 net096_54 net096_55 net096_56 net096_57 net096_58 net096_59 net096_60 net096_61 net096_62 net096_63 B0_3_3 B0_3_2 B0_3_1 B0_3_0 B1_3_3 B1_3_2 B1_3_1 B1_3_0 G03 net068_0 net068_1 net068_2 net068_3 net068_4 net068_5 net068_6 net068_7 W0_3_3 W0_3_2 W0_3_1 W0_3_0 W1_3_3 W1_3_2 W1_3_1 W1_3_0 \~R0_3_3 \~R0_3_2 \~R0_3_1 \~R0_3_0 \~R1_3_3 \~R1_3_2 \~R1_3_1 \~R1_3_0) _sub125
    I10 (net0157_0 net0157_1 net0157_2 net0157_3 net0157_4 net0157_5 net0157_6 net0157_7 net0157_8 net0157_9 net0157_10 net0157_11 net0157_12 net0157_13 net0157_14 net0157_15 net0157_16 net0157_17 net0157_18 net0157_19 net0157_20 net0157_21 net0157_22 net0157_23 net0157_24 net0157_25 net0157_26 net0157_27 net0157_28 net0157_29 net0157_30 net0157_31 net0157_32 net0157_33 net0157_34 net0157_35 net0157_36 net0157_37 net0157_38 net0157_39 net0157_40 net0157_41 net0157_42 net0157_43 net0157_44 net0157_45 net0157_46 net0157_47 net0157_48 net0157_49 net0157_50 net0157_51 net0157_52 net0157_53 net0157_54 net0157_55 net0157_56 net0157_57 net0157_58 net0157_59 net0157_60 net0157_61 net0157_62 net0157_63 B0_3_3 B0_3_2 B0_3_1 B0_3_0 B1_3_3 B1_3_2 B1_3_1 B1_3_0 G03 net0131_0 net0131_1 net0131_2 net0131_3 net0131_4 net0131_5 net0131_6 net0131_7 W0_3_3 W0_3_2 W0_3_1 W0_3_0 W1_3_3 W1_3_2 W1_3_1 W1_3_0 \~R0_3_3 \~R0_3_2 \~R0_3_1 \~R0_3_0 \~R1_3_3 \~R1_3_2 \~R1_3_1 \~R1_3_0) _sub125
    I9 (net087_0 net087_1 net087_2 net087_3 net087_4 net087_5 net087_6 net087_7 net087_8 net087_9 net087_10 net087_11 net087_12 net087_13 net087_14 net087_15 net087_16 net087_17 net087_18 net087_19 net087_20 net087_21 net087_22 net087_23 net087_24 net087_25 net087_26 net087_27 net087_28 net087_29 net087_30 net087_31 net087_32 net087_33 net087_34 net087_35 net087_36 net087_37 net087_38 net087_39 net087_40 net087_41 net087_42 net087_43 net087_44 net087_45 net087_46 net087_47 net087_48 net087_49 net087_50 net087_51 net087_52 net087_53 net087_54 net087_55 net087_56 net087_57 net087_58 net087_59 net087_60 net087_61 net087_62 net087_63 B0_3_3 B0_3_2 B0_3_1 B0_3_0 B1_3_3 B1_3_2 B1_3_1 B1_3_0 G03 net059_0 net059_1 net059_2 net059_3 net059_4 net059_5 net059_6 net059_7 W0_3_3 W0_3_2 W0_3_1 W0_3_0 W1_3_3 W1_3_2 W1_3_1 W1_3_0 \~R0_3_3 \~R0_3_2 \~R0_3_1 \~R0_3_0 \~R1_3_3 \~R1_3_2 \~R1_3_1 \~R1_3_0) _sub125
    I8 (A_1_63 A_1_62 A_1_61 A_1_60 A_1_59 A_1_58 A_1_57 A_1_56 A_1_55 A_1_54 A_1_53 A_1_52 A_1_51 A_1_50 A_1_49 A_1_48 A_1_47 A_1_46 A_1_45 A_1_44 A_1_43 A_1_42 A_1_41 A_1_40 A_1_39 A_1_38 A_1_37 A_1_36 A_1_35 A_1_34 A_1_33 A_1_32 A_1_31 A_1_30 A_1_29 A_1_28 A_1_27 A_1_26 A_1_25 A_1_24 A_1_23 A_1_22 A_1_21 A_1_20 A_1_19 A_1_18 A_1_17 A_1_16 A_1_15 A_1_14 A_1_13 A_1_12 A_1_11 A_1_10 A_1_9 A_1_8 A_1_7 A_1_6 A_1_5 A_1_4 A_1_3 A_1_2 A_1_1 A_1_0 B0_3_3 B0_3_2 B0_3_1 B0_3_0 B1_3_3 B1_3_2 B1_3_1 B1_3_0 G03 S_1_7 S_1_6 S_1_5 S_1_4 S_1_3 S_1_2 S_1_1 S_1_0 W0_3_3 W0_3_2 W0_3_1 W0_3_0 W1_3_3 W1_3_2 W1_3_1 W1_3_0 \~R0_3_3 \~R0_3_2 \~R0_3_1 \~R0_3_0 \~R1_3_3 \~R1_3_2 \~R1_3_1 \~R1_3_0) _sub125
    I7 (net096_0 net096_1 net096_2 net096_3 net096_4 net096_5 net096_6 net096_7 net096_8 net096_9 net096_10 net096_11 net096_12 net096_13 net096_14 net096_15 net096_16 net096_17 net096_18 net096_19 net096_20 net096_21 net096_22 net096_23 net096_24 net096_25 net096_26 net096_27 net096_28 net096_29 net096_30 net096_31 net096_32 net096_33 net096_34 net096_35 net096_36 net096_37 net096_38 net096_39 net096_40 net096_41 net096_42 net096_43 net096_44 net096_45 net096_46 net096_47 net096_48 net096_49 net096_50 net096_51 net096_52 net096_53 net096_54 net096_55 net096_56 net096_57 net096_58 net096_59 net096_60 net096_61 net096_62 net096_63 B0_2_3 B0_2_2 B0_2_1 B0_2_0 B1_2_3 B1_2_2 B1_2_1 B1_2_0 G02 net068_0 net068_1 net068_2 net068_3 net068_4 net068_5 net068_6 net068_7 W0_2_3 W0_2_2 W0_2_1 W0_2_0 W1_2_3 W1_2_2 W1_2_1 W1_2_0 \~R0_2_3 \~R0_2_2 \~R0_2_1 \~R0_2_0 \~R1_2_3 \~R1_2_2 \~R1_2_1 \~R1_2_0) _sub125
    I6 (net0157_0 net0157_1 net0157_2 net0157_3 net0157_4 net0157_5 net0157_6 net0157_7 net0157_8 net0157_9 net0157_10 net0157_11 net0157_12 net0157_13 net0157_14 net0157_15 net0157_16 net0157_17 net0157_18 net0157_19 net0157_20 net0157_21 net0157_22 net0157_23 net0157_24 net0157_25 net0157_26 net0157_27 net0157_28 net0157_29 net0157_30 net0157_31 net0157_32 net0157_33 net0157_34 net0157_35 net0157_36 net0157_37 net0157_38 net0157_39 net0157_40 net0157_41 net0157_42 net0157_43 net0157_44 net0157_45 net0157_46 net0157_47 net0157_48 net0157_49 net0157_50 net0157_51 net0157_52 net0157_53 net0157_54 net0157_55 net0157_56 net0157_57 net0157_58 net0157_59 net0157_60 net0157_61 net0157_62 net0157_63 B0_2_3 B0_2_2 B0_2_1 B0_2_0 B1_2_3 B1_2_2 B1_2_1 B1_2_0 G02 net0131_0 net0131_1 net0131_2 net0131_3 net0131_4 net0131_5 net0131_6 net0131_7 W0_2_3 W0_2_2 W0_2_1 W0_2_0 W1_2_3 W1_2_2 W1_2_1 W1_2_0 \~R0_2_3 \~R0_2_2 \~R0_2_1 \~R0_2_0 \~R1_2_3 \~R1_2_2 \~R1_2_1 \~R1_2_0) _sub125
    I5 (net087_0 net087_1 net087_2 net087_3 net087_4 net087_5 net087_6 net087_7 net087_8 net087_9 net087_10 net087_11 net087_12 net087_13 net087_14 net087_15 net087_16 net087_17 net087_18 net087_19 net087_20 net087_21 net087_22 net087_23 net087_24 net087_25 net087_26 net087_27 net087_28 net087_29 net087_30 net087_31 net087_32 net087_33 net087_34 net087_35 net087_36 net087_37 net087_38 net087_39 net087_40 net087_41 net087_42 net087_43 net087_44 net087_45 net087_46 net087_47 net087_48 net087_49 net087_50 net087_51 net087_52 net087_53 net087_54 net087_55 net087_56 net087_57 net087_58 net087_59 net087_60 net087_61 net087_62 net087_63 B0_2_3 B0_2_2 B0_2_1 B0_2_0 B1_2_3 B1_2_2 B1_2_1 B1_2_0 G02 net059_0 net059_1 net059_2 net059_3 net059_4 net059_5 net059_6 net059_7 W0_2_3 W0_2_2 W0_2_1 W0_2_0 W1_2_3 W1_2_2 W1_2_1 W1_2_0 \~R0_2_3 \~R0_2_2 \~R0_2_1 \~R0_2_0 \~R1_2_3 \~R1_2_2 \~R1_2_1 \~R1_2_0) _sub125
    I4 (A_1_63 A_1_62 A_1_61 A_1_60 A_1_59 A_1_58 A_1_57 A_1_56 A_1_55 A_1_54 A_1_53 A_1_52 A_1_51 A_1_50 A_1_49 A_1_48 A_1_47 A_1_46 A_1_45 A_1_44 A_1_43 A_1_42 A_1_41 A_1_40 A_1_39 A_1_38 A_1_37 A_1_36 A_1_35 A_1_34 A_1_33 A_1_32 A_1_31 A_1_30 A_1_29 A_1_28 A_1_27 A_1_26 A_1_25 A_1_24 A_1_23 A_1_22 A_1_21 A_1_20 A_1_19 A_1_18 A_1_17 A_1_16 A_1_15 A_1_14 A_1_13 A_1_12 A_1_11 A_1_10 A_1_9 A_1_8 A_1_7 A_1_6 A_1_5 A_1_4 A_1_3 A_1_2 A_1_1 A_1_0 B0_2_3 B0_2_2 B0_2_1 B0_2_0 B1_2_3 B1_2_2 B1_2_1 B1_2_0 G02 S_1_7 S_1_6 S_1_5 S_1_4 S_1_3 S_1_2 S_1_1 S_1_0 W0_2_3 W0_2_2 W0_2_1 W0_2_0 W1_2_3 W1_2_2 W1_2_1 W1_2_0 \~R0_2_3 \~R0_2_2 \~R0_2_1 \~R0_2_0 \~R1_2_3 \~R1_2_2 \~R1_2_1 \~R1_2_0) _sub125
    I3 (net096_0 net096_1 net096_2 net096_3 net096_4 net096_5 net096_6 net096_7 net096_8 net096_9 net096_10 net096_11 net096_12 net096_13 net096_14 net096_15 net096_16 net096_17 net096_18 net096_19 net096_20 net096_21 net096_22 net096_23 net096_24 net096_25 net096_26 net096_27 net096_28 net096_29 net096_30 net096_31 net096_32 net096_33 net096_34 net096_35 net096_36 net096_37 net096_38 net096_39 net096_40 net096_41 net096_42 net096_43 net096_44 net096_45 net096_46 net096_47 net096_48 net096_49 net096_50 net096_51 net096_52 net096_53 net096_54 net096_55 net096_56 net096_57 net096_58 net096_59 net096_60 net096_61 net096_62 net096_63 B0_1_3 B0_1_2 B0_1_1 B0_1_0 B1_1_3 B1_1_2 B1_1_1 B1_1_0 G01 net068_0 net068_1 net068_2 net068_3 net068_4 net068_5 net068_6 net068_7 W0_1_3 W0_1_2 W0_1_1 W0_1_0 W1_1_3 W1_1_2 W1_1_1 W1_1_0 \~R0_1_3 \~R0_1_2 \~R0_1_1 \~R0_1_0 \~R1_1_3 \~R1_1_2 \~R1_1_1 \~R1_1_0) _sub125
    I2 (net0157_0 net0157_1 net0157_2 net0157_3 net0157_4 net0157_5 net0157_6 net0157_7 net0157_8 net0157_9 net0157_10 net0157_11 net0157_12 net0157_13 net0157_14 net0157_15 net0157_16 net0157_17 net0157_18 net0157_19 net0157_20 net0157_21 net0157_22 net0157_23 net0157_24 net0157_25 net0157_26 net0157_27 net0157_28 net0157_29 net0157_30 net0157_31 net0157_32 net0157_33 net0157_34 net0157_35 net0157_36 net0157_37 net0157_38 net0157_39 net0157_40 net0157_41 net0157_42 net0157_43 net0157_44 net0157_45 net0157_46 net0157_47 net0157_48 net0157_49 net0157_50 net0157_51 net0157_52 net0157_53 net0157_54 net0157_55 net0157_56 net0157_57 net0157_58 net0157_59 net0157_60 net0157_61 net0157_62 net0157_63 B0_1_3 B0_1_2 B0_1_1 B0_1_0 B1_1_3 B1_1_2 B1_1_1 B1_1_0 G01 net0131_0 net0131_1 net0131_2 net0131_3 net0131_4 net0131_5 net0131_6 net0131_7 W0_1_3 W0_1_2 W0_1_1 W0_1_0 W1_1_3 W1_1_2 W1_1_1 W1_1_0 \~R0_1_3 \~R0_1_2 \~R0_1_1 \~R0_1_0 \~R1_1_3 \~R1_1_2 \~R1_1_1 \~R1_1_0) _sub125
    I1 (net087_0 net087_1 net087_2 net087_3 net087_4 net087_5 net087_6 net087_7 net087_8 net087_9 net087_10 net087_11 net087_12 net087_13 net087_14 net087_15 net087_16 net087_17 net087_18 net087_19 net087_20 net087_21 net087_22 net087_23 net087_24 net087_25 net087_26 net087_27 net087_28 net087_29 net087_30 net087_31 net087_32 net087_33 net087_34 net087_35 net087_36 net087_37 net087_38 net087_39 net087_40 net087_41 net087_42 net087_43 net087_44 net087_45 net087_46 net087_47 net087_48 net087_49 net087_50 net087_51 net087_52 net087_53 net087_54 net087_55 net087_56 net087_57 net087_58 net087_59 net087_60 net087_61 net087_62 net087_63 B0_1_3 B0_1_2 B0_1_1 B0_1_0 B1_1_3 B1_1_2 B1_1_1 B1_1_0 G01 net059_0 net059_1 net059_2 net059_3 net059_4 net059_5 net059_6 net059_7 W0_1_3 W0_1_2 W0_1_1 W0_1_0 W1_1_3 W1_1_2 W1_1_1 W1_1_0 \~R0_1_3 \~R0_1_2 \~R0_1_1 \~R0_1_0 \~R1_1_3 \~R1_1_2 \~R1_1_1 \~R1_1_0) _sub125
    I0 (A_1_63 A_1_62 A_1_61 A_1_60 A_1_59 A_1_58 A_1_57 A_1_56 A_1_55 A_1_54 A_1_53 A_1_52 A_1_51 A_1_50 A_1_49 A_1_48 A_1_47 A_1_46 A_1_45 A_1_44 A_1_43 A_1_42 A_1_41 A_1_40 A_1_39 A_1_38 A_1_37 A_1_36 A_1_35 A_1_34 A_1_33 A_1_32 A_1_31 A_1_30 A_1_29 A_1_28 A_1_27 A_1_26 A_1_25 A_1_24 A_1_23 A_1_22 A_1_21 A_1_20 A_1_19 A_1_18 A_1_17 A_1_16 A_1_15 A_1_14 A_1_13 A_1_12 A_1_11 A_1_10 A_1_9 A_1_8 A_1_7 A_1_6 A_1_5 A_1_4 A_1_3 A_1_2 A_1_1 A_1_0 B0_1_3 B0_1_2 B0_1_1 B0_1_0 B1_1_3 B1_1_2 B1_1_1 B1_1_0 G01 S_1_7 S_1_6 S_1_5 S_1_4 S_1_3 S_1_2 S_1_1 S_1_0 W0_1_3 W0_1_2 W0_1_1 W0_1_0 W1_1_3 W1_1_2 W1_1_1 W1_1_0 \~R0_1_3 \~R0_1_2 \~R0_1_1 \~R0_1_0 \~R1_1_3 \~R1_1_2 \~R1_1_1 \~R1_1_0) _sub125
    I25 (net042 B0_4_3 B0_4_2 B0_4_1 B0_4_0 B1_4_3 B1_4_2 B1_4_1 B1_4_0 G04 RD_8of32_27 RD_8of32_26 RD_8of32_25 RD_8of32_24 RD_8of32_31 RD_8of32_30 RD_8of32_29 RD_8of32_28 RW_1 RW_0 Reset ValAddr W0_4_3 W0_4_2 W0_4_1 W0_4_0 W1_4_3 W1_4_2 W1_4_1 W1_4_0 WD_8of32_27 WD_8of32_26 WD_8of32_25 WD_8of32_24 WD_8of32_31 WD_8of32_30 WD_8of32_29 WD_8of32_28 0 net0170 RD_Ack_7 RD_Ack_6 WD_Ack_7 WD_Ack_6 \~R0_4_3 \~R0_4_2 \~R0_4_1 \~R0_4_0 \~R1_4_3 \~R1_4_2 \~R1_4_1 \~R1_4_0) _sub128
    I22 (ck_2 B0_3_3 B0_3_2 B0_3_1 B0_3_0 B1_3_3 B1_3_2 B1_3_1 B1_3_0 G03 RD_8of32_19 RD_8of32_18 RD_8of32_17 RD_8of32_16 RD_8of32_23 RD_8of32_22 RD_8of32_21 RD_8of32_20 RW_1 RW_0 Reset ValAddr W0_3_3 W0_3_2 W0_3_1 W0_3_0 W1_3_3 W1_3_2 W1_3_1 W1_3_0 WD_8of32_19 WD_8of32_18 WD_8of32_17 WD_8of32_16 WD_8of32_23 WD_8of32_22 WD_8of32_21 WD_8of32_20 net042 ck_3 RD_Ack_5 RD_Ack_4 WD_Ack_5 WD_Ack_4 \~R0_3_3 \~R0_3_2 \~R0_3_1 \~R0_3_0 \~R1_3_3 \~R1_3_2 \~R1_3_1 \~R1_3_0) _sub128
    I21 (ck_0 B0_2_3 B0_2_2 B0_2_1 B0_2_0 B1_2_3 B1_2_2 B1_2_1 B1_2_0 G02 RD_8of32_11 RD_8of32_10 RD_8of32_9 RD_8of32_8 RD_8of32_15 RD_8of32_14 RD_8of32_13 RD_8of32_12 RW_1 RW_0 Reset ValAddr W0_2_3 W0_2_2 W0_2_1 W0_2_0 W1_2_3 W1_2_2 W1_2_1 W1_2_0 WD_8of32_11 WD_8of32_10 WD_8of32_9 WD_8of32_8 WD_8of32_15 WD_8of32_14 WD_8of32_13 WD_8of32_12 ck_1 net027 RD_Ack_3 RD_Ack_2 WD_Ack_3 WD_Ack_2 \~R0_2_3 \~R0_2_2 \~R0_2_1 \~R0_2_0 \~R1_2_3 \~R1_2_2 \~R1_2_1 \~R1_2_0) _sub128
    I20 (net027 B0_1_3 B0_1_2 B0_1_1 B0_1_0 B1_1_3 B1_1_2 B1_1_1 B1_1_0 G01 RD_8of32_3 RD_8of32_2 RD_8of32_1 RD_8of32_0 RD_8of32_7 RD_8of32_6 RD_8of32_5 RD_8of32_4 RW_1 RW_0 Reset ValAddr W0_1_3 W0_1_2 W0_1_1 W0_1_0 W1_1_3 W1_1_2 W1_1_1 W1_1_0 WD_8of32_3 WD_8of32_2 WD_8of32_1 WD_8of32_0 WD_8of32_7 WD_8of32_6 WD_8of32_5 WD_8of32_4 net0173 0 RD_Ack_1 RD_Ack_0 WD_Ack_1 WD_Ack_0 \~R0_1_3 \~R0_1_2 \~R0_1_1 \~R0_1_0 \~R1_1_3 \~R1_1_2 \~R1_1_1 \~R1_1_0) _sub128
    I24 (A_3 A_2 A_1 A_0 A_7 A_6 A_5 A_4 A_11 A_10 A_9 A_8 A_15 A_14 A_13 A_12 A_19 A_18 A_17 A_16 ck_1 ck_0 ck_3 ck_2 net09 RW_1 RW_0 Reset ValAddr) _sub129
    I30 (net09 Ack) inv_1x
    I29_4 (net09 Ctrl_Ack_4) inv_1x
    I29_3 (net09 Ctrl_Ack_3) inv_1x
    I29_2 (net09 Ctrl_Ack_2) inv_1x
    I29_1 (net09 Ctrl_Ack_1) inv_1x
    I29_0 (net09 Ctrl_Ack_0) inv_1x
    I19 (A_3 A_2 A_1 A_0 A_7 A_6 A_5 A_4 A_11 A_10 A_9 A_8 A_15 A_14 A_13 A_12 net096_0 net096_1 net096_2 net096_3 net096_4 net096_5 net096_6 net096_7 net096_8 net096_9 net096_10 net096_11 net096_12 net096_13 net096_14 net096_15 net096_16 net096_17 net096_18 net096_19 net096_20 net096_21 net096_22 net096_23 net096_24 net096_25 net096_26 net096_27 net096_28 net096_29 net096_30 net096_31 net096_32 net096_33 net096_34 net096_35 net096_36 net096_37 net096_38 net096_39 net096_40 net096_41 net096_42 net096_43 net096_44 net096_45 net096_46 net096_47 net096_48 net096_49 net096_50 net096_51 net096_52 net096_53 net096_54 net096_55 net096_56 net096_57 net096_58 net096_59 net096_60 net096_61 net096_62 net096_63 A_19 net068_0 net068_1 net068_2 net068_3 net068_4 net068_5 net068_6 net068_7) _sub130
    I18 (A_3 A_2 A_1 A_0 A_7 A_6 A_5 A_4 A_11 A_10 A_9 A_8 A_15 A_14 A_13 A_12 net0157_0 net0157_1 net0157_2 net0157_3 net0157_4 net0157_5 net0157_6 net0157_7 net0157_8 net0157_9 net0157_10 net0157_11 net0157_12 net0157_13 net0157_14 net0157_15 net0157_16 net0157_17 net0157_18 net0157_19 net0157_20 net0157_21 net0157_22 net0157_23 net0157_24 net0157_25 net0157_26 net0157_27 net0157_28 net0157_29 net0157_30 net0157_31 net0157_32 net0157_33 net0157_34 net0157_35 net0157_36 net0157_37 net0157_38 net0157_39 net0157_40 net0157_41 net0157_42 net0157_43 net0157_44 net0157_45 net0157_46 net0157_47 net0157_48 net0157_49 net0157_50 net0157_51 net0157_52 net0157_53 net0157_54 net0157_55 net0157_56 net0157_57 net0157_58 net0157_59 net0157_60 net0157_61 net0157_62 net0157_63 A_18 net0131_0 net0131_1 net0131_2 net0131_3 net0131_4 net0131_5 net0131_6 net0131_7) _sub130
    I17 (A_3 A_2 A_1 A_0 A_7 A_6 A_5 A_4 A_11 A_10 A_9 A_8 A_15 A_14 A_13 A_12 net087_0 net087_1 net087_2 net087_3 net087_4 net087_5 net087_6 net087_7 net087_8 net087_9 net087_10 net087_11 net087_12 net087_13 net087_14 net087_15 net087_16 net087_17 net087_18 net087_19 net087_20 net087_21 net087_22 net087_23 net087_24 net087_25 net087_26 net087_27 net087_28 net087_29 net087_30 net087_31 net087_32 net087_33 net087_34 net087_35 net087_36 net087_37 net087_38 net087_39 net087_40 net087_41 net087_42 net087_43 net087_44 net087_45 net087_46 net087_47 net087_48 net087_49 net087_50 net087_51 net087_52 net087_53 net087_54 net087_55 net087_56 net087_57 net087_58 net087_59 net087_60 net087_61 net087_62 net087_63 A_17 net059_0 net059_1 net059_2 net059_3 net059_4 net059_5 net059_6 net059_7) _sub130
    I16 (A_3 A_2 A_1 A_0 A_7 A_6 A_5 A_4 A_11 A_10 A_9 A_8 A_15 A_14 A_13 A_12 A_1_63 A_1_62 A_1_61 A_1_60 A_1_59 A_1_58 A_1_57 A_1_56 A_1_55 A_1_54 A_1_53 A_1_52 A_1_51 A_1_50 A_1_49 A_1_48 A_1_47 A_1_46 A_1_45 A_1_44 A_1_43 A_1_42 A_1_41 A_1_40 A_1_39 A_1_38 A_1_37 A_1_36 A_1_35 A_1_34 A_1_33 A_1_32 A_1_31 A_1_30 A_1_29 A_1_28 A_1_27 A_1_26 A_1_25 A_1_24 A_1_23 A_1_22 A_1_21 A_1_20 A_1_19 A_1_18 A_1_17 A_1_16 A_1_15 A_1_14 A_1_13 A_1_12 A_1_11 A_1_10 A_1_9 A_1_8 A_1_7 A_1_6 A_1_5 A_1_4 A_1_3 A_1_2 A_1_1 A_1_0 A_16 S_1_7 S_1_6 S_1_5 S_1_4 S_1_3 S_1_2 S_1_1 S_1_0) _sub130
ends _sub131

// 16nm/inv_1xt/schematic
//system verilogNetlist schematic cmos.sch cmos_sch veriloga ahdl
subckt inv_1xt A Y
    M0 (Y A 0 0) nfet w=60n l=20n nfin=1 m=1 degradation=no
    M1 (Y A vcc! vcc!) pfet w=100n l=20n nfin=1 m=1 degradation=no
ends inv_1xt

// 16nm_Tests/6T_BANK_Test/schematic
// system verilogNetlist schematic cmos.sch cmos_sch veriloga ahdl
V1 (vdd! 0) vsource type=dc dc=vdd
V0 (vcc! 0) vsource type=dc dc=vcc
IBank (AT_19 AT_18 AT_17 AT_16 AT_15 AT_14 AT_13 AT_12 AT_11 AT_10 AT_9 AT_8 AT_7 AT_6 AT_5 AT_4 AT_3 AT_2 AT_1 AT_0 AckT net018_0 net018_1 net018_2 net018_3 net018_4 ReaDataT_31 ReaDataT_30 ReaDataT_29 ReaDataT_28 ReaDataT_27 ReaDataT_26 ReaDataT_25 ReaDataT_24 ReaDataT_23 ReaDataT_22 ReaDataT_21 ReaDataT_20 ReaDataT_19 ReaDataT_18 ReaDataT_17 ReaDataT_16 ReaDataT_15 ReaDataT_14 ReaDataT_13 ReaDataT_12 ReaDataT_11 ReaDataT_10 ReaDataT_9 ReaDataT_8 ReaDataT_7 ReaDataT_6 ReaDataT_5 ReaDataT_4 ReaDataT_3 ReaDataT_2 ReaDataT_1 ReaDataT_0 RAckT_7 RAckT_6 RAckT_5 RAckT_4 RAckT_3 RAckT_2 RAckT_1 RAckT_0 RWT_1 RWT_0 WriteDataT_31 WriteDataT_30 WriteDataT_29 WriteDataT_28 WriteDataT_27 WriteDataT_26 WriteDataT_25 WriteDataT_24 WriteDataT_23 WriteDataT_22 WriteDataT_21 WriteDataT_20 WriteDataT_19 WriteDataT_18 WriteDataT_17 WriteDataT_16 WriteDataT_15 WriteDataT_14 WriteDataT_13 WriteDataT_12 WriteDataT_11 WriteDataT_10 WriteDataT_9 WriteDataT_8 WriteDataT_7 WriteDataT_6 WriteDataT_5 WriteDataT_4 WriteDataT_3 WriteDataT_2 WriteDataT_1 WriteDataT_0 WAck_7 WAck_6 WAck_5 WAck_4 WAck_3 WAck_2 WAck_1 WAck_0) _sub131
I15_4 (net018_0 net013_0) inv_1xt
I15_3 (net018_1 net013_1) inv_1xt
I15_2 (net018_2 net013_2) inv_1xt
I15_1 (net018_3 net013_3) inv_1xt
I15_0 (net018_4 net013_4) inv_1xt
I11_7 (\~RAck_7 RAckT_7) inv_1xt
I11_6 (\~RAck_6 RAckT_6) inv_1xt
I11_5 (\~RAck_5 RAckT_5) inv_1xt
I11_4 (\~RAck_4 RAckT_4) inv_1xt
I11_3 (\~RAck_3 RAckT_3) inv_1xt
I11_2 (\~RAck_2 RAckT_2) inv_1xt
I11_1 (\~RAck_1 RAckT_1) inv_1xt
I11_0 (\~RAck_0 RAckT_0) inv_1xt
I10_7 (WAck_7 \~WAck_7) inv_1xt
I10_6 (WAck_6 \~WAck_6) inv_1xt
I10_5 (WAck_5 \~WAck_5) inv_1xt
I10_4 (WAck_4 \~WAck_4) inv_1xt
I10_3 (WAck_3 \~WAck_3) inv_1xt
I10_2 (WAck_2 \~WAck_2) inv_1xt
I10_1 (WAck_1 \~WAck_1) inv_1xt
I10_0 (WAck_0 \~WAck_0) inv_1xt
I16_1 (\~RW_1 RWT_1) inv_1xt
I16_0 (\~RW_0 RWT_0) inv_1xt
I14_19 (\~A_19 AT_19) inv_1xt
I14_18 (\~A_18 AT_18) inv_1xt
I14_17 (\~A_17 AT_17) inv_1xt
I14_16 (\~A_16 AT_16) inv_1xt
I14_15 (\~A_15 AT_15) inv_1xt
I14_14 (\~A_14 AT_14) inv_1xt
I14_13 (\~A_13 AT_13) inv_1xt
I14_12 (\~A_12 AT_12) inv_1xt
I14_11 (\~A_11 AT_11) inv_1xt
I14_10 (\~A_10 AT_10) inv_1xt
I14_9 (\~A_9 AT_9) inv_1xt
I14_8 (\~A_8 AT_8) inv_1xt
I14_7 (\~A_7 AT_7) inv_1xt
I14_6 (\~A_6 AT_6) inv_1xt
I14_5 (\~A_5 AT_5) inv_1xt
I14_4 (\~A_4 AT_4) inv_1xt
I14_3 (\~A_3 AT_3) inv_1xt
I14_2 (\~A_2 AT_2) inv_1xt
I14_1 (\~A_1 AT_1) inv_1xt
I14_0 (\~A_0 AT_0) inv_1xt
I13 (AckT \~Ack) inv_1xt
I6_31 (ReaDataT_31 \~ReadData_31) inv_1xt
I6_30 (ReaDataT_30 \~ReadData_30) inv_1xt
I6_29 (ReaDataT_29 \~ReadData_29) inv_1xt
I6_28 (ReaDataT_28 \~ReadData_28) inv_1xt
I6_27 (ReaDataT_27 \~ReadData_27) inv_1xt
I6_26 (ReaDataT_26 \~ReadData_26) inv_1xt
I6_25 (ReaDataT_25 \~ReadData_25) inv_1xt
I6_24 (ReaDataT_24 \~ReadData_24) inv_1xt
I6_23 (ReaDataT_23 \~ReadData_23) inv_1xt
I6_22 (ReaDataT_22 \~ReadData_22) inv_1xt
I6_21 (ReaDataT_21 \~ReadData_21) inv_1xt
I6_20 (ReaDataT_20 \~ReadData_20) inv_1xt
I6_19 (ReaDataT_19 \~ReadData_19) inv_1xt
I6_18 (ReaDataT_18 \~ReadData_18) inv_1xt
I6_17 (ReaDataT_17 \~ReadData_17) inv_1xt
I6_16 (ReaDataT_16 \~ReadData_16) inv_1xt
I6_15 (ReaDataT_15 \~ReadData_15) inv_1xt
I6_14 (ReaDataT_14 \~ReadData_14) inv_1xt
I6_13 (ReaDataT_13 \~ReadData_13) inv_1xt
I6_12 (ReaDataT_12 \~ReadData_12) inv_1xt
I6_11 (ReaDataT_11 \~ReadData_11) inv_1xt
I6_10 (ReaDataT_10 \~ReadData_10) inv_1xt
I6_9 (ReaDataT_9 \~ReadData_9) inv_1xt
I6_8 (ReaDataT_8 \~ReadData_8) inv_1xt
I6_7 (ReaDataT_7 \~ReadData_7) inv_1xt
I6_6 (ReaDataT_6 \~ReadData_6) inv_1xt
I6_5 (ReaDataT_5 \~ReadData_5) inv_1xt
I6_4 (ReaDataT_4 \~ReadData_4) inv_1xt
I6_3 (ReaDataT_3 \~ReadData_3) inv_1xt
I6_2 (ReaDataT_2 \~ReadData_2) inv_1xt
I6_1 (ReaDataT_1 \~ReadData_1) inv_1xt
I6_0 (ReaDataT_0 \~ReadData_0) inv_1xt
I5_31 (\~WriteData_31 WriteDataT_31) inv_1xt
I5_30 (\~WriteData_30 WriteDataT_30) inv_1xt
I5_29 (\~WriteData_29 WriteDataT_29) inv_1xt
I5_28 (\~WriteData_28 WriteDataT_28) inv_1xt
I5_27 (\~WriteData_27 WriteDataT_27) inv_1xt
I5_26 (\~WriteData_26 WriteDataT_26) inv_1xt
I5_25 (\~WriteData_25 WriteDataT_25) inv_1xt
I5_24 (\~WriteData_24 WriteDataT_24) inv_1xt
I5_23 (\~WriteData_23 WriteDataT_23) inv_1xt
I5_22 (\~WriteData_22 WriteDataT_22) inv_1xt
I5_21 (\~WriteData_21 WriteDataT_21) inv_1xt
I5_20 (\~WriteData_20 WriteDataT_20) inv_1xt
I5_19 (\~WriteData_19 WriteDataT_19) inv_1xt
I5_18 (\~WriteData_18 WriteDataT_18) inv_1xt
I5_17 (\~WriteData_17 WriteDataT_17) inv_1xt
I5_16 (\~WriteData_16 WriteDataT_16) inv_1xt
I5_15 (\~WriteData_15 WriteDataT_15) inv_1xt
I5_14 (\~WriteData_14 WriteDataT_14) inv_1xt
I5_13 (\~WriteData_13 WriteDataT_13) inv_1xt
I5_12 (\~WriteData_12 WriteDataT_12) inv_1xt
I5_11 (\~WriteData_11 WriteDataT_11) inv_1xt
I5_10 (\~WriteData_10 WriteDataT_10) inv_1xt
I5_9 (\~WriteData_9 WriteDataT_9) inv_1xt
I5_8 (\~WriteData_8 WriteDataT_8) inv_1xt
I5_7 (\~WriteData_7 WriteDataT_7) inv_1xt
I5_6 (\~WriteData_6 WriteDataT_6) inv_1xt
I5_5 (\~WriteData_5 WriteDataT_5) inv_1xt
I5_4 (\~WriteData_4 WriteDataT_4) inv_1xt
I5_3 (\~WriteData_3 WriteDataT_3) inv_1xt
I5_2 (\~WriteData_2 WriteDataT_2) inv_1xt
I5_1 (\~WriteData_1 WriteDataT_1) inv_1xt
I5_0 (\~WriteData_0 WriteDataT_0) inv_1xt
// BEGIN Hierarchical Interface Elements
_ie99892 (\~RAck_0 0) d2a src="99892" val0=0.0 val1=vdd valx=vdd/2 rise=2p fall=2p
_ie99893 (\~WriteData_13 0) d2a src="99893" val0=0.0 val1=vdd valx=vdd/2 rise=2p fall=2p
_ie99894 (\~WriteData_9 0) d2a src="99894" val0=0.0 val1=vdd valx=vdd/2 rise=2p fall=2p
_ie99895 (\~A_10 0) d2a src="99895" val0=0.0 val1=vdd valx=vdd/2 rise=2p fall=2p
_ie99896 (\~WriteData_14 0) d2a src="99896" val0=0.0 val1=vdd valx=vdd/2 rise=2p fall=2p
_ie99897 (\~ReadData_24 0) a2d dest="99897" vl=0.3*vdd vh=0.7*vdd timex=20n
_ie99898 (\~WAck_1 0) a2d dest="99898" vl=0.3*vdd vh=0.7*vdd timex=20n
_ie99899 (\~ReadData_25 0) a2d dest="99899" vl=0.3*vdd vh=0.7*vdd timex=20n
_ie99900 (\~ReadData_18 0) a2d dest="99900" vl=0.3*vdd vh=0.7*vdd timex=20n
_ie99901 (\~ReadData_26 0) a2d dest="99901" vl=0.3*vdd vh=0.7*vdd timex=20n
_ie99902 (\~RAck_7 0) d2a src="99902" val0=0.0 val1=vdd valx=vdd/2 rise=2p fall=2p
_ie99903 (\~ReadData_27 0) a2d dest="99903" vl=0.3*vdd vh=0.7*vdd timex=20n
_ie99904 (\~RW_0 0) d2a src="99904" val0=0.0 val1=vdd valx=vdd/2 rise=2p fall=2p
_ie99905 (\~WAck_0 0) a2d dest="99905" vl=0.3*vdd vh=0.7*vdd timex=20n
_ie99906 (\~A_6 0) d2a src="99906" val0=0.0 val1=vdd valx=vdd/2 rise=2p fall=2p
_ie99907 (\~A_7 0) d2a src="99907" val0=0.0 val1=vdd valx=vdd/2 rise=2p fall=2p
_ie99908 (\~A_11 0) d2a src="99908" val0=0.0 val1=vdd valx=vdd/2 rise=2p fall=2p
_ie99909 (\~RAck_1 0) d2a src="99909" val0=0.0 val1=vdd valx=vdd/2 rise=2p fall=2p
_ie99910 (\~A_12 0) d2a src="99910" val0=0.0 val1=vdd valx=vdd/2 rise=2p fall=2p
_ie99911 (\~ReadData_10 0) a2d dest="99911" vl=0.3*vdd vh=0.7*vdd timex=20n
_ie99912 (\~WriteData_6 0) d2a src="99912" val0=0.0 val1=vdd valx=vdd/2 rise=2p fall=2p
_ie99913 (\~WAck_4 0) a2d dest="99913" vl=0.3*vdd vh=0.7*vdd timex=20n
_ie99914 (\~WriteData_15 0) d2a src="99914" val0=0.0 val1=vdd valx=vdd/2 rise=2p fall=2p
_ie99915 (\~A_8 0) d2a src="99915" val0=0.0 val1=vdd valx=vdd/2 rise=2p fall=2p
_ie99916 (\~RAck_2 0) d2a src="99916" val0=0.0 val1=vdd valx=vdd/2 rise=2p fall=2p
_ie99917 (\~ReadData_0 0) a2d dest="99917" vl=0.3*vdd vh=0.7*vdd timex=20n
_ie99918 (\~WriteData_17 0) d2a src="99918" val0=0.0 val1=vdd valx=vdd/2 rise=2p fall=2p
_ie99919 (\~WriteData_29 0) d2a src="99919" val0=0.0 val1=vdd valx=vdd/2 rise=2p fall=2p
_ie99920 (\~ReadData_13 0) a2d dest="99920" vl=0.3*vdd vh=0.7*vdd timex=20n
_ie99921 (\~A_13 0) d2a src="99921" val0=0.0 val1=vdd valx=vdd/2 rise=2p fall=2p
_ie99922 (\~RW_1 0) d2a src="99922" val0=0.0 val1=vdd valx=vdd/2 rise=2p fall=2p
_ie99923 (\~ReadData_1 0) a2d dest="99923" vl=0.3*vdd vh=0.7*vdd timex=20n
_ie99924 (\~A_19 0) d2a src="99924" val0=0.0 val1=vdd valx=vdd/2 rise=2p fall=2p
_ie99925 (\~ReadData_5 0) a2d dest="99925" vl=0.3*vdd vh=0.7*vdd timex=20n
_ie99926 (\~A_14 0) d2a src="99926" val0=0.0 val1=vdd valx=vdd/2 rise=2p fall=2p
_ie99927 (\~A_15 0) d2a src="99927" val0=0.0 val1=vdd valx=vdd/2 rise=2p fall=2p
_ie99928 (\~A_16 0) d2a src="99928" val0=0.0 val1=vdd valx=vdd/2 rise=2p fall=2p
_ie99929 (\~A_5 0) d2a src="99929" val0=0.0 val1=vdd valx=vdd/2 rise=2p fall=2p
_ie99930 (\~ReadData_9 0) a2d dest="99930" vl=0.3*vdd vh=0.7*vdd timex=20n
_ie99931 (\~ReadData_14 0) a2d dest="99931" vl=0.3*vdd vh=0.7*vdd timex=20n
_ie99932 (net013_1 0) a2d dest="99932" vl=0.3*vdd vh=0.7*vdd timex=20n
_ie99933 (\~WriteData_10 0) d2a src="99933" val0=0.0 val1=vdd valx=vdd/2 rise=2p fall=2p
_ie99934 (\~WriteData_11 0) d2a src="99934" val0=0.0 val1=vdd valx=vdd/2 rise=2p fall=2p
_ie99935 (net013_0 0) a2d dest="99935" vl=0.3*vdd vh=0.7*vdd timex=20n
_ie99936 (\~RAck_3 0) d2a src="99936" val0=0.0 val1=vdd valx=vdd/2 rise=2p fall=2p
_ie99937 (\~RAck_6 0) d2a src="99937" val0=0.0 val1=vdd valx=vdd/2 rise=2p fall=2p
_ie99938 (\~WriteData_16 0) d2a src="99938" val0=0.0 val1=vdd valx=vdd/2 rise=2p fall=2p
_ie99939 (\~WriteData_23 0) d2a src="99939" val0=0.0 val1=vdd valx=vdd/2 rise=2p fall=2p
_ie99940 (\~WriteData_24 0) d2a src="99940" val0=0.0 val1=vdd valx=vdd/2 rise=2p fall=2p
_ie99941 (\~ReadData_19 0) a2d dest="99941" vl=0.3*vdd vh=0.7*vdd timex=20n
_ie99942 (\~ReadData_2 0) a2d dest="99942" vl=0.3*vdd vh=0.7*vdd timex=20n
_ie99943 (\~WAck_5 0) a2d dest="99943" vl=0.3*vdd vh=0.7*vdd timex=20n
_ie99944 (\~ReadData_17 0) a2d dest="99944" vl=0.3*vdd vh=0.7*vdd timex=20n
_ie99945 (\~WAck_6 0) a2d dest="99945" vl=0.3*vdd vh=0.7*vdd timex=20n
_ie99946 (\~WriteData_18 0) d2a src="99946" val0=0.0 val1=vdd valx=vdd/2 rise=2p fall=2p
_ie99947 (\~A_0 0) d2a src="99947" val0=0.0 val1=vdd valx=vdd/2 rise=2p fall=2p
_ie99948 (\~WAck_7 0) a2d dest="99948" vl=0.3*vdd vh=0.7*vdd timex=20n
_ie99949 (\~WriteData_7 0) d2a src="99949" val0=0.0 val1=vdd valx=vdd/2 rise=2p fall=2p
_ie99950 (\~ReadData_30 0) a2d dest="99950" vl=0.3*vdd vh=0.7*vdd timex=20n
_ie99951 (\~WAck_3 0) a2d dest="99951" vl=0.3*vdd vh=0.7*vdd timex=20n
_ie99952 (\~ReadData_12 0) a2d dest="99952" vl=0.3*vdd vh=0.7*vdd timex=20n
_ie99953 (\~A_4 0) d2a src="99953" val0=0.0 val1=vdd valx=vdd/2 rise=2p fall=2p
_ie99954 (\~WriteData_12 0) d2a src="99954" val0=0.0 val1=vdd valx=vdd/2 rise=2p fall=2p
_ie99955 (\~WriteData_25 0) d2a src="99955" val0=0.0 val1=vdd valx=vdd/2 rise=2p fall=2p
_ie99956 (\~ReadData_22 0) a2d dest="99956" vl=0.3*vdd vh=0.7*vdd timex=20n
_ie99957 (\~ReadData_6 0) a2d dest="99957" vl=0.3*vdd vh=0.7*vdd timex=20n
_ie99958 (\~WriteData_22 0) d2a src="99958" val0=0.0 val1=vdd valx=vdd/2 rise=2p fall=2p
_ie99959 (\~ReadData_15 0) a2d dest="99959" vl=0.3*vdd vh=0.7*vdd timex=20n
_ie99960 (\~A_1 0) d2a src="99960" val0=0.0 val1=vdd valx=vdd/2 rise=2p fall=2p
_ie99961 (\~A_2 0) d2a src="99961" val0=0.0 val1=vdd valx=vdd/2 rise=2p fall=2p
_ie99962 (\~WriteData_28 0) d2a src="99962" val0=0.0 val1=vdd valx=vdd/2 rise=2p fall=2p
_ie99963 (\~WAck_2 0) a2d dest="99963" vl=0.3*vdd vh=0.7*vdd timex=20n
_ie99964 (\~WriteData_20 0) d2a src="99964" val0=0.0 val1=vdd valx=vdd/2 rise=2p fall=2p
_ie99965 (\~ReadData_8 0) a2d dest="99965" vl=0.3*vdd vh=0.7*vdd timex=20n
_ie99966 (\~ReadData_21 0) a2d dest="99966" vl=0.3*vdd vh=0.7*vdd timex=20n
_ie99967 (\~RAck_4 0) d2a src="99967" val0=0.0 val1=vdd valx=vdd/2 rise=2p fall=2p
_ie99968 (\~WriteData_21 0) d2a src="99968" val0=0.0 val1=vdd valx=vdd/2 rise=2p fall=2p
_ie99969 (\~ReadData_16 0) a2d dest="99969" vl=0.3*vdd vh=0.7*vdd timex=20n
_ie99970 (\~A_17 0) d2a src="99970" val0=0.0 val1=vdd valx=vdd/2 rise=2p fall=2p
_ie99971 (\~WriteData_19 0) d2a src="99971" val0=0.0 val1=vdd valx=vdd/2 rise=2p fall=2p
_ie99972 (\~WriteData_30 0) d2a src="99972" val0=0.0 val1=vdd valx=vdd/2 rise=2p fall=2p
_ie99973 (\~WriteData_31 0) d2a src="99973" val0=0.0 val1=vdd valx=vdd/2 rise=2p fall=2p
_ie99974 (\~A_3 0) d2a src="99974" val0=0.0 val1=vdd valx=vdd/2 rise=2p fall=2p
_ie99975 (\~ReadData_4 0) a2d dest="99975" vl=0.3*vdd vh=0.7*vdd timex=20n
_ie99976 (\~A_18 0) d2a src="99976" val0=0.0 val1=vdd valx=vdd/2 rise=2p fall=2p
_ie99977 (\~WriteData_26 0) d2a src="99977" val0=0.0 val1=vdd valx=vdd/2 rise=2p fall=2p
_ie99978 (\~WriteData_27 0) d2a src="99978" val0=0.0 val1=vdd valx=vdd/2 rise=2p fall=2p
_ie99979 (\~Ack 0) a2d dest="99979" vl=0.3*vdd vh=0.7*vdd timex=20n
_ie99980 (\~ReadData_23 0) a2d dest="99980" vl=0.3*vdd vh=0.7*vdd timex=20n
_ie99981 (\~ReadData_31 0) a2d dest="99981" vl=0.3*vdd vh=0.7*vdd timex=20n
_ie99982 (\~ReadData_3 0) a2d dest="99982" vl=0.3*vdd vh=0.7*vdd timex=20n
_ie99983 (\~ReadData_28 0) a2d dest="99983" vl=0.3*vdd vh=0.7*vdd timex=20n
_ie99984 (\~ReadData_29 0) a2d dest="99984" vl=0.3*vdd vh=0.7*vdd timex=20n
_ie99985 (\~ReadData_11 0) a2d dest="99985" vl=0.3*vdd vh=0.7*vdd timex=20n
_ie99986 (\~WriteData_8 0) d2a src="99986" val0=0.0 val1=vdd valx=vdd/2 rise=2p fall=2p
_ie99987 (\~ReadData_20 0) a2d dest="99987" vl=0.3*vdd vh=0.7*vdd timex=20n
_ie99988 (\~WriteData_1 0) d2a src="99988" val0=0.0 val1=vdd valx=vdd/2 rise=2p fall=2p
_ie99989 (\~WriteData_2 0) d2a src="99989" val0=0.0 val1=vdd valx=vdd/2 rise=2p fall=2p
_ie99990 (\~WriteData_3 0) d2a src="99990" val0=0.0 val1=vdd valx=vdd/2 rise=2p fall=2p
_ie99991 (\~WriteData_4 0) d2a src="99991" val0=0.0 val1=vdd valx=vdd/2 rise=2p fall=2p
_ie99992 (\~WriteData_5 0) d2a src="99992" val0=0.0 val1=vdd valx=vdd/2 rise=2p fall=2p
_ie99993 (\~WriteData_0 0) d2a src="99993" val0=0.0 val1=vdd valx=vdd/2 rise=2p fall=2p
_ie99994 (net013_4 0) a2d dest="99994" vl=0.3*vdd vh=0.7*vdd timex=20n
_ie99995 (\~A_9 0) d2a src="99995" val0=0.0 val1=vdd valx=vdd/2 rise=2p fall=2p
_ie99996 (net013_3 0) a2d dest="99996" vl=0.3*vdd vh=0.7*vdd timex=20n
_ie99997 (net013_2 0) a2d dest="99997" vl=0.3*vdd vh=0.7*vdd timex=20n
_ie99998 (\~ReadData_7 0) a2d dest="99998" vl=0.3*vdd vh=0.7*vdd timex=20n
_ie99999 (\~RAck_5 0) d2a src="99999" val0=0.0 val1=vdd valx=vdd/2 rise=2p fall=2p
// END Hierarchical Interface Elements
ic IBank.I20.BpAck_3=vdd IBank.I20.BpAck_2=vdd IBank.I20.BpAck_1=vdd IBank.I20.BpAck_0=vdd IBank.I20.RAckp_3=0 IBank.I20.RAckp_2=0 IBank.I20.RAckp_1=0 IBank.I20.RAckp_0=0 IBank.I20.Rack_3=vdd IBank.I20.Rack_2=vdd IBank.I20.Rack_1=vdd IBank.I20.Rack_0=vdd IBank.G01=0 IBank.I20.R1p_3=0 IBank.I20.R1p_2=0 IBank.I20.R1p_1=0 IBank.I20.R1p_0=0 IBank.I20.R0p_3=0 IBank.I20.R0p_2=0 IBank.I20.R0p_1=0 IBank.I20.R0p_0=0 IBank.I20.R0_3=0 IBank.I20.R0_2=0 IBank.I20.R0_1=0 IBank.I20.R0_0=0 IBank.I20.R1_3=0 IBank.I20.R1_2=0 IBank.I20.R1_1=0 IBank.I20.R1_0=0 IBank.\~R0_1_3=vdd IBank.\~R0_1_2=vdd IBank.\~R0_1_1=vdd IBank.\~R0_1_0=vdd IBank.\~R1_1_3=vdd IBank.\~R1_1_2=vdd IBank.\~R1_1_1=vdd IBank.\~R1_1_0=vdd IBank.I20.net030=vdd IBank.ValAddr=0 WAck_1=vdd WAck_0=vdd IBank.I20.wack_3=vdd IBank.I20.wack_2=vdd IBank.I20.wack_1=vdd IBank.I20.wack_0=vdd IBank.I20.net052=vdd IBank.I20.net056=vdd IBank.I20.net053=vdd IBank.I20.net063=vdd IBank.I20.Wen=0 IBank.B0_1_3=0 IBank.B1_1_3=0 IBank.B0_1_2=0 IBank.B1_1_2=0 IBank.B0_1_1=0 IBank.B1_1_1=0 IBank.B0_1_0=0 IBank.B1_1_0=0 IBank.I20.B0p_3=0 IBank.I20.B1p_3=0 IBank.I20.B0p_2=0 IBank.I20.B1p_2=0 IBank.I20.B0p_1=0 IBank.I20.B1p_1=0 IBank.I20.B0p_0=0 IBank.I20.B1p_0=0 IBank.I20.nOr_7=0 IBank.I20.nOr_6=0 IBank.I20.nOr_5=0 IBank.I20.nOr_4=0 IBank.I20.nOr_3=0 IBank.I20.nOr_2=0 IBank.I20.nOr_1=0 IBank.I20.nOr_0=0 AckT=vdd net018_0=vdd net018_1=vdd net018_2=vdd net018_3=vdd net018_4=vdd RWT_1=0 RWT_0=0 IBank.I0.I0.I0.I7.I3.Q1=vdd IBank.I0.I0.I0.I7.I3.Q0=0 AT_19=0 AT_18=0 AT_17=0 AT_16=0 AT_15=0 AT_14=0 AT_13=0 AT_12=0 AT_11=0 AT_10=0 AT_9=0 AT_8=0 AT_7=0 AT_6=0 AT_5=0 AT_4=0 AT_3=0 AT_2=0 AT_1=0 AT_0=0 RAckT_7=vdd RAckT_6=vdd RAckT_5=vdd RAckT_4=vdd RAckT_3=vdd RAckT_2=vdd RAckT_1=vdd RAckT_0=vdd WriteDataT_31=0 WriteDataT_30=0 WriteDataT_29=0 WriteDataT_28=0 WriteDataT_27=0 WriteDataT_26=0 WriteDataT_25=0 WriteDataT_24=0 WriteDataT_23=0 WriteDataT_22=0 WriteDataT_21=0 WriteDataT_20=0 WriteDataT_19=0 WriteDataT_18=0 WriteDataT_17=0 WriteDataT_16=0 WriteDataT_15=0 WriteDataT_14=0 WriteDataT_13=0 WriteDataT_12=0 WriteDataT_11=0 WriteDataT_10=0 WriteDataT_9=0 WriteDataT_8=0 WriteDataT_7=0 WriteDataT_6=0 WriteDataT_5=0 WriteDataT_4=0 WriteDataT_3=0 WriteDataT_2=0 WriteDataT_1=0 WriteDataT_0=0
simulatorOptions options temp=30.0
tran tran stop=6n errpreset=conservative
save IBank.I20.I24:3 V0:p V0:p V1:p V1:p
