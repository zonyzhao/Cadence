// Design: 16nm_Tests/6T_BANK_Test
simulator lang=spectre
global 0 vdd! vcc!
parameters vdd=.7 vcc=vdd
include "/software/cadence/ncsu-FreePDK15/hspice_16nm_hp.include"

// 16nm/6T/schematic
//system verilogNetlist schematic cmos.sch cmos_sch veriloga ahdl
subckt _sub98 A B0 B1
    M5 (Q0 Q1 0 0) nfet w=60n l=20n nfin=1 m=1 degradation=no
    M4 (Q1 Q0 0 0) nfet w=60n l=20n nfin=1 m=1 degradation=no
    M1 (Q1 A B1 0) nfet w=120n l=20n nfin=2 m=1 degradation=no
    M0 (Q0 A B0 0) nfet w=120n l=20n nfin=2 m=1 degradation=no
    M3 (Q0 Q1 vdd! vdd!) pfet w=100n l=20n nfin=1 m=1 degradation=no
    M2 (Q1 Q0 vdd! vdd!) pfet w=100n l=20n nfin=1 m=1 degradation=no
ends _sub98

// 16nm/6T_4x/schematic
//system verilogNetlist schematic cmos.sch cmos_sch veriloga ahdl
subckt _sub99 A_3 A_2 A_1 A_0 B0 B1
    I3 (A_0 B0 B1) _sub98
    I2 (A_1 B0 B1) _sub98
    I1 (A_2 B0 B1) _sub98
    I0 (A_3 B0 B1) _sub98
ends _sub99

// 16nm/6T_32x/schematic
//system verilogNetlist schematic cmos.sch cmos_sch veriloga ahdl
subckt _sub100 B0 B1 A_31 A_30 A_29 A_28 A_27 A_26 A_25 A_24 A_23 A_22 A_21 A_20 A_19 A_18 A_17 A_16 A_15 A_14 A_13 A_12 A_11 A_10 A_9 A_8 A_7 A_6 A_5 A_4 A_3 A_2 A_1 A_0
    I7 (A_3 A_2 A_1 A_0 B0 B1) _sub99
    I6 (A_7 A_6 A_5 A_4 B0 B1) _sub99
    I5 (A_11 A_10 A_9 A_8 B0 B1) _sub99
    I4 (A_15 A_14 A_13 A_12 B0 B1) _sub99
    I3 (A_19 A_18 A_17 A_16 B0 B1) _sub99
    I2 (A_23 A_22 A_21 A_20 B0 B1) _sub99
    I1 (A_27 A_26 A_25 A_24 B0 B1) _sub99
    I0 (A_31 A_30 A_29 A_28 B0 B1) _sub99
ends _sub100

// 16nm/6T_32x_CTRL/schematic
//system verilogNetlist schematic cmos.sch cmos_sch veriloga ahdl
subckt _sub101 B0 B1 S W0 W1
    M10 (B1 B0 net22 vdd!) pfet w=100n l=20n nfin=1 m=1 degradation=no
    M9 (net22 W1 vdd! vdd!) pfet w=100n l=20n nfin=1 m=1 degradation=no
    M8 (B0 B1 net23 vdd!) pfet w=100n l=20n nfin=1 m=1 degradation=no
    M7 (net23 W0 vdd! vdd!) pfet w=100n l=20n nfin=1 m=1 degradation=no
    M2 (B1 S vdd! vdd!) pfet w=100n l=20n nfin=1 m=1 degradation=no
    M0 (B0 S vdd! vdd!) pfet w=100n l=20n nfin=1 m=1 degradation=no
    M6 (B1 W1 net24 0) nfet w=60n l=20n nfin=1 m=1 degradation=no
    M5 (net24 S 0 0) nfet w=60n l=20n nfin=1 m=1 degradation=no
    M4 (net25 S 0 0) nfet w=60n l=20n nfin=1 m=1 degradation=no
    M3 (B0 W0 net25 0) nfet w=60n l=20n nfin=1 m=1 degradation=no
ends _sub101

// 16nm/nand4_1x/schematic
//system verilogNetlist schematic cmos.sch cmos_sch veriloga ahdl
subckt nand4_1x A B C D Y
    M5 (Y D vdd! vdd!) pfet w=100n l=20n nfin=1 m=1 degradation=no
    M4 (Y C vdd! vdd!) pfet w=100n l=20n nfin=1 m=1 degradation=no
    M1 (Y B vdd! vdd!) pfet w=100n l=20n nfin=1 m=1 degradation=no
    M0 (Y A vdd! vdd!) pfet w=100n l=20n nfin=1 m=1 degradation=no
    M7 (net23 D 0 0) nfet w=240n l=20n nfin=1 m=1 degradation=no
    M6 (net25 C net23 0) nfet w=240n l=20n nfin=1 m=1 degradation=no
    M3 (net24 B net25 0) nfet w=240n l=20n nfin=1 m=1 degradation=no
    M2 (Y A net24 0) nfet w=240n l=20n nfin=1 m=1 degradation=no
ends nand4_1x

// 16nm/6T_32x4/schematic
//system verilogNetlist schematic cmos.sch cmos_sch veriloga ahdl
subckt _sub102 A_31 A_30 A_29 A_28 A_27 A_26 A_25 A_24 A_23 A_22 A_21 A_20 A_19 A_18 A_17 A_16 A_15 A_14 A_13 A_12 A_11 A_10 A_9 A_8 A_7 A_6 A_5 A_4 A_3 A_2 A_1 A_0 B0 B1 S_3 S_2 S_1 S_0 W0 W1 SM1 SM0
    ISRAM3 (B0P4 B1P4 A_31 A_30 A_29 A_28 A_27 A_26 A_25 A_24 A_23 A_22 A_21 A_20 A_19 A_18 A_17 A_16 A_15 A_14 A_13 A_12 A_11 A_10 A_9 A_8 A_7 A_6 A_5 A_4 A_3 A_2 A_1 A_0) _sub100
    ISRAM1 (B0P2 B1P2 A_31 A_30 A_29 A_28 A_27 A_26 A_25 A_24 A_23 A_22 A_21 A_20 A_19 A_18 A_17 A_16 A_15 A_14 A_13 A_12 A_11 A_10 A_9 A_8 A_7 A_6 A_5 A_4 A_3 A_2 A_1 A_0) _sub100
    ISRAM2 (B0P3 B1P3 A_31 A_30 A_29 A_28 A_27 A_26 A_25 A_24 A_23 A_22 A_21 A_20 A_19 A_18 A_17 A_16 A_15 A_14 A_13 A_12 A_11 A_10 A_9 A_8 A_7 A_6 A_5 A_4 A_3 A_2 A_1 A_0) _sub100
    ISRAM0 (B0P1 B1P1 A_31 A_30 A_29 A_28 A_27 A_26 A_25 A_24 A_23 A_22 A_21 A_20 A_19 A_18 A_17 A_16 A_15 A_14 A_13 A_12 A_11 A_10 A_9 A_8 A_7 A_6 A_5 A_4 A_3 A_2 A_1 A_0) _sub100
    M1 (B0P1 B0 net67 0) nfet w=60n l=20n nfin=1 m=1 degradation=no
    M0 (net67 S_0 0 0) nfet w=60n l=20n nfin=1 m=1 degradation=no
    M3 (net66 S_0 0 0) nfet w=60n l=20n nfin=1 m=1 degradation=no
    M10 (B1P2 B1 net65 0) nfet w=60n l=20n nfin=1 m=1 degradation=no
    M9 (net65 S_1 0 0) nfet w=60n l=20n nfin=1 m=1 degradation=no
    M6 (net64 S_1 0 0) nfet w=60n l=20n nfin=1 m=1 degradation=no
    M7 (B0P2 B0 net64 0) nfet w=60n l=20n nfin=1 m=1 degradation=no
    M13 (B0P3 B0 net63 0) nfet w=60n l=20n nfin=1 m=1 degradation=no
    M12 (net63 S_2 0 0) nfet w=60n l=20n nfin=1 m=1 degradation=no
    M15 (net62 S_2 0 0) nfet w=60n l=20n nfin=1 m=1 degradation=no
    M16 (B1P3 B1 net62 0) nfet w=60n l=20n nfin=1 m=1 degradation=no
    M22 (B1P4 B1 net61 0) nfet w=60n l=20n nfin=1 m=1 degradation=no
    M21 (net61 S_3 0 0) nfet w=60n l=20n nfin=1 m=1 degradation=no
    M18 (net60 S_3 0 0) nfet w=60n l=20n nfin=1 m=1 degradation=no
    M19 (B0P4 B0 net60 0) nfet w=60n l=20n nfin=1 m=1 degradation=no
    M4 (B1P1 B1 net66 0) nfet w=60n l=20n nfin=1 m=1 degradation=no
    I4 (B0P1 B1P1 S_0 W0 W1) _sub101
    I11 (B0P2 B1P2 S_1 W0 W1) _sub101
    I20 (B0P3 B1P3 S_2 W0 W1) _sub101
    I27 (B0P4 B1P4 S_3 W0 W1) _sub101
    I16 (B1P1 B1P2 B1P3 B1P4 SM1) nand4_1x
    I13 (B0P1 B0P2 B0P3 B0P4 SM0) nand4_1x
    C7 (B1P4 0) capacitor c=1.2822f m=1
    C3 (B1P2 0) capacitor c=1.2822f m=1
    C5 (B1P3 0) capacitor c=1.2822f m=1
    C6 (B0P4 0) capacitor c=1.2822f m=1
    C4 (B0P3 0) capacitor c=1.2822f m=1
    C2 (B0P2 0) capacitor c=1.2822f m=1
    C1 (B1P1 0) capacitor c=1.2822f m=1
    C0 (B0P1 0) capacitor c=1.2822f m=1
    M5 (B1P1 S_0 vdd! vdd!) pfet w=100n l=20n nfin=1 m=1 degradation=no
    M2 (B0P1 S_0 vdd! vdd!) pfet w=100n l=20n nfin=1 m=1 degradation=no
    M11 (B1P2 S_1 vdd! vdd!) pfet w=100n l=20n nfin=1 m=1 degradation=no
    M8 (B0P2 S_1 vdd! vdd!) pfet w=100n l=20n nfin=1 m=1 degradation=no
    M17 (B1P3 S_2 vdd! vdd!) pfet w=100n l=20n nfin=1 m=1 degradation=no
    M14 (B0P3 S_2 vdd! vdd!) pfet w=100n l=20n nfin=1 m=1 degradation=no
    M20 (B0P4 S_3 vdd! vdd!) pfet w=100n l=20n nfin=1 m=1 degradation=no
    M23 (B1P4 S_3 vdd! vdd!) pfet w=100n l=20n nfin=1 m=1 degradation=no
ends _sub102

// 16nm/6T_SetRead/schematic
//system verilogNetlist schematic cmos.sch cmos_sch veriloga ahdl
subckt _sub103 \~R0 \~R1 Go SM0_0 SM0_1 SM1_0 SM1_1
    M5 (\~R0 SM0_0 net18 0) nfet w=60n l=20n nfin=1 m=1 degradation=no
    M3 (\~R0 SM0_1 net18 0) nfet w=60n l=20n nfin=1 m=1 degradation=no
    M2 (net18 Go 0 0) nfet w=120n l=20n nfin=2 m=1 degradation=no
    M1 (\~R1 SM1_1 net18 0) nfet w=60n l=20n nfin=1 m=1 degradation=no
    M0 (\~R1 SM1_0 net18 0) nfet w=60n l=20n nfin=1 m=1 degradation=no
ends _sub103

// 16nm/6T_CHUNK/schematic
//system verilogNetlist schematic cmos.sch cmos_sch veriloga ahdl
subckt _sub104 \~R0_3 \~R0_2 \~R0_1 \~R0_0 \~R1_3 \~R1_2 \~R1_1 \~R1_0 A_63 A_62 A_61 A_60 A_59 A_58 A_57 A_56 A_55 A_54 A_53 A_52 A_51 A_50 A_49 A_48 A_47 A_46 A_45 A_44 A_43 A_42 A_41 A_40 A_39 A_38 A_37 A_36 A_35 A_34 A_33 A_32 A_31 A_30 A_29 A_28 A_27 A_26 A_25 A_24 A_23 A_22 A_21 A_20 A_19 A_18 A_17 A_16 A_15 A_14 A_13 A_12 A_11 A_10 A_9 A_8 A_7 A_6 A_5 A_4 A_3 A_2 A_1 A_0 B0_3 B0_2 B0_1 B0_0 B1_3 B1_2 B1_1 B1_0 S_7 S_6 S_5 S_4 S_3 S_2 S_1 S_0 W0_3 W0_2 W0_1 W0_0 W1_3 W1_2 W1_1 W1_0 Go
    IARRAY7 (A_63 A_62 A_61 A_60 A_59 A_58 A_57 A_56 A_55 A_54 A_53 A_52 A_51 A_50 A_49 A_48 A_47 A_46 A_45 A_44 A_43 A_42 A_41 A_40 A_39 A_38 A_37 A_36 A_35 A_34 A_33 A_32 B0_3 B1_3 S_7 S_6 S_5 S_4 W0_3 W1_3 SM1_1_bit3 SM0_1_bit3) _sub102
    IARRAY6 (A_63 A_62 A_61 A_60 A_59 A_58 A_57 A_56 A_55 A_54 A_53 A_52 A_51 A_50 A_49 A_48 A_47 A_46 A_45 A_44 A_43 A_42 A_41 A_40 A_39 A_38 A_37 A_36 A_35 A_34 A_33 A_32 B0_2 B1_2 S_7 S_6 S_5 S_4 W0_2 W1_2 SM1_1_bit2 SM0_1_bit2) _sub102
    IARRAY5 (A_63 A_62 A_61 A_60 A_59 A_58 A_57 A_56 A_55 A_54 A_53 A_52 A_51 A_50 A_49 A_48 A_47 A_46 A_45 A_44 A_43 A_42 A_41 A_40 A_39 A_38 A_37 A_36 A_35 A_34 A_33 A_32 B0_1 B1_1 S_7 S_6 S_5 S_4 W0_1 W1_1 SM1_1_bit1 SM0_1_bit1) _sub102
    IARRAY4 (A_63 A_62 A_61 A_60 A_59 A_58 A_57 A_56 A_55 A_54 A_53 A_52 A_51 A_50 A_49 A_48 A_47 A_46 A_45 A_44 A_43 A_42 A_41 A_40 A_39 A_38 A_37 A_36 A_35 A_34 A_33 A_32 B0_0 B1_0 S_7 S_6 S_5 S_4 W0_0 W1_0 SM1_1_bit0 SM0_1_bit0) _sub102
    IARRAY3 (A_31 A_30 A_29 A_28 A_27 A_26 A_25 A_24 A_23 A_22 A_21 A_20 A_19 A_18 A_17 A_16 A_15 A_14 A_13 A_12 A_11 A_10 A_9 A_8 A_7 A_6 A_5 A_4 A_3 A_2 A_1 A_0 B0_3 B1_3 S_3 S_2 S_1 S_0 W0_3 W1_3 SM1_0_bit3 SM0_0_bit3) _sub102
    IARRAY2 (A_31 A_30 A_29 A_28 A_27 A_26 A_25 A_24 A_23 A_22 A_21 A_20 A_19 A_18 A_17 A_16 A_15 A_14 A_13 A_12 A_11 A_10 A_9 A_8 A_7 A_6 A_5 A_4 A_3 A_2 A_1 A_0 B0_2 B1_2 S_3 S_2 S_1 S_0 W0_2 W1_2 SM1_0_bit2 SM0_0_bit2) _sub102
    IARRAY1 (A_31 A_30 A_29 A_28 A_27 A_26 A_25 A_24 A_23 A_22 A_21 A_20 A_19 A_18 A_17 A_16 A_15 A_14 A_13 A_12 A_11 A_10 A_9 A_8 A_7 A_6 A_5 A_4 A_3 A_2 A_1 A_0 B0_1 B1_1 S_3 S_2 S_1 S_0 W0_1 W1_1 SM1_0_bit1 SM0_0_bit1) _sub102
    IARRAY0 (A_31 A_30 A_29 A_28 A_27 A_26 A_25 A_24 A_23 A_22 A_21 A_20 A_19 A_18 A_17 A_16 A_15 A_14 A_13 A_12 A_11 A_10 A_9 A_8 A_7 A_6 A_5 A_4 A_3 A_2 A_1 A_0 B0_0 B1_0 S_3 S_2 S_1 S_0 W0_0 W1_0 SM1_0_bit0 SM0_0_bit0) _sub102
    I7 (\~R0_3 \~R1_3 Go SM0_0_bit3 SM0_1_bit3 SM1_0_bit3 SM1_1_bit3) _sub103
    I6 (\~R0_2 \~R1_2 Go SM0_0_bit2 SM0_1_bit2 SM1_0_bit2 SM1_1_bit2) _sub103
    I5 (\~R0_1 \~R1_1 Go SM0_0_bit1 SM0_1_bit1 SM1_0_bit1 SM1_1_bit1) _sub103
    I4 (\~R0_0 \~R1_0 Go SM0_0_bit0 SM0_1_bit0 SM1_0_bit0 SM1_1_bit0) _sub103
ends _sub104

// 16nm/inv_1x/schematic
//system verilogNetlist schematic cmos.sch cmos_sch veriloga ahdl
subckt inv_1x A Y
    M0 (Y A 0 0) nfet w=60n l=20n nfin=1 m=1 degradation=no
    M1 (Y A vdd! vdd!) pfet w=100n l=20n nfin=1 m=1 degradation=no
ends inv_1x

// 16nm/nand_1x/schematic
//system verilogNetlist schematic cmos.sch cmos_sch veriloga ahdl
subckt nand_1x A B Y
    M1 (Y B vdd! vdd!) pfet w=100n l=20n nfin=1 m=1 degradation=no
    M0 (Y A vdd! vdd!) pfet w=100n l=20n nfin=1 m=1 degradation=no
    M3 (net22 B 0 0) nfet w=120n l=20n nfin=1 m=1 degradation=no
    M2 (Y A net22 0) nfet w=120n l=20n nfin=1 m=1 degradation=no
ends nand_1x

// 16nm/nor_1x/schematic
//system verilogNetlist schematic cmos.sch cmos_sch veriloga ahdl
subckt nor_1x A B Y
    M3 (Y B or_pd_ps vdd!) pfet w=200n l=20n nfin=1 m=1 degradation=no
    M2 (or_pd_ps A vdd! vdd!) pfet w=200n l=20n nfin=1 m=1 degradation=no
    M1 (Y B 0 0) nfet w=60n l=20n nfin=1 m=1 degradation=no
    M0 (Y A 0 0) nfet w=60n l=20n nfin=1 m=1 degradation=no
ends nor_1x

// 16nm/or_1x/schematic
//system verilogNetlist schematic cmos.sch cmos_sch veriloga ahdl
subckt or_1x A B Y
    I6 (A B AnorB) nor_1x
    I7 (AnorB Y) inv_1x
ends or_1x

// 16nm/inv_weak_1x/schematic
//system verilogNetlist schematic cmos.sch cmos_sch veriloga ahdl
subckt inv_weak_1x A Y
    M2 (net13 vdd! 0 0) nfet w=60n l=20n nfin=1 ls=105n m=1 degradation=no
    M0 (Y A net13 0) nfet w=60n l=20n nfin=1 ls=105n m=1 degradation=no
    M3 (net14 0 vdd! vdd!) pfet w=100n l=20n nfin=1 m=1 degradation=no
    M1 (Y A net14 vdd!) pfet w=100n l=20n nfin=1 m=1 degradation=no
ends inv_weak_1x

// 16nm/TH22/schematic
//system verilogNetlist schematic cmos.sch cmos_sch veriloga ahdl
subckt TH22 A B Y
    M5 (Y net5 0 0) nfet w=60n l=20n nfin=1 m=1 degradation=no
    M4 (net5 Y net9 0) nfet w=120n l=20n nfin=1 m=1 degradation=no
    M3 (net9 B 0 0) nfet w=120n l=20n nfin=1 m=1 degradation=no
    M2 (net9 A 0 0) nfet w=120n l=20n nfin=1 m=1 degradation=no
    M1 (net5 B net17 0) nfet w=120n l=20n nfin=1 m=1 degradation=no
    M0 (net17 A 0 0) nfet w=120n l=20n nfin=1 m=1 degradation=no
    M11 (Y net5 vdd! vdd!) pfet w=100n l=20n nfin=1 m=1 degradation=no
    M10 (net5 B net032 vdd!) pfet w=200n l=20n nfin=1 m=1 degradation=no
    M9 (net032 A vdd! vdd!) pfet w=200n l=20n nfin=1 m=1 degradation=no
    M8 (net037 B vdd! vdd!) pfet w=200n l=20n nfin=1 m=1 degradation=no
    M7 (net037 A vdd! vdd!) pfet w=200n l=20n nfin=1 m=1 degradation=no
    M6 (net5 Y net037 vdd!) pfet w=200n l=20n nfin=1 m=1 degradation=no
ends TH22

// 16nm/PCHBd/schematic
//system verilogNetlist schematic cmos.sch cmos_sch veriloga ahdl
subckt PCHBd R0i\+1 R1i\+1 Ai R0i R1i Ai\+1
    I32 (\~R0 R0i\+1) inv_1x
    I5 (\~R1 R1i\+1) inv_1x
    I35 (Ai \~ack) inv_1x
    M16 (\~R0 R0i net034 0) nfet w=60n l=20n nfin=1 m=1 degradation=no
    M3 (\~R1 R1i net033 0) nfet w=60n l=20n nfin=1 m=1 degradation=no
    M4 (net034 oE 0 0) nfet w=60n l=20n nfin=1 m=1 degradation=no
    M5 (net033 oE 0 0) nfet w=60n l=20n nfin=1 m=1 degradation=no
    M10 (\~R0 oE vdd! vdd!) pfet w=200n l=20n nfin=1 m=1 degradation=no
    M1 (\~R1 oE vdd! vdd!) pfet w=200n l=20n nfin=1 m=1 degradation=no
    I6 (\~R1 \~R0 outValid) nand_1x
    I9 (R0i R1i inValid) or_1x
    I2 (R0i\+1 \~R0) inv_weak_1x
    I33 (R1i\+1 \~R1) inv_weak_1x
    I12 (outValid inValid Ai) TH22
    I30 (\~ack Ai\+1 oE) TH22
ends PCHBd

// 16nm/THaC/schematic
//system verilogNetlist schematic cmos.sch cmos_sch veriloga ahdl
subckt THaC A Y C\- B\+
    M8 (net11 A 0 A) nfet w=120n l=20n nfin=1 m=1 degradation=no
    M5 (net7 A net33 A) nfet w=120n l=20n nfin=1 m=1 degradation=no
    M6 (net7 Y net11 Y) nfet w=120n l=20n nfin=1 m=1 degradation=no
    M9 (net11 C\- 0 C\-) nfet w=120n l=20n nfin=1 m=1 degradation=no
    M7 (net33 \~B\+ 0 \~B\+) nfet w=120n l=20n nfin=1 m=1 degradation=no
    I2 (net7 Y) inv_1x
    I9 (B\+ \~B\+) inv_1x
    M4 (net7 Y net17 Y) pfet w=100n l=20n nfin=1 m=1 degradation=no
    M3 (net7 C\- net32 C\-) pfet w=100n l=20n nfin=1 m=1 degradation=no
    M0 (net32 A vdd! A) pfet w=100n l=20n nfin=1 m=1 degradation=no
    M2 (net17 \~B\+ vdd! \~B\+) pfet w=100n l=20n nfin=1 m=1 degradation=no
    M1 (net17 A vdd! A) pfet w=100n l=20n nfin=1 m=1 degradation=no
ends THaC

// 16nm/PCHB_Write/schematic
//system verilogNetlist schematic cmos.sch cmos_sch veriloga ahdl
subckt PCHB_Write B0 B1 outAck R0i R1i W0 W1
    I34 (outAck net027) inv_1x
    I5 (net029 B1) inv_1x
    I4 (net18 B0) inv_1x
    I12 (inValid outAck outValid inAck) THaC
    M5 (net026 oE 0 0) nfet w=60n l=20n nfin=1 m=1 degradation=no
    M4 (net22 oE 0 0) nfet w=60n l=20n nfin=1 m=1 degradation=no
    M3 (net029 R1i net026 0) nfet w=60n l=20n nfin=1 m=1 degradation=no
    M2 (net18 R0i net22 0) nfet w=60n l=20n nfin=1 m=1 degradation=no
    M1 (net029 oE vdd! vdd!) pfet w=200n l=20n nfin=1 m=1 degradation=no
    M0 (net18 oE vdd! vdd!) pfet w=200n l=20n nfin=1 m=1 degradation=no
    I6 (net029 net18 outValid) nand_1x
    I9 (R0i R1i inValid) or_1x
    I2 (B0 net18) inv_weak_1x
    I3 (B1 net029) inv_weak_1x
    I11 (net027 inAck oE) TH22
    I31 (W1 W0 inAck) nor_1x
ends PCHB_Write

// 16nm/and_1x/schematic
//system verilogNetlist schematic cmos.sch cmos_sch veriloga ahdl
subckt and_1x A B Y
    I7 (A B ntYbar) nand_1x
    I6 (ntYbar Y) inv_1x
ends and_1x

// 16nm/and4_1x/schematic
//system verilogNetlist schematic cmos.sch cmos_sch veriloga ahdl
subckt and4_1x A B C D Y
    I15 (A B C D net1) nand4_1x
    I16 (net1 Y) inv_1x
ends and4_1x

// 16nm/WCHB_Read/schematic
//system verilogNetlist schematic cmos.sch cmos_sch veriloga ahdl
subckt WCHB_Read Lack_1 Lack_0 L0_1 L0_0 L1_1 L1_0 Rack Out_3 Out_2 Out_1 Out_0
    I23 (n0_1 n1_1 Lack_1) nor_1x
    I12 (n0_0 n1_0 Lack_0) nor_1x
    I34 (\~Out_0 \~Out_1 \~Out_2 \~Out_3 outAck) and4_1x
    I29 (n0_0 n1_1 m_2) nand_1x
    I26 (n1_0 n1_1 m_3) nand_1x
    I25 (n1_0 n0_1 m_1) nand_1x
    I24 (n0_0 n0_1 m_0) nand_1x
    I28 (Rack m_2 \~Out_2) TH22
    I27 (Rack m_3 \~Out_3) TH22
    I0 (L0_0 outAck n0_0) TH22
    I7 (Rack m_0 \~Out_0) TH22
    I1 (L1_0 outAck n1_0) TH22
    I21 (L0_1 outAck n0_1) TH22
    I6 (Rack m_1 \~Out_1) TH22
    I22 (L1_1 outAck n1_1) TH22
    I42 (\~Out_3 Out_3) inv_1x
    I41 (\~Out_2 Out_2) inv_1x
    I39 (\~Out_0 Out_0) inv_1x
    I40 (\~Out_1 Out_1) inv_1x
ends WCHB_Read

// 16nm/TH44~/schematic
//system verilogNetlist schematic cmos.sch cmos_sch veriloga ahdl
subckt _sub105 A B C D Y
    M19 (net13 A 0 0) nfet w=80n l=16n nfin=1 m=1 degradation=no
    M18 (net13 B 0 0) nfet w=80n l=16n nfin=1 m=1 degradation=no
    M17 (net13 C 0 0) nfet w=80n l=16n nfin=1 m=1 degradation=no
    M16 (net13 D 0 0) nfet w=80n l=16n nfin=1 m=1 degradation=no
    M15 (net011 net19 0 0) nfet w=40n l=16n nfin=1 m=1 degradation=no
    M14 (net42 A 0 0) nfet w=160n l=16n nfin=1 m=1 degradation=no
    M13 (net43 B net42 0) nfet w=160n l=16n nfin=1 m=1 degradation=no
    M12 (net44 C net43 0) nfet w=160n l=16n nfin=1 m=1 degradation=no
    M11 (net19 D net44 0) nfet w=160n l=16n nfin=1 m=1 degradation=no
    M10 (net19 net011 net13 0) nfet w=80n l=16n nfin=1 m=1 degradation=no
    I6 (net011 Y) inv_1x
    M9 (net011 net19 vdd! vdd!) pfet w=80n l=16n nfin=1 m=1 degradation=no
    M8 (net19 net011 net15 vdd!) pfet w=160n l=16n nfin=1 m=1 degradation=no
    M7 (net15 D vdd! vdd!) pfet w=160n l=16n nfin=1 m=1 degradation=no
    M6 (net15 C vdd! vdd!) pfet w=160n l=16n nfin=1 m=1 degradation=no
    M5 (net15 B vdd! vdd!) pfet w=160n l=16n nfin=1 m=1 degradation=no
    M4 (net15 A vdd! vdd!) pfet w=160n l=16n nfin=1 m=1 degradation=no
    M3 (net19 D net45 vdd!) pfet w=320n l=16n nfin=1 m=1 degradation=no
    M2 (net45 C net46 vdd!) pfet w=320n l=16n nfin=1 m=1 degradation=no
    M1 (net46 B net47 vdd!) pfet w=320n l=16n nfin=1 m=1 degradation=no
    M0 (net47 A vdd! vdd!) pfet w=320n l=16n nfin=1 m=1 degradation=no
ends _sub105

// 16nm/nor4_1x/schematic
//system verilogNetlist schematic cmos.sch cmos_sch veriloga ahdl
subckt nor4_1x A B C D Y
    M5 (net017 C net21 vdd!) pfet w=400n l=20n nfin=1 m=1 degradation=no
    M4 (Y D net017 vdd!) pfet w=400n l=20n nfin=1 m=1 degradation=no
    M3 (net21 B net018 vdd!) pfet w=400n l=20n nfin=1 m=1 degradation=no
    M2 (net018 A vdd! vdd!) pfet w=400n l=20n nfin=1 m=1 degradation=no
    M7 (Y D 0 0) nfet w=60n l=20n nfin=1 m=1 degradation=no
    M6 (Y C 0 0) nfet w=60n l=20n nfin=1 m=1 degradation=no
    M1 (Y A 0 0) nfet w=60n l=20n nfin=1 m=1 degradation=no
    M0 (Y B 0 0) nfet w=60n l=20n nfin=1 m=1 degradation=no
ends nor4_1x

// 16nm/or4_1x/schematic
//system verilogNetlist schematic cmos.sch cmos_sch veriloga ahdl
subckt or4_1x A B C D Y
    I0 (A B C D net11) nor4_1x
    I1 (net11 Y) inv_1x
ends or4_1x

// 16nm/WCHB_Write/schematic
//system verilogNetlist schematic cmos.sch cmos_sch veriloga ahdl
subckt WCHB_Write Lack In_3 In_2 In_1 In_0 Rack_1 Rack_0 Out1_1 Out1_0 Out0_1 Out0_0
    I26 (b1_1 Rack_1 \~Out1_1) TH22
    I7 (b1_0 Rack_0 \~Out1_0) TH22
    I24 (b0_1 Rack_1 \~Out0_1) TH22
    I6 (b0_0 Rack_0 \~Out0_0) TH22
    I3 (In_3 nxa n_3) TH22
    I2 (In_2 nxa n_2) TH22
    I1 (In_1 nxa n_1) TH22
    I0 (In_0 nxa n_0) TH22
    I30 (\~Out1_1 Out1_1) inv_1x
    I29 (\~Out0_0 Out0_0) inv_1x
    I31 (\~Out0_1 Out0_1) inv_1x
    I28 (\~Out1_0 Out1_0) inv_1x
    I12 (n_0 n_1 n_2 n_3 Lack) or4_1x
    I19 (n_3 n_1 b1_0) nor_1x
    I22 (n_2 n_3 b1_1) nor_1x
    I21 (n_0 n_1 b0_1) nor_1x
    I20 (n_0 n_2 b0_0) nor_1x
    I27 (\~Out1_0 \~Out0_0 \~Out1_1 \~Out0_1 nxa) and4_1x
ends WCHB_Write

// 16nm/6T_DATAb/schematic
//system verilogNetlist schematic cmos.sch cmos_sch veriloga ahdl
subckt _sub106 Ack B0_3 B0_2 B0_1 B0_0 B1_3 B1_2 B1_1 B1_0 Go W0_3 W0_2 W0_1 W0_0 W1_3 W1_2 W1_1 W1_0 RW_1 RW_0 Reset ValAddr Read_1of4_3 Read_1of4_2 Read_1of4_1 Read_1of4_0 Read_1of4_7 Read_1of4_6 Read_1of4_5 Read_1of4_4 W1_1of4_3 W1_1of4_2 W1_1of4_1 W1_1of4_0 W2_1of4_3 W2_1of4_2 W2_1of4_1 W2_1of4_0 \~R1_3 \~R1_2 \~R1_1 \~R1_0 \~R0_3 \~R0_2 \~R0_1 \~R0_0 AckThruTop AckThruBot WdataAck_1 WdataAck_0 RdataAck_1 RdataAck_0
    IRPCHB_3 (R0q_3 R1q_3 Lack_3 R0_3 R1_3 RpAck_3) PCHBd
    IRPCHB_2 (R0q_2 R1q_2 Lack_2 R0_2 R1_2 RpAck_2) PCHBd
    IRPCHB_1 (R0q_1 R1q_1 Lack_1 R0_1 R1_1 RpAck_1) PCHBd
    IRPCHB_0 (R0q_0 R1q_0 Lack_0 R0_0 R1_0 RpAck_0) PCHBd
    I8 (intRack intWack Ack) nand_1x
    IWPCHB0_1 (B0_1 B1_1 wack_1 nB0_1 nB1_1 W0_1 W1_1) PCHB_Write
    IWPCHB0_0 (B0_0 B1_0 wack_0 nB0_0 nB1_0 W0_0 W1_0) PCHB_Write
    IWPCHB1_1 (B0_3 B1_3 wack_3 nB0_3 nB1_3 W0_3 W1_3) PCHB_Write
    IWPCHB1_0 (B0_2 B1_2 wack_2 nB0_2 nB1_2 W0_2 W1_2) PCHB_Write
    I13_3 (Wen B0_3 W0_3) and_1x
    I13_2 (Wen B0_2 W0_2) and_1x
    I13_1 (Wen B0_1 W0_1) and_1x
    I13_0 (Wen B0_0 W0_0) and_1x
    I11_3 (Wen B1_3 W1_3) and_1x
    I11_2 (Wen B1_2 W1_2) and_1x
    I11_1 (Wen B1_1 W1_1) and_1x
    I11_0 (Wen B1_0 W1_0) and_1x
    M0_3 (\~R1_3 Go vdd! vdd!) pfet w=100n l=20n nfin=1 m=1 degradation=no
    M0_2 (\~R1_2 Go vdd! vdd!) pfet w=100n l=20n nfin=1 m=1 degradation=no
    M0_1 (\~R1_1 Go vdd! vdd!) pfet w=100n l=20n nfin=1 m=1 degradation=no
    M0_0 (\~R1_0 Go vdd! vdd!) pfet w=100n l=20n nfin=1 m=1 degradation=no
    M1_3 (\~R0_3 Go vdd! vdd!) pfet w=100n l=20n nfin=1 m=1 degradation=no
    M1_2 (\~R0_2 Go vdd! vdd!) pfet w=100n l=20n nfin=1 m=1 degradation=no
    M1_1 (\~R0_1 Go vdd! vdd!) pfet w=100n l=20n nfin=1 m=1 degradation=no
    M1_0 (\~R0_0 Go vdd! vdd!) pfet w=100n l=20n nfin=1 m=1 degradation=no
    I4_3 (\~R1_3 R1_3) inv_1x
    I4_2 (\~R1_2 R1_2) inv_1x
    I4_1 (\~R1_1 R1_1) inv_1x
    I4_0 (\~R1_0 R1_0) inv_1x
    I6_3 (\~R0_3 R0_3) inv_1x
    I6_2 (\~R0_2 R0_2) inv_1x
    I6_1 (\~R0_1 R0_1) inv_1x
    I6_0 (\~R0_0 R0_0) inv_1x
    I1 (AckThruBot AckThruTop) iprobe
    I9 (ValAddr RW_0 Wen) TH22
    I7 (ValAddr RW_1 Go) TH22
    IRWCHB_1 (RpAck_3 RpAck_2 R0q_3 R0q_2 R1q_3 R1q_2 RdataAck_1 Read_1of4_7 Read_1of4_6 Read_1of4_5 Read_1of4_4) WCHB_Read
    IRWCHB_0 (RpAck_1 RpAck_0 R0q_1 R0q_0 R1q_1 R1q_0 RdataAck_0 Read_1of4_3 Read_1of4_2 Read_1of4_1 Read_1of4_0) WCHB_Read
    I16 (wack_0 wack_2 wack_3 wack_1 intWack) _sub105
    I0 (Lack_3 Lack_2 Lack_1 Lack_0 intRack) _sub105
    IWWCHB1 (WdataAck_1 W2_1of4_3 W2_1of4_2 W2_1of4_1 W2_1of4_0 wack_3 wack_2 nB1_3 nB1_2 nB0_3 nB0_2) WCHB_Write
    IWWCHB0 (WdataAck_0 W1_1of4_3 W1_1of4_2 W1_1of4_1 W1_1of4_0 wack_1 wack_0 nB1_1 nB1_0 nB0_1 nB0_0) WCHB_Write
ends _sub106

// 16nm/TH44/schematic
//system verilogNetlist schematic cmos.sch cmos_sch veriloga ahdl
subckt TH44 A B C D Y
    M19 (net13 A 0 0) nfet w=120n l=20n nfin=1 m=1 degradation=no
    M18 (net13 B 0 0) nfet w=120n l=20n nfin=1 m=1 degradation=no
    M17 (net13 C 0 0) nfet w=120n l=20n nfin=1 m=1 degradation=no
    M16 (net13 D 0 0) nfet w=120n l=20n nfin=1 m=1 degradation=no
    M15 (Y net19 0 0) nfet w=60n l=20n nfin=1 m=1 degradation=no
    M14 (net42 A 0 0) nfet w=240n l=20n nfin=1 m=1 degradation=no
    M13 (net43 B net42 0) nfet w=240n l=20n nfin=1 m=1 degradation=no
    M12 (net44 C net43 0) nfet w=240n l=20n nfin=1 m=1 degradation=no
    M11 (net19 D net44 0) nfet w=240n l=20n nfin=1 m=1 degradation=no
    M10 (net19 Y net13 0) nfet w=120n l=20n nfin=1 m=1 degradation=no
    M9 (Y net19 vdd! vdd!) pfet w=100n l=20n nfin=1 m=1 degradation=no
    M8 (net19 Y net15 vdd!) pfet w=200n l=20n nfin=1 m=1 degradation=yes
    M7 (net15 D vdd! vdd!) pfet w=200n l=20n nfin=1 m=1 degradation=no
    M6 (net15 C vdd! vdd!) pfet w=200n l=20n nfin=1 m=1 degradation=no
    M5 (net15 B vdd! vdd!) pfet w=200n l=20n nfin=1 m=1 degradation=no
    M4 (net15 A vdd! vdd!) pfet w=200n l=20n nfin=1 m=1 degradation=yes
    M3 (net19 D net45 vdd!) pfet w=320n l=20n nfin=1 m=1 degradation=no
    M2 (net45 C net46 vdd!) pfet w=320n l=20n nfin=1 m=1 degradation=no
    M1 (net46 B net47 vdd!) pfet w=320n l=20n nfin=1 m=1 degradation=no
    M0 (net47 A vdd! vdd!) pfet w=320n l=20n nfin=1 m=1 degradation=no
ends TH44

// 16nm/6T_CONTROL/schematic
//system verilogNetlist schematic cmos.sch cmos_sch veriloga ahdl
subckt _sub107 OutAck ValAddr _1of4_1_3 _1of4_1_2 _1of4_1_1 _1of4_1_0 _1of4_2_3 _1of4_2_2 _1of4_2_1 _1of4_2_0 _1of4_3_3 _1of4_3_2 _1of4_3_1 _1of4_3_0 _1of4_4_3 _1of4_4_2 _1of4_4_1 _1of4_4_0 _1of4_5_3 _1of4_5_2 _1of4_5_1 _1of4_5_0 RW_1 RW_0 Reset AddrAck_3 AddrAck_2 AddrAck_1 AddrAck_0 InAck_3 InAck_2 InAck_1 InAck_0
    I18 (pV_0 pV_1 pV_2 pV_3 ValAddr) nand4_1x
    I14 (InAck_0 InAck_1 InAck_2 InAck_3 OutAck) TH44
    I19_3 (AddrAck_3 _1of4_5_3 pV_3) nand_1x
    I19_2 (AddrAck_2 _1of4_5_2 pV_2) nand_1x
    I19_1 (AddrAck_1 _1of4_5_1 pV_1) nand_1x
    I19_0 (AddrAck_0 _1of4_5_0 pV_0) nand_1x
ends _sub107

// 16nm/Demux_2e1of4/schematic
//system verilogNetlist schematic cmos.sch cmos_sch veriloga ahdl
subckt Demux_2e1of4 A_15 A_14 A_13 A_12 A_11 A_10 A_9 A_8 A_7 A_6 A_5 A_4 A_3 A_2 A_1 A_0 _1of4_1_3 _1of4_1_2 _1of4_1_1 _1of4_1_0 _1of4_2_3 _1of4_2_2 _1of4_2_1 _1of4_2_0 En EnOut
    I15 (_1of4_1_3 _1of4_2_3 EnOut En A_15) and4_1x
    I14 (_1of4_1_2 _1of4_2_3 EnOut En A_14) and4_1x
    I13 (_1of4_1_1 _1of4_2_3 EnOut En A_13) and4_1x
    I12 (_1of4_1_0 _1of4_2_3 EnOut En A_12) and4_1x
    I11 (_1of4_1_3 _1of4_2_2 EnOut En A_11) and4_1x
    I10 (_1of4_1_2 _1of4_2_2 EnOut En A_10) and4_1x
    I9 (_1of4_1_1 _1of4_2_2 EnOut En A_9) and4_1x
    I8 (_1of4_1_0 _1of4_2_2 EnOut En A_8) and4_1x
    I7 (_1of4_1_3 _1of4_2_1 EnOut En A_7) and4_1x
    I6 (_1of4_1_2 _1of4_2_1 EnOut En A_6) and4_1x
    I5 (_1of4_1_1 _1of4_2_1 EnOut En A_5) and4_1x
    I4 (_1of4_1_0 _1of4_2_1 EnOut En A_4) and4_1x
    I3 (_1of4_1_3 _1of4_2_0 EnOut En A_3) and4_1x
    I2 (_1of4_1_2 _1of4_2_0 EnOut En A_2) and4_1x
    I1 (_1of4_1_1 _1of4_2_0 EnOut En A_1) and4_1x
    I0 (_1of4_1_0 _1of4_2_0 EnOut En A_0) and4_1x
ends Demux_2e1of4

// 16nm/or16_1x/schematic
//system verilogNetlist schematic cmos.sch cmos_sch veriloga ahdl
subckt or16_1x Y X_15 X_14 X_13 X_12 X_11 X_10 X_9 X_8 X_7 X_6 X_5 X_4 X_3 X_2 X_1 X_0
    I2 (nX30 nX74 nX118 nX1512 Y) nand4_1x
    I0 (X_0 X_1 X_2 X_3 nX30) nor4_1x
    I1 (X_4 X_5 X_6 X_7 nX74) nor4_1x
    I3 (X_8 X_9 X_10 X_11 nX118) nor4_1x
    I4 (X_12 X_13 X_14 X_15 nX1512) nor4_1x
ends or16_1x

// 16nm/Demux_3e1of4/schematic
//system verilogNetlist schematic cmos.sch cmos_sch veriloga ahdl
subckt Demux_3e1of4 A_63 A_62 A_61 A_60 A_59 A_58 A_57 A_56 A_55 A_54 A_53 A_52 A_51 A_50 A_49 A_48 A_47 A_46 A_45 A_44 A_43 A_42 A_41 A_40 A_39 A_38 A_37 A_36 A_35 A_34 A_33 A_32 A_31 A_30 A_29 A_28 A_27 A_26 A_25 A_24 A_23 A_22 A_21 A_20 A_19 A_18 A_17 A_16 A_15 A_14 A_13 A_12 A_11 A_10 A_9 A_8 A_7 A_6 A_5 A_4 A_3 A_2 A_1 A_0 _1of4_1_3 _1of4_1_2 _1of4_1_1 _1of4_1_0 _1of4_2_3 _1of4_2_2 _1of4_2_1 _1of4_2_0 _1of4_3_3 _1of4_3_2 _1of4_3_1 _1of4_3_0 En AddrValid
    I3 (A_63 A_62 A_61 A_60 A_59 A_58 A_57 A_56 A_55 A_54 A_53 A_52 A_51 A_50 A_49 A_48 _1of4_1_3 _1of4_1_2 _1of4_1_1 _1of4_1_0 _1of4_2_3 _1of4_2_2 _1of4_2_1 _1of4_2_0 En _1of4_3_3) Demux_2e1of4
    I2 (A_47 A_46 A_45 A_44 A_43 A_42 A_41 A_40 A_39 A_38 A_37 A_36 A_35 A_34 A_33 A_32 _1of4_1_3 _1of4_1_2 _1of4_1_1 _1of4_1_0 _1of4_2_3 _1of4_2_2 _1of4_2_1 _1of4_2_0 En _1of4_3_2) Demux_2e1of4
    I1 (A_31 A_30 A_29 A_28 A_27 A_26 A_25 A_24 A_23 A_22 A_21 A_20 A_19 A_18 A_17 A_16 _1of4_1_3 _1of4_1_2 _1of4_1_1 _1of4_1_0 _1of4_2_3 _1of4_2_2 _1of4_2_1 _1of4_2_0 En _1of4_3_1) Demux_2e1of4
    I0 (A_15 A_14 A_13 A_12 A_11 A_10 A_9 A_8 A_7 A_6 A_5 A_4 A_3 A_2 A_1 A_0 _1of4_1_3 _1of4_1_2 _1of4_1_1 _1of4_1_0 _1of4_2_3 _1of4_2_2 _1of4_2_1 _1of4_2_0 En _1of4_3_0) Demux_2e1of4
    I8 (net22 A_63 A_62 A_61 A_60 A_59 A_58 A_57 A_56 A_55 A_54 A_53 A_52 A_51 A_50 A_49 A_48) or16_1x
    I7 (net23 A_47 A_46 A_45 A_44 A_43 A_42 A_41 A_40 A_39 A_38 A_37 A_36 A_35 A_34 A_33 A_32) or16_1x
    I6 (net24 A_31 A_30 A_29 A_28 A_27 A_26 A_25 A_24 A_23 A_22 A_21 A_20 A_19 A_18 A_17 A_16) or16_1x
    I17 (net25 A_15 A_14 A_13 A_12 A_11 A_10 A_9 A_8 A_7 A_6 A_5 A_4 A_3 A_2 A_1 A_0) or16_1x
    I11 (net25 net24 net23 net22 AddrValid) or4_1x
ends Demux_3e1of4

// 16nm/nor3_1x/schematic
//system verilogNetlist schematic cmos.sch cmos_sch veriloga ahdl
subckt nor3_1x A B C Y
    M5 (Y C net21 vdd!) pfet w=300n l=20n nfin=1 m=1 degradation=no
    M3 (net21 B net018 vdd!) pfet w=300n l=20n nfin=1 m=1 degradation=no
    M2 (net018 A vdd! vdd!) pfet w=300n l=20n nfin=1 m=1 degradation=no
    M6 (Y C 0 0) nfet w=60n l=20n nfin=1 m=1 degradation=no
    M1 (Y A 0 0) nfet w=60n l=20n nfin=1 m=1 degradation=no
    M0 (Y B 0 0) nfet w=60n l=20n nfin=1 m=1 degradation=no
ends nor3_1x

// 16nm/6T_DEMUX_/schematic
//system verilogNetlist schematic cmos.sch cmos_sch veriloga ahdl
subckt _sub108 A_63 A_62 A_61 A_60 A_59 A_58 A_57 A_56 A_55 A_54 A_53 A_52 A_51 A_50 A_49 A_48 A_47 A_46 A_45 A_44 A_43 A_42 A_41 A_40 A_39 A_38 A_37 A_36 A_35 A_34 A_33 A_32 A_31 A_30 A_29 A_28 A_27 A_26 A_25 A_24 A_23 A_22 A_21 A_20 A_19 A_18 A_17 A_16 A_15 A_14 A_13 A_12 A_11 A_10 A_9 A_8 A_7 A_6 A_5 A_4 A_3 A_2 A_1 A_0 S_7 S_6 S_5 S_4 S_3 S_2 S_1 S_0 _1of4_1_3 _1of4_1_2 _1of4_1_1 _1of4_1_0 _1of4_2_3 _1of4_2_2 _1of4_2_1 _1of4_2_0 _1of4_3_3 _1of4_3_2 _1of4_3_1 _1of4_3_0 _1of4_4_3 _1of4_4_2 _1of4_4_1 _1of4_4_0 En Ack
    I0 (A_63 A_62 A_61 A_60 A_59 A_58 A_57 A_56 A_55 A_54 A_53 A_52 A_51 A_50 A_49 A_48 A_47 A_46 A_45 A_44 A_43 A_42 A_41 A_40 A_39 A_38 A_37 A_36 A_35 A_34 A_33 A_32 A_31 A_30 A_29 A_28 A_27 A_26 A_25 A_24 A_23 A_22 A_21 A_20 A_19 A_18 A_17 A_16 A_15 A_14 A_13 A_12 A_11 A_10 A_9 A_8 A_7 A_6 A_5 A_4 A_3 A_2 A_1 A_0 _1of4_1_3 _1of4_1_2 _1of4_1_1 _1of4_1_0 _1of4_2_3 _1of4_2_2 _1of4_2_1 _1of4_2_0 _1of4_3_3 _1of4_3_2 _1of4_3_1 _1of4_3_0 En Ack) Demux_3e1of4
    I10_3 (_1of4_4_3 net020_0) inv_1x
    I10_2 (_1of4_4_2 net020_1) inv_1x
    I10_1 (_1of4_4_1 net020_2) inv_1x
    I10_0 (_1of4_4_0 net020_3) inv_1x
    I9 (En net015) inv_1x
    I6 (En net016) inv_1x
    I4 (_1of4_3_0 _1of4_3_1 net23) nor_1x
    I5 (_1of4_3_2 _1of4_3_3 net22) nor_1x
    I1_3 (net020_0 net23 net016 S_3) nor3_1x
    I1_2 (net020_1 net23 net016 S_2) nor3_1x
    I1_1 (net020_2 net23 net016 S_1) nor3_1x
    I1_0 (net020_3 net23 net016 S_0) nor3_1x
    I2_3 (net020_0 net22 net015 S_7) nor3_1x
    I2_2 (net020_1 net22 net015 S_6) nor3_1x
    I2_1 (net020_2 net22 net015 S_5) nor3_1x
    I2_0 (net020_3 net22 net015 S_4) nor3_1x
ends _sub108

// 16nm/6T_BANK/schematic
//system verilogNetlist schematic cmos.sch cmos_sch veriloga ahdl
subckt _sub109 outAck A_19 A_18 A_17 A_16 A_15 A_14 A_13 A_12 A_11 A_10 A_9 A_8 A_7 A_6 A_5 A_4 A_3 A_2 A_1 A_0 RW_1 RW_0 RD_8of32_31 RD_8of32_30 RD_8of32_29 RD_8of32_28 RD_8of32_27 RD_8of32_26 RD_8of32_25 RD_8of32_24 RD_8of32_23 RD_8of32_22 RD_8of32_21 RD_8of32_20 RD_8of32_19 RD_8of32_18 RD_8of32_17 RD_8of32_16 RD_8of32_15 RD_8of32_14 RD_8of32_13 RD_8of32_12 RD_8of32_11 RD_8of32_10 RD_8of32_9 RD_8of32_8 RD_8of32_7 RD_8of32_6 RD_8of32_5 RD_8of32_4 RD_8of32_3 RD_8of32_2 RD_8of32_1 RD_8of32_0 WD_8of32_31 WD_8of32_30 WD_8of32_29 WD_8of32_28 WD_8of32_27 WD_8of32_26 WD_8of32_25 WD_8of32_24 WD_8of32_23 WD_8of32_22 WD_8of32_21 WD_8of32_20 WD_8of32_19 WD_8of32_18 WD_8of32_17 WD_8of32_16 WD_8of32_15 WD_8of32_14 WD_8of32_13 WD_8of32_12 WD_8of32_11 WD_8of32_10 WD_8of32_9 WD_8of32_8 WD_8of32_7 WD_8of32_6 WD_8of32_5 WD_8of32_4 WD_8of32_3 WD_8of32_2 WD_8of32_1 WD_8of32_0 WD_Ack_7 WD_Ack_6 WD_Ack_5 WD_Ack_4 WD_Ack_3 WD_Ack_2 WD_Ack_1 WD_Ack_0 RD_Ack_7 RD_Ack_6 RD_Ack_5 RD_Ack_4 RD_Ack_3 RD_Ack_2 RD_Ack_1 RD_Ack_0 Ctrl_Ack_4 Ctrl_Ack_3 Ctrl_Ack_2 Ctrl_Ack_1 Ctrl_Ack_0
    ICHUNK15 (\~R0_4_3 \~R0_4_2 \~R0_4_1 \~R0_4_0 \~R1_4_3 \~R1_4_2 \~R1_4_1 \~R1_4_0 A_4_63 A_4_62 A_4_61 A_4_60 A_4_59 A_4_58 A_4_57 A_4_56 A_4_55 A_4_54 A_4_53 A_4_52 A_4_51 A_4_50 A_4_49 A_4_48 A_4_47 A_4_46 A_4_45 A_4_44 A_4_43 A_4_42 A_4_41 A_4_40 A_4_39 A_4_38 A_4_37 A_4_36 A_4_35 A_4_34 A_4_33 A_4_32 A_4_31 A_4_30 A_4_29 A_4_28 A_4_27 A_4_26 A_4_25 A_4_24 A_4_23 A_4_22 A_4_21 A_4_20 A_4_19 A_4_18 A_4_17 A_4_16 A_4_15 A_4_14 A_4_13 A_4_12 A_4_11 A_4_10 A_4_9 A_4_8 A_4_7 A_4_6 A_4_5 A_4_4 A_4_3 A_4_2 A_4_1 A_4_0 B0_4_3 B0_4_2 B0_4_1 B0_4_0 B1_4_3 B1_4_2 B1_4_1 B1_4_0 S_4_7 S_4_6 S_4_5 S_4_4 S_4_3 S_4_2 S_4_1 S_4_0 W0_4_3 W0_4_2 W0_4_1 W0_4_0 W1_4_3 W1_4_2 W1_4_1 W1_4_0 G04) _sub104
    ICHUNK11 (\~R0_4_3 \~R0_4_2 \~R0_4_1 \~R0_4_0 \~R1_4_3 \~R1_4_2 \~R1_4_1 \~R1_4_0 A_3_63 A_3_62 A_3_61 A_3_60 A_3_59 A_3_58 A_3_57 A_3_56 A_3_55 A_3_54 A_3_53 A_3_52 A_3_51 A_3_50 A_3_49 A_3_48 A_3_47 A_3_46 A_3_45 A_3_44 A_3_43 A_3_42 A_3_41 A_3_40 A_3_39 A_3_38 A_3_37 A_3_36 A_3_35 A_3_34 A_3_33 A_3_32 A_3_31 A_3_30 A_3_29 A_3_28 A_3_27 A_3_26 A_3_25 A_3_24 A_3_23 A_3_22 A_3_21 A_3_20 A_3_19 A_3_18 A_3_17 A_3_16 A_3_15 A_3_14 A_3_13 A_3_12 A_3_11 A_3_10 A_3_9 A_3_8 A_3_7 A_3_6 A_3_5 A_3_4 A_3_3 A_3_2 A_3_1 A_3_0 B0_4_3 B0_4_2 B0_4_1 B0_4_0 B1_4_3 B1_4_2 B1_4_1 B1_4_0 S_3_7 S_3_6 S_3_5 S_3_4 S_3_3 S_3_2 S_3_1 S_3_0 W0_4_3 W0_4_2 W0_4_1 W0_4_0 W1_4_3 W1_4_2 W1_4_1 W1_4_0 G04) _sub104
    ICHUNK7 (\~R0_4_3 \~R0_4_2 \~R0_4_1 \~R0_4_0 \~R1_4_3 \~R1_4_2 \~R1_4_1 \~R1_4_0 A_2_63 A_2_62 A_2_61 A_2_60 A_2_59 A_2_58 A_2_57 A_2_56 A_2_55 A_2_54 A_2_53 A_2_52 A_2_51 A_2_50 A_2_49 A_2_48 A_2_47 A_2_46 A_2_45 A_2_44 A_2_43 A_2_42 A_2_41 A_2_40 A_2_39 A_2_38 A_2_37 A_2_36 A_2_35 A_2_34 A_2_33 A_2_32 A_2_31 A_2_30 A_2_29 A_2_28 A_2_27 A_2_26 A_2_25 A_2_24 A_2_23 A_2_22 A_2_21 A_2_20 A_2_19 A_2_18 A_2_17 A_2_16 A_2_15 A_2_14 A_2_13 A_2_12 A_2_11 A_2_10 A_2_9 A_2_8 A_2_7 A_2_6 A_2_5 A_2_4 A_2_3 A_2_2 A_2_1 A_2_0 B0_4_3 B0_4_2 B0_4_1 B0_4_0 B1_4_3 B1_4_2 B1_4_1 B1_4_0 S_2_7 S_2_6 S_2_5 S_2_4 S_2_3 S_2_2 S_2_1 S_2_0 W0_4_3 W0_4_2 W0_4_1 W0_4_0 W1_4_3 W1_4_2 W1_4_1 W1_4_0 G04) _sub104
    ICHUNK3 (\~R0_4_3 \~R0_4_2 \~R0_4_1 \~R0_4_0 \~R1_4_3 \~R1_4_2 \~R1_4_1 \~R1_4_0 A_1_63 A_1_62 A_1_61 A_1_60 A_1_59 A_1_58 A_1_57 A_1_56 A_1_55 A_1_54 A_1_53 A_1_52 A_1_51 A_1_50 A_1_49 A_1_48 A_1_47 A_1_46 A_1_45 A_1_44 A_1_43 A_1_42 A_1_41 A_1_40 A_1_39 A_1_38 A_1_37 A_1_36 A_1_35 A_1_34 A_1_33 A_1_32 A_1_31 A_1_30 A_1_29 A_1_28 A_1_27 A_1_26 A_1_25 A_1_24 A_1_23 A_1_22 A_1_21 A_1_20 A_1_19 A_1_18 A_1_17 A_1_16 A_1_15 A_1_14 A_1_13 A_1_12 A_1_11 A_1_10 A_1_9 A_1_8 A_1_7 A_1_6 A_1_5 A_1_4 A_1_3 A_1_2 A_1_1 A_1_0 B0_4_3 B0_4_2 B0_4_1 B0_4_0 B1_4_3 B1_4_2 B1_4_1 B1_4_0 S_1_7 S_1_6 S_1_5 S_1_4 S_1_3 S_1_2 S_1_1 S_1_0 W0_4_3 W0_4_2 W0_4_1 W0_4_0 W1_4_3 W1_4_2 W1_4_1 W1_4_0 G04) _sub104
    ICHUNK14 (\~R0_3_3 \~R0_3_2 \~R0_3_1 \~R0_3_0 \~R1_3_3 \~R1_3_2 \~R1_3_1 \~R1_3_0 A_4_63 A_4_62 A_4_61 A_4_60 A_4_59 A_4_58 A_4_57 A_4_56 A_4_55 A_4_54 A_4_53 A_4_52 A_4_51 A_4_50 A_4_49 A_4_48 A_4_47 A_4_46 A_4_45 A_4_44 A_4_43 A_4_42 A_4_41 A_4_40 A_4_39 A_4_38 A_4_37 A_4_36 A_4_35 A_4_34 A_4_33 A_4_32 A_4_31 A_4_30 A_4_29 A_4_28 A_4_27 A_4_26 A_4_25 A_4_24 A_4_23 A_4_22 A_4_21 A_4_20 A_4_19 A_4_18 A_4_17 A_4_16 A_4_15 A_4_14 A_4_13 A_4_12 A_4_11 A_4_10 A_4_9 A_4_8 A_4_7 A_4_6 A_4_5 A_4_4 A_4_3 A_4_2 A_4_1 A_4_0 B0_3_3 B0_3_2 B0_3_1 B0_3_0 B1_3_3 B1_3_2 B1_3_1 B1_3_0 S_4_7 S_4_6 S_4_5 S_4_4 S_4_3 S_4_2 S_4_1 S_4_0 W0_3_3 W0_3_2 W0_3_1 W0_3_0 W1_3_3 W1_3_2 W1_3_1 W1_3_0 G03) _sub104
    ICHUNK10 (\~R0_3_3 \~R0_3_2 \~R0_3_1 \~R0_3_0 \~R1_3_3 \~R1_3_2 \~R1_3_1 \~R1_3_0 A_3_63 A_3_62 A_3_61 A_3_60 A_3_59 A_3_58 A_3_57 A_3_56 A_3_55 A_3_54 A_3_53 A_3_52 A_3_51 A_3_50 A_3_49 A_3_48 A_3_47 A_3_46 A_3_45 A_3_44 A_3_43 A_3_42 A_3_41 A_3_40 A_3_39 A_3_38 A_3_37 A_3_36 A_3_35 A_3_34 A_3_33 A_3_32 A_3_31 A_3_30 A_3_29 A_3_28 A_3_27 A_3_26 A_3_25 A_3_24 A_3_23 A_3_22 A_3_21 A_3_20 A_3_19 A_3_18 A_3_17 A_3_16 A_3_15 A_3_14 A_3_13 A_3_12 A_3_11 A_3_10 A_3_9 A_3_8 A_3_7 A_3_6 A_3_5 A_3_4 A_3_3 A_3_2 A_3_1 A_3_0 B0_3_3 B0_3_2 B0_3_1 B0_3_0 B1_3_3 B1_3_2 B1_3_1 B1_3_0 S_3_7 S_3_6 S_3_5 S_3_4 S_3_3 S_3_2 S_3_1 S_3_0 W0_3_3 W0_3_2 W0_3_1 W0_3_0 W1_3_3 W1_3_2 W1_3_1 W1_3_0 G03) _sub104
    ICHUNK6 (\~R0_3_3 \~R0_3_2 \~R0_3_1 \~R0_3_0 \~R1_3_3 \~R1_3_2 \~R1_3_1 \~R1_3_0 A_2_63 A_2_62 A_2_61 A_2_60 A_2_59 A_2_58 A_2_57 A_2_56 A_2_55 A_2_54 A_2_53 A_2_52 A_2_51 A_2_50 A_2_49 A_2_48 A_2_47 A_2_46 A_2_45 A_2_44 A_2_43 A_2_42 A_2_41 A_2_40 A_2_39 A_2_38 A_2_37 A_2_36 A_2_35 A_2_34 A_2_33 A_2_32 A_2_31 A_2_30 A_2_29 A_2_28 A_2_27 A_2_26 A_2_25 A_2_24 A_2_23 A_2_22 A_2_21 A_2_20 A_2_19 A_2_18 A_2_17 A_2_16 A_2_15 A_2_14 A_2_13 A_2_12 A_2_11 A_2_10 A_2_9 A_2_8 A_2_7 A_2_6 A_2_5 A_2_4 A_2_3 A_2_2 A_2_1 A_2_0 B0_3_3 B0_3_2 B0_3_1 B0_3_0 B1_3_3 B1_3_2 B1_3_1 B1_3_0 S_2_7 S_2_6 S_2_5 S_2_4 S_2_3 S_2_2 S_2_1 S_2_0 W0_3_3 W0_3_2 W0_3_1 W0_3_0 W1_3_3 W1_3_2 W1_3_1 W1_3_0 G03) _sub104
    ICHUNK2 (\~R0_3_3 \~R0_3_2 \~R0_3_1 \~R0_3_0 \~R1_3_3 \~R1_3_2 \~R1_3_1 \~R1_3_0 A_1_63 A_1_62 A_1_61 A_1_60 A_1_59 A_1_58 A_1_57 A_1_56 A_1_55 A_1_54 A_1_53 A_1_52 A_1_51 A_1_50 A_1_49 A_1_48 A_1_47 A_1_46 A_1_45 A_1_44 A_1_43 A_1_42 A_1_41 A_1_40 A_1_39 A_1_38 A_1_37 A_1_36 A_1_35 A_1_34 A_1_33 A_1_32 A_1_31 A_1_30 A_1_29 A_1_28 A_1_27 A_1_26 A_1_25 A_1_24 A_1_23 A_1_22 A_1_21 A_1_20 A_1_19 A_1_18 A_1_17 A_1_16 A_1_15 A_1_14 A_1_13 A_1_12 A_1_11 A_1_10 A_1_9 A_1_8 A_1_7 A_1_6 A_1_5 A_1_4 A_1_3 A_1_2 A_1_1 A_1_0 B0_3_3 B0_3_2 B0_3_1 B0_3_0 B1_3_3 B1_3_2 B1_3_1 B1_3_0 S_1_7 S_1_6 S_1_5 S_1_4 S_1_3 S_1_2 S_1_1 S_1_0 W0_3_3 W0_3_2 W0_3_1 W0_3_0 W1_3_3 W1_3_2 W1_3_1 W1_3_0 G03) _sub104
    ICHUNK13 (\~R0_2_3 \~R0_2_2 \~R0_2_1 \~R0_2_0 \~R1_2_3 \~R1_2_2 \~R1_2_1 \~R1_2_0 A_4_63 A_4_62 A_4_61 A_4_60 A_4_59 A_4_58 A_4_57 A_4_56 A_4_55 A_4_54 A_4_53 A_4_52 A_4_51 A_4_50 A_4_49 A_4_48 A_4_47 A_4_46 A_4_45 A_4_44 A_4_43 A_4_42 A_4_41 A_4_40 A_4_39 A_4_38 A_4_37 A_4_36 A_4_35 A_4_34 A_4_33 A_4_32 A_4_31 A_4_30 A_4_29 A_4_28 A_4_27 A_4_26 A_4_25 A_4_24 A_4_23 A_4_22 A_4_21 A_4_20 A_4_19 A_4_18 A_4_17 A_4_16 A_4_15 A_4_14 A_4_13 A_4_12 A_4_11 A_4_10 A_4_9 A_4_8 A_4_7 A_4_6 A_4_5 A_4_4 A_4_3 A_4_2 A_4_1 A_4_0 B0_2_3 B0_2_2 B0_2_1 B0_2_0 B1_2_3 B1_2_2 B1_2_1 B1_2_0 S_4_7 S_4_6 S_4_5 S_4_4 S_4_3 S_4_2 S_4_1 S_4_0 W0_2_3 W0_2_2 W0_2_1 W0_2_0 W1_2_3 W1_2_2 W1_2_1 W1_2_0 G02) _sub104
    ICHUNK9 (\~R0_2_3 \~R0_2_2 \~R0_2_1 \~R0_2_0 \~R1_2_3 \~R1_2_2 \~R1_2_1 \~R1_2_0 A_3_63 A_3_62 A_3_61 A_3_60 A_3_59 A_3_58 A_3_57 A_3_56 A_3_55 A_3_54 A_3_53 A_3_52 A_3_51 A_3_50 A_3_49 A_3_48 A_3_47 A_3_46 A_3_45 A_3_44 A_3_43 A_3_42 A_3_41 A_3_40 A_3_39 A_3_38 A_3_37 A_3_36 A_3_35 A_3_34 A_3_33 A_3_32 A_3_31 A_3_30 A_3_29 A_3_28 A_3_27 A_3_26 A_3_25 A_3_24 A_3_23 A_3_22 A_3_21 A_3_20 A_3_19 A_3_18 A_3_17 A_3_16 A_3_15 A_3_14 A_3_13 A_3_12 A_3_11 A_3_10 A_3_9 A_3_8 A_3_7 A_3_6 A_3_5 A_3_4 A_3_3 A_3_2 A_3_1 A_3_0 B0_2_3 B0_2_2 B0_2_1 B0_2_0 B1_2_3 B1_2_2 B1_2_1 B1_2_0 S_3_7 S_3_6 S_3_5 S_3_4 S_3_3 S_3_2 S_3_1 S_3_0 W0_2_3 W0_2_2 W0_2_1 W0_2_0 W1_2_3 W1_2_2 W1_2_1 W1_2_0 G02) _sub104
    ICHUNK5 (\~R0_2_3 \~R0_2_2 \~R0_2_1 \~R0_2_0 \~R1_2_3 \~R1_2_2 \~R1_2_1 \~R1_2_0 A_2_63 A_2_62 A_2_61 A_2_60 A_2_59 A_2_58 A_2_57 A_2_56 A_2_55 A_2_54 A_2_53 A_2_52 A_2_51 A_2_50 A_2_49 A_2_48 A_2_47 A_2_46 A_2_45 A_2_44 A_2_43 A_2_42 A_2_41 A_2_40 A_2_39 A_2_38 A_2_37 A_2_36 A_2_35 A_2_34 A_2_33 A_2_32 A_2_31 A_2_30 A_2_29 A_2_28 A_2_27 A_2_26 A_2_25 A_2_24 A_2_23 A_2_22 A_2_21 A_2_20 A_2_19 A_2_18 A_2_17 A_2_16 A_2_15 A_2_14 A_2_13 A_2_12 A_2_11 A_2_10 A_2_9 A_2_8 A_2_7 A_2_6 A_2_5 A_2_4 A_2_3 A_2_2 A_2_1 A_2_0 B0_2_3 B0_2_2 B0_2_1 B0_2_0 B1_2_3 B1_2_2 B1_2_1 B1_2_0 S_2_7 S_2_6 S_2_5 S_2_4 S_2_3 S_2_2 S_2_1 S_2_0 W0_2_3 W0_2_2 W0_2_1 W0_2_0 W1_2_3 W1_2_2 W1_2_1 W1_2_0 G02) _sub104
    ICHUNK1 (\~R0_2_3 \~R0_2_2 \~R0_2_1 \~R0_2_0 \~R1_2_3 \~R1_2_2 \~R1_2_1 \~R1_2_0 A_1_63 A_1_62 A_1_61 A_1_60 A_1_59 A_1_58 A_1_57 A_1_56 A_1_55 A_1_54 A_1_53 A_1_52 A_1_51 A_1_50 A_1_49 A_1_48 A_1_47 A_1_46 A_1_45 A_1_44 A_1_43 A_1_42 A_1_41 A_1_40 A_1_39 A_1_38 A_1_37 A_1_36 A_1_35 A_1_34 A_1_33 A_1_32 A_1_31 A_1_30 A_1_29 A_1_28 A_1_27 A_1_26 A_1_25 A_1_24 A_1_23 A_1_22 A_1_21 A_1_20 A_1_19 A_1_18 A_1_17 A_1_16 A_1_15 A_1_14 A_1_13 A_1_12 A_1_11 A_1_10 A_1_9 A_1_8 A_1_7 A_1_6 A_1_5 A_1_4 A_1_3 A_1_2 A_1_1 A_1_0 B0_2_3 B0_2_2 B0_2_1 B0_2_0 B1_2_3 B1_2_2 B1_2_1 B1_2_0 S_1_7 S_1_6 S_1_5 S_1_4 S_1_3 S_1_2 S_1_1 S_1_0 W0_2_3 W0_2_2 W0_2_1 W0_2_0 W1_2_3 W1_2_2 W1_2_1 W1_2_0 G02) _sub104
    ICHUNK12 (\~R0_1_3 \~R0_1_2 \~R0_1_1 \~R0_1_0 \~R1_1_3 \~R1_1_2 \~R1_1_1 \~R1_1_0 A_4_63 A_4_62 A_4_61 A_4_60 A_4_59 A_4_58 A_4_57 A_4_56 A_4_55 A_4_54 A_4_53 A_4_52 A_4_51 A_4_50 A_4_49 A_4_48 A_4_47 A_4_46 A_4_45 A_4_44 A_4_43 A_4_42 A_4_41 A_4_40 A_4_39 A_4_38 A_4_37 A_4_36 A_4_35 A_4_34 A_4_33 A_4_32 A_4_31 A_4_30 A_4_29 A_4_28 A_4_27 A_4_26 A_4_25 A_4_24 A_4_23 A_4_22 A_4_21 A_4_20 A_4_19 A_4_18 A_4_17 A_4_16 A_4_15 A_4_14 A_4_13 A_4_12 A_4_11 A_4_10 A_4_9 A_4_8 A_4_7 A_4_6 A_4_5 A_4_4 A_4_3 A_4_2 A_4_1 A_4_0 B0_1_3 B0_1_2 B0_1_1 B0_1_0 B1_1_3 B1_1_2 B1_1_1 B1_1_0 S_4_7 S_4_6 S_4_5 S_4_4 S_4_3 S_4_2 S_4_1 S_4_0 W0_1_3 W0_1_2 W0_1_1 W0_1_0 W1_1_3 W1_1_2 W1_1_1 W1_1_0 G01) _sub104
    ICHUNK8 (\~R0_1_3 \~R0_1_2 \~R0_1_1 \~R0_1_0 \~R1_1_3 \~R1_1_2 \~R1_1_1 \~R1_1_0 A_3_63 A_3_62 A_3_61 A_3_60 A_3_59 A_3_58 A_3_57 A_3_56 A_3_55 A_3_54 A_3_53 A_3_52 A_3_51 A_3_50 A_3_49 A_3_48 A_3_47 A_3_46 A_3_45 A_3_44 A_3_43 A_3_42 A_3_41 A_3_40 A_3_39 A_3_38 A_3_37 A_3_36 A_3_35 A_3_34 A_3_33 A_3_32 A_3_31 A_3_30 A_3_29 A_3_28 A_3_27 A_3_26 A_3_25 A_3_24 A_3_23 A_3_22 A_3_21 A_3_20 A_3_19 A_3_18 A_3_17 A_3_16 A_3_15 A_3_14 A_3_13 A_3_12 A_3_11 A_3_10 A_3_9 A_3_8 A_3_7 A_3_6 A_3_5 A_3_4 A_3_3 A_3_2 A_3_1 A_3_0 B0_1_3 B0_1_2 B0_1_1 B0_1_0 B1_1_3 B1_1_2 B1_1_1 B1_1_0 S_3_7 S_3_6 S_3_5 S_3_4 S_3_3 S_3_2 S_3_1 S_3_0 W0_1_3 W0_1_2 W0_1_1 W0_1_0 W1_1_3 W1_1_2 W1_1_1 W1_1_0 G01) _sub104
    ICHUNK4 (\~R0_1_3 \~R0_1_2 \~R0_1_1 \~R0_1_0 \~R1_1_3 \~R1_1_2 \~R1_1_1 \~R1_1_0 A_2_63 A_2_62 A_2_61 A_2_60 A_2_59 A_2_58 A_2_57 A_2_56 A_2_55 A_2_54 A_2_53 A_2_52 A_2_51 A_2_50 A_2_49 A_2_48 A_2_47 A_2_46 A_2_45 A_2_44 A_2_43 A_2_42 A_2_41 A_2_40 A_2_39 A_2_38 A_2_37 A_2_36 A_2_35 A_2_34 A_2_33 A_2_32 A_2_31 A_2_30 A_2_29 A_2_28 A_2_27 A_2_26 A_2_25 A_2_24 A_2_23 A_2_22 A_2_21 A_2_20 A_2_19 A_2_18 A_2_17 A_2_16 A_2_15 A_2_14 A_2_13 A_2_12 A_2_11 A_2_10 A_2_9 A_2_8 A_2_7 A_2_6 A_2_5 A_2_4 A_2_3 A_2_2 A_2_1 A_2_0 B0_1_3 B0_1_2 B0_1_1 B0_1_0 B1_1_3 B1_1_2 B1_1_1 B1_1_0 S_2_7 S_2_6 S_2_5 S_2_4 S_2_3 S_2_2 S_2_1 S_2_0 W0_1_3 W0_1_2 W0_1_1 W0_1_0 W1_1_3 W1_1_2 W1_1_1 W1_1_0 G01) _sub104
    ICHUNK0 (\~R0_1_3 \~R0_1_2 \~R0_1_1 \~R0_1_0 \~R1_1_3 \~R1_1_2 \~R1_1_1 \~R1_1_0 A_1_63 A_1_62 A_1_61 A_1_60 A_1_59 A_1_58 A_1_57 A_1_56 A_1_55 A_1_54 A_1_53 A_1_52 A_1_51 A_1_50 A_1_49 A_1_48 A_1_47 A_1_46 A_1_45 A_1_44 A_1_43 A_1_42 A_1_41 A_1_40 A_1_39 A_1_38 A_1_37 A_1_36 A_1_35 A_1_34 A_1_33 A_1_32 A_1_31 A_1_30 A_1_29 A_1_28 A_1_27 A_1_26 A_1_25 A_1_24 A_1_23 A_1_22 A_1_21 A_1_20 A_1_19 A_1_18 A_1_17 A_1_16 A_1_15 A_1_14 A_1_13 A_1_12 A_1_11 A_1_10 A_1_9 A_1_8 A_1_7 A_1_6 A_1_5 A_1_4 A_1_3 A_1_2 A_1_1 A_1_0 B0_1_3 B0_1_2 B0_1_1 B0_1_0 B1_1_3 B1_1_2 B1_1_1 B1_1_0 S_1_7 S_1_6 S_1_5 S_1_4 S_1_3 S_1_2 S_1_1 S_1_0 W0_1_3 W0_1_2 W0_1_1 W0_1_0 W1_1_3 W1_1_2 W1_1_1 W1_1_0 G01) _sub104
    IDATA3 (net042 B0_4_3 B0_4_2 B0_4_1 B0_4_0 B1_4_3 B1_4_2 B1_4_1 B1_4_0 G04 W0_4_3 W0_4_2 W0_4_1 W0_4_0 W1_4_3 W1_4_2 W1_4_1 W1_4_0 RW_1 RW_0 Reset ValAddr RD_8of32_27 RD_8of32_26 RD_8of32_25 RD_8of32_24 RD_8of32_31 RD_8of32_30 RD_8of32_29 RD_8of32_28 WD_8of32_27 WD_8of32_26 WD_8of32_25 WD_8of32_24 WD_8of32_31 WD_8of32_30 WD_8of32_29 WD_8of32_28 \~R1_4_3 \~R1_4_2 \~R1_4_1 \~R1_4_0 \~R0_4_3 \~R0_4_2 \~R0_4_1 \~R0_4_0 net0170 0 WD_Ack_7 WD_Ack_6 RD_Ack_7 RD_Ack_6) _sub106
    IDATA2 (ck_2 B0_3_3 B0_3_2 B0_3_1 B0_3_0 B1_3_3 B1_3_2 B1_3_1 B1_3_0 G03 W0_3_3 W0_3_2 W0_3_1 W0_3_0 W1_3_3 W1_3_2 W1_3_1 W1_3_0 RW_1 RW_0 Reset ValAddr RD_8of32_19 RD_8of32_18 RD_8of32_17 RD_8of32_16 RD_8of32_23 RD_8of32_22 RD_8of32_21 RD_8of32_20 WD_8of32_19 WD_8of32_18 WD_8of32_17 WD_8of32_16 WD_8of32_23 WD_8of32_22 WD_8of32_21 WD_8of32_20 \~R1_3_3 \~R1_3_2 \~R1_3_1 \~R1_3_0 \~R0_3_3 \~R0_3_2 \~R0_3_1 \~R0_3_0 ck_3 net042 WD_Ack_5 WD_Ack_4 RD_Ack_5 RD_Ack_4) _sub106
    IDATA1 (ck_0 B0_2_3 B0_2_2 B0_2_1 B0_2_0 B1_2_3 B1_2_2 B1_2_1 B1_2_0 G02 W0_2_3 W0_2_2 W0_2_1 W0_2_0 W1_2_3 W1_2_2 W1_2_1 W1_2_0 RW_1 RW_0 Reset ValAddr RD_8of32_11 RD_8of32_10 RD_8of32_9 RD_8of32_8 RD_8of32_15 RD_8of32_14 RD_8of32_13 RD_8of32_12 WD_8of32_11 WD_8of32_10 WD_8of32_9 WD_8of32_8 WD_8of32_15 WD_8of32_14 WD_8of32_13 WD_8of32_12 \~R1_2_3 \~R1_2_2 \~R1_2_1 \~R1_2_0 \~R0_2_3 \~R0_2_2 \~R0_2_1 \~R0_2_0 net027 ck_1 WD_Ack_3 WD_Ack_2 RD_Ack_3 RD_Ack_2) _sub106
    IDATA0 (net027 B0_1_3 B0_1_2 B0_1_1 B0_1_0 B1_1_3 B1_1_2 B1_1_1 B1_1_0 G01 W0_1_3 W0_1_2 W0_1_1 W0_1_0 W1_1_3 W1_1_2 W1_1_1 W1_1_0 RW_1 RW_0 Reset ValAddr RD_8of32_3 RD_8of32_2 RD_8of32_1 RD_8of32_0 RD_8of32_7 RD_8of32_6 RD_8of32_5 RD_8of32_4 WD_8of32_3 WD_8of32_2 WD_8of32_1 WD_8of32_0 WD_8of32_7 WD_8of32_6 WD_8of32_5 WD_8of32_4 \~R1_1_3 \~R1_1_2 \~R1_1_1 \~R1_1_0 \~R0_1_3 \~R0_1_2 \~R0_1_1 \~R0_1_0 0 net0173 WD_Ack_1 WD_Ack_0 RD_Ack_1 RD_Ack_0) _sub106
    I24 (outAck ValAddr A_3 A_2 A_1 A_0 A_7 A_6 A_5 A_4 A_11 A_10 A_9 A_8 A_15 A_14 A_13 A_12 A_19 A_18 A_17 A_16 RW_1 RW_0 Reset AvAck_3 AvAck_2 AvAck_1 AvAck_0 ck_3 ck_2 ck_1 ck_0) _sub107
    I29_4 (outAck Ctrl_Ack_4) inv_1x
    I29_3 (outAck Ctrl_Ack_3) inv_1x
    I29_2 (outAck Ctrl_Ack_2) inv_1x
    I29_1 (outAck Ctrl_Ack_1) inv_1x
    I29_0 (outAck Ctrl_Ack_0) inv_1x
    I19 (A_4_63 A_4_62 A_4_61 A_4_60 A_4_59 A_4_58 A_4_57 A_4_56 A_4_55 A_4_54 A_4_53 A_4_52 A_4_51 A_4_50 A_4_49 A_4_48 A_4_47 A_4_46 A_4_45 A_4_44 A_4_43 A_4_42 A_4_41 A_4_40 A_4_39 A_4_38 A_4_37 A_4_36 A_4_35 A_4_34 A_4_33 A_4_32 A_4_31 A_4_30 A_4_29 A_4_28 A_4_27 A_4_26 A_4_25 A_4_24 A_4_23 A_4_22 A_4_21 A_4_20 A_4_19 A_4_18 A_4_17 A_4_16 A_4_15 A_4_14 A_4_13 A_4_12 A_4_11 A_4_10 A_4_9 A_4_8 A_4_7 A_4_6 A_4_5 A_4_4 A_4_3 A_4_2 A_4_1 A_4_0 S_4_7 S_4_6 S_4_5 S_4_4 S_4_3 S_4_2 S_4_1 S_4_0 A_3 A_2 A_1 A_0 A_7 A_6 A_5 A_4 A_11 A_10 A_9 A_8 A_15 A_14 A_13 A_12 A_19 AvAck_3) _sub108
    I18 (A_3_63 A_3_62 A_3_61 A_3_60 A_3_59 A_3_58 A_3_57 A_3_56 A_3_55 A_3_54 A_3_53 A_3_52 A_3_51 A_3_50 A_3_49 A_3_48 A_3_47 A_3_46 A_3_45 A_3_44 A_3_43 A_3_42 A_3_41 A_3_40 A_3_39 A_3_38 A_3_37 A_3_36 A_3_35 A_3_34 A_3_33 A_3_32 A_3_31 A_3_30 A_3_29 A_3_28 A_3_27 A_3_26 A_3_25 A_3_24 A_3_23 A_3_22 A_3_21 A_3_20 A_3_19 A_3_18 A_3_17 A_3_16 A_3_15 A_3_14 A_3_13 A_3_12 A_3_11 A_3_10 A_3_9 A_3_8 A_3_7 A_3_6 A_3_5 A_3_4 A_3_3 A_3_2 A_3_1 A_3_0 S_3_7 S_3_6 S_3_5 S_3_4 S_3_3 S_3_2 S_3_1 S_3_0 A_3 A_2 A_1 A_0 A_7 A_6 A_5 A_4 A_11 A_10 A_9 A_8 A_15 A_14 A_13 A_12 A_18 AvAck_2) _sub108
    I17 (A_2_63 A_2_62 A_2_61 A_2_60 A_2_59 A_2_58 A_2_57 A_2_56 A_2_55 A_2_54 A_2_53 A_2_52 A_2_51 A_2_50 A_2_49 A_2_48 A_2_47 A_2_46 A_2_45 A_2_44 A_2_43 A_2_42 A_2_41 A_2_40 A_2_39 A_2_38 A_2_37 A_2_36 A_2_35 A_2_34 A_2_33 A_2_32 A_2_31 A_2_30 A_2_29 A_2_28 A_2_27 A_2_26 A_2_25 A_2_24 A_2_23 A_2_22 A_2_21 A_2_20 A_2_19 A_2_18 A_2_17 A_2_16 A_2_15 A_2_14 A_2_13 A_2_12 A_2_11 A_2_10 A_2_9 A_2_8 A_2_7 A_2_6 A_2_5 A_2_4 A_2_3 A_2_2 A_2_1 A_2_0 S_2_7 S_2_6 S_2_5 S_2_4 S_2_3 S_2_2 S_2_1 S_2_0 A_3 A_2 A_1 A_0 A_7 A_6 A_5 A_4 A_11 A_10 A_9 A_8 A_15 A_14 A_13 A_12 A_17 AvAck_1) _sub108
    I16 (A_1_63 A_1_62 A_1_61 A_1_60 A_1_59 A_1_58 A_1_57 A_1_56 A_1_55 A_1_54 A_1_53 A_1_52 A_1_51 A_1_50 A_1_49 A_1_48 A_1_47 A_1_46 A_1_45 A_1_44 A_1_43 A_1_42 A_1_41 A_1_40 A_1_39 A_1_38 A_1_37 A_1_36 A_1_35 A_1_34 A_1_33 A_1_32 A_1_31 A_1_30 A_1_29 A_1_28 A_1_27 A_1_26 A_1_25 A_1_24 A_1_23 A_1_22 A_1_21 A_1_20 A_1_19 A_1_18 A_1_17 A_1_16 A_1_15 A_1_14 A_1_13 A_1_12 A_1_11 A_1_10 A_1_9 A_1_8 A_1_7 A_1_6 A_1_5 A_1_4 A_1_3 A_1_2 A_1_1 A_1_0 S_1_7 S_1_6 S_1_5 S_1_4 S_1_3 S_1_2 S_1_1 S_1_0 A_3 A_2 A_1 A_0 A_7 A_6 A_5 A_4 A_11 A_10 A_9 A_8 A_15 A_14 A_13 A_12 A_16 AvAck_0) _sub108
ends _sub109

// 16nm/inv_1xt/schematic
//system verilogNetlist schematic cmos.sch cmos_sch veriloga ahdl
subckt inv_1xt A Y
    M0 (Y A 0 0) nfet w=60n l=20n nfin=1 m=1 degradation=no
    M1 (Y A vcc! vcc!) pfet w=100n l=20n nfin=1 m=1 degradation=no
ends inv_1xt

// 16nm_Tests/6T_BANK_Test/schematic
// system verilogNetlist schematic cmos.sch cmos_sch veriloga ahdl
V1 (vdd! 0) vsource type=dc dc=vdd
V0 (vcc! 0) vsource type=dc dc=vcc
IBank (AckT AT_19 AT_18 AT_17 AT_16 AT_15 AT_14 AT_13 AT_12 AT_11 AT_10 AT_9 AT_8 AT_7 AT_6 AT_5 AT_4 AT_3 AT_2 AT_1 AT_0 RWT_1 RWT_0 ReaDataT_31 ReaDataT_30 ReaDataT_29 ReaDataT_28 ReaDataT_27 ReaDataT_26 ReaDataT_25 ReaDataT_24 ReaDataT_23 ReaDataT_22 ReaDataT_21 ReaDataT_20 ReaDataT_19 ReaDataT_18 ReaDataT_17 ReaDataT_16 ReaDataT_15 ReaDataT_14 ReaDataT_13 ReaDataT_12 ReaDataT_11 ReaDataT_10 ReaDataT_9 ReaDataT_8 ReaDataT_7 ReaDataT_6 ReaDataT_5 ReaDataT_4 ReaDataT_3 ReaDataT_2 ReaDataT_1 ReaDataT_0 WriteDataT_31 WriteDataT_30 WriteDataT_29 WriteDataT_28 WriteDataT_27 WriteDataT_26 WriteDataT_25 WriteDataT_24 WriteDataT_23 WriteDataT_22 WriteDataT_21 WriteDataT_20 WriteDataT_19 WriteDataT_18 WriteDataT_17 WriteDataT_16 WriteDataT_15 WriteDataT_14 WriteDataT_13 WriteDataT_12 WriteDataT_11 WriteDataT_10 WriteDataT_9 WriteDataT_8 WriteDataT_7 WriteDataT_6 WriteDataT_5 WriteDataT_4 WriteDataT_3 WriteDataT_2 WriteDataT_1 WriteDataT_0 WDataAckT_7 WDataAckT_6 WDataAckT_5 WDataAckT_4 WDataAckT_3 WDataAckT_2 WDataAckT_1 WDataAckT_0 ReadDataAckT_7 ReadDataAckT_6 ReadDataAckT_5 ReadDataAckT_4 ReadDataAckT_3 ReadDataAckT_2 ReadDataAckT_1 ReadDataAckT_0 CtrlAckT_4 CtrlAckT_3 CtrlAckT_2 CtrlAckT_1 CtrlAckT_0) _sub109
I15_4 (CtrlAckT_4 net013_0) inv_1xt
I15_3 (CtrlAckT_3 net013_1) inv_1xt
I15_2 (CtrlAckT_2 net013_2) inv_1xt
I15_1 (CtrlAckT_1 net013_3) inv_1xt
I15_0 (CtrlAckT_0 net013_4) inv_1xt
I11_7 (\~RAck_7 ReadDataAckT_7) inv_1xt
I11_6 (\~RAck_6 ReadDataAckT_6) inv_1xt
I11_5 (\~RAck_5 ReadDataAckT_5) inv_1xt
I11_4 (\~RAck_4 ReadDataAckT_4) inv_1xt
I11_3 (\~RAck_3 ReadDataAckT_3) inv_1xt
I11_2 (\~RAck_2 ReadDataAckT_2) inv_1xt
I11_1 (\~RAck_1 ReadDataAckT_1) inv_1xt
I11_0 (\~RAck_0 ReadDataAckT_0) inv_1xt
I10_7 (WDataAckT_7 \~WAck_7) inv_1xt
I10_6 (WDataAckT_6 \~WAck_6) inv_1xt
I10_5 (WDataAckT_5 \~WAck_5) inv_1xt
I10_4 (WDataAckT_4 \~WAck_4) inv_1xt
I10_3 (WDataAckT_3 \~WAck_3) inv_1xt
I10_2 (WDataAckT_2 \~WAck_2) inv_1xt
I10_1 (WDataAckT_1 \~WAck_1) inv_1xt
I10_0 (WDataAckT_0 \~WAck_0) inv_1xt
I16_1 (\~RW_1 RWT_1) inv_1xt
I16_0 (\~RW_0 RWT_0) inv_1xt
I14_19 (\~A_19 AT_19) inv_1xt
I14_18 (\~A_18 AT_18) inv_1xt
I14_17 (\~A_17 AT_17) inv_1xt
I14_16 (\~A_16 AT_16) inv_1xt
I14_15 (\~A_15 AT_15) inv_1xt
I14_14 (\~A_14 AT_14) inv_1xt
I14_13 (\~A_13 AT_13) inv_1xt
I14_12 (\~A_12 AT_12) inv_1xt
I14_11 (\~A_11 AT_11) inv_1xt
I14_10 (\~A_10 AT_10) inv_1xt
I14_9 (\~A_9 AT_9) inv_1xt
I14_8 (\~A_8 AT_8) inv_1xt
I14_7 (\~A_7 AT_7) inv_1xt
I14_6 (\~A_6 AT_6) inv_1xt
I14_5 (\~A_5 AT_5) inv_1xt
I14_4 (\~A_4 AT_4) inv_1xt
I14_3 (\~A_3 AT_3) inv_1xt
I14_2 (\~A_2 AT_2) inv_1xt
I14_1 (\~A_1 AT_1) inv_1xt
I14_0 (\~A_0 AT_0) inv_1xt
I13 (AckT \~Ack) inv_1xt
I6_31 (ReaDataT_31 \~ReadData_31) inv_1xt
I6_30 (ReaDataT_30 \~ReadData_30) inv_1xt
I6_29 (ReaDataT_29 \~ReadData_29) inv_1xt
I6_28 (ReaDataT_28 \~ReadData_28) inv_1xt
I6_27 (ReaDataT_27 \~ReadData_27) inv_1xt
I6_26 (ReaDataT_26 \~ReadData_26) inv_1xt
I6_25 (ReaDataT_25 \~ReadData_25) inv_1xt
I6_24 (ReaDataT_24 \~ReadData_24) inv_1xt
I6_23 (ReaDataT_23 \~ReadData_23) inv_1xt
I6_22 (ReaDataT_22 \~ReadData_22) inv_1xt
I6_21 (ReaDataT_21 \~ReadData_21) inv_1xt
I6_20 (ReaDataT_20 \~ReadData_20) inv_1xt
I6_19 (ReaDataT_19 \~ReadData_19) inv_1xt
I6_18 (ReaDataT_18 \~ReadData_18) inv_1xt
I6_17 (ReaDataT_17 \~ReadData_17) inv_1xt
I6_16 (ReaDataT_16 \~ReadData_16) inv_1xt
I6_15 (ReaDataT_15 \~ReadData_15) inv_1xt
I6_14 (ReaDataT_14 \~ReadData_14) inv_1xt
I6_13 (ReaDataT_13 \~ReadData_13) inv_1xt
I6_12 (ReaDataT_12 \~ReadData_12) inv_1xt
I6_11 (ReaDataT_11 \~ReadData_11) inv_1xt
I6_10 (ReaDataT_10 \~ReadData_10) inv_1xt
I6_9 (ReaDataT_9 \~ReadData_9) inv_1xt
I6_8 (ReaDataT_8 \~ReadData_8) inv_1xt
I6_7 (ReaDataT_7 \~ReadData_7) inv_1xt
I6_6 (ReaDataT_6 \~ReadData_6) inv_1xt
I6_5 (ReaDataT_5 \~ReadData_5) inv_1xt
I6_4 (ReaDataT_4 \~ReadData_4) inv_1xt
I6_3 (ReaDataT_3 \~ReadData_3) inv_1xt
I6_2 (ReaDataT_2 \~ReadData_2) inv_1xt
I6_1 (ReaDataT_1 \~ReadData_1) inv_1xt
I6_0 (ReaDataT_0 \~ReadData_0) inv_1xt
I5_31 (\~WriteData_31 WriteDataT_31) inv_1xt
I5_30 (\~WriteData_30 WriteDataT_30) inv_1xt
I5_29 (\~WriteData_29 WriteDataT_29) inv_1xt
I5_28 (\~WriteData_28 WriteDataT_28) inv_1xt
I5_27 (\~WriteData_27 WriteDataT_27) inv_1xt
I5_26 (\~WriteData_26 WriteDataT_26) inv_1xt
I5_25 (\~WriteData_25 WriteDataT_25) inv_1xt
I5_24 (\~WriteData_24 WriteDataT_24) inv_1xt
I5_23 (\~WriteData_23 WriteDataT_23) inv_1xt
I5_22 (\~WriteData_22 WriteDataT_22) inv_1xt
I5_21 (\~WriteData_21 WriteDataT_21) inv_1xt
I5_20 (\~WriteData_20 WriteDataT_20) inv_1xt
I5_19 (\~WriteData_19 WriteDataT_19) inv_1xt
I5_18 (\~WriteData_18 WriteDataT_18) inv_1xt
I5_17 (\~WriteData_17 WriteDataT_17) inv_1xt
I5_16 (\~WriteData_16 WriteDataT_16) inv_1xt
I5_15 (\~WriteData_15 WriteDataT_15) inv_1xt
I5_14 (\~WriteData_14 WriteDataT_14) inv_1xt
I5_13 (\~WriteData_13 WriteDataT_13) inv_1xt
I5_12 (\~WriteData_12 WriteDataT_12) inv_1xt
I5_11 (\~WriteData_11 WriteDataT_11) inv_1xt
I5_10 (\~WriteData_10 WriteDataT_10) inv_1xt
I5_9 (\~WriteData_9 WriteDataT_9) inv_1xt
I5_8 (\~WriteData_8 WriteDataT_8) inv_1xt
I5_7 (\~WriteData_7 WriteDataT_7) inv_1xt
I5_6 (\~WriteData_6 WriteDataT_6) inv_1xt
I5_5 (\~WriteData_5 WriteDataT_5) inv_1xt
I5_4 (\~WriteData_4 WriteDataT_4) inv_1xt
I5_3 (\~WriteData_3 WriteDataT_3) inv_1xt
I5_2 (\~WriteData_2 WriteDataT_2) inv_1xt
I5_1 (\~WriteData_1 WriteDataT_1) inv_1xt
I5_0 (\~WriteData_0 WriteDataT_0) inv_1xt
// BEGIN Hierarchical Interface Elements
_ie99892 (\~WriteData_14 0) d2a src="99892" val0=0.0 val1=vdd valx=vdd/2 rise=2p fall=2p
_ie99893 (\~A_0 0) d2a src="99893" val0=0.0 val1=vdd valx=vdd/2 rise=2p fall=2p
_ie99894 (\~WriteData_2 0) d2a src="99894" val0=0.0 val1=vdd valx=vdd/2 rise=2p fall=2p
_ie99895 (\~ReadData_31 0) a2d dest="99895" vl=0.3*vdd vh=0.7*vdd timex=20n
_ie99896 (\~ReadData_2 0) a2d dest="99896" vl=0.3*vdd vh=0.7*vdd timex=20n
_ie99897 (\~ReadData_28 0) a2d dest="99897" vl=0.3*vdd vh=0.7*vdd timex=20n
_ie99898 (net013_4 0) a2d dest="99898" vl=0.3*vdd vh=0.7*vdd timex=20n
_ie99899 (\~ReadData_30 0) a2d dest="99899" vl=0.3*vdd vh=0.7*vdd timex=20n
_ie99900 (\~A_1 0) d2a src="99900" val0=0.0 val1=vdd valx=vdd/2 rise=2p fall=2p
_ie99901 (\~RAck_1 0) d2a src="99901" val0=0.0 val1=vdd valx=vdd/2 rise=2p fall=2p
_ie99902 (\~WriteData_25 0) d2a src="99902" val0=0.0 val1=vdd valx=vdd/2 rise=2p fall=2p
_ie99903 (net013_3 0) a2d dest="99903" vl=0.3*vdd vh=0.7*vdd timex=20n
_ie99904 (\~WriteData_21 0) d2a src="99904" val0=0.0 val1=vdd valx=vdd/2 rise=2p fall=2p
_ie99905 (\~WriteData_5 0) d2a src="99905" val0=0.0 val1=vdd valx=vdd/2 rise=2p fall=2p
_ie99906 (\~WriteData_18 0) d2a src="99906" val0=0.0 val1=vdd valx=vdd/2 rise=2p fall=2p
_ie99907 (\~WriteData_26 0) d2a src="99907" val0=0.0 val1=vdd valx=vdd/2 rise=2p fall=2p
_ie99908 (\~ReadData_12 0) a2d dest="99908" vl=0.3*vdd vh=0.7*vdd timex=20n
_ie99909 (\~A_18 0) d2a src="99909" val0=0.0 val1=vdd valx=vdd/2 rise=2p fall=2p
_ie99910 (\~WriteData_3 0) d2a src="99910" val0=0.0 val1=vdd valx=vdd/2 rise=2p fall=2p
_ie99911 (\~A_17 0) d2a src="99911" val0=0.0 val1=vdd valx=vdd/2 rise=2p fall=2p
_ie99912 (\~WriteData_31 0) d2a src="99912" val0=0.0 val1=vdd valx=vdd/2 rise=2p fall=2p
_ie99913 (net013_2 0) a2d dest="99913" vl=0.3*vdd vh=0.7*vdd timex=20n
_ie99914 (\~WriteData_24 0) d2a src="99914" val0=0.0 val1=vdd valx=vdd/2 rise=2p fall=2p
_ie99915 (\~WriteData_23 0) d2a src="99915" val0=0.0 val1=vdd valx=vdd/2 rise=2p fall=2p
_ie99916 (\~RAck_2 0) d2a src="99916" val0=0.0 val1=vdd valx=vdd/2 rise=2p fall=2p
_ie99917 (\~WriteData_20 0) d2a src="99917" val0=0.0 val1=vdd valx=vdd/2 rise=2p fall=2p
_ie99918 (\~A_12 0) d2a src="99918" val0=0.0 val1=vdd valx=vdd/2 rise=2p fall=2p
_ie99919 (net013_0 0) a2d dest="99919" vl=0.3*vdd vh=0.7*vdd timex=20n
_ie99920 (\~WAck_1 0) a2d dest="99920" vl=0.3*vdd vh=0.7*vdd timex=20n
_ie99921 (\~WriteData_6 0) d2a src="99921" val0=0.0 val1=vdd valx=vdd/2 rise=2p fall=2p
_ie99922 (\~WriteData_16 0) d2a src="99922" val0=0.0 val1=vdd valx=vdd/2 rise=2p fall=2p
_ie99923 (\~RAck_6 0) d2a src="99923" val0=0.0 val1=vdd valx=vdd/2 rise=2p fall=2p
_ie99924 (\~ReadData_4 0) a2d dest="99924" vl=0.3*vdd vh=0.7*vdd timex=20n
_ie99925 (\~WAck_7 0) a2d dest="99925" vl=0.3*vdd vh=0.7*vdd timex=20n
_ie99926 (\~ReadData_26 0) a2d dest="99926" vl=0.3*vdd vh=0.7*vdd timex=20n
_ie99927 (\~ReadData_14 0) a2d dest="99927" vl=0.3*vdd vh=0.7*vdd timex=20n
_ie99928 (\~WriteData_8 0) d2a src="99928" val0=0.0 val1=vdd valx=vdd/2 rise=2p fall=2p
_ie99929 (\~WAck_6 0) a2d dest="99929" vl=0.3*vdd vh=0.7*vdd timex=20n
_ie99930 (\~ReadData_8 0) a2d dest="99930" vl=0.3*vdd vh=0.7*vdd timex=20n
_ie99931 (\~ReadData_6 0) a2d dest="99931" vl=0.3*vdd vh=0.7*vdd timex=20n
_ie99932 (\~A_3 0) d2a src="99932" val0=0.0 val1=vdd valx=vdd/2 rise=2p fall=2p
_ie99933 (\~ReadData_5 0) a2d dest="99933" vl=0.3*vdd vh=0.7*vdd timex=20n
_ie99934 (\~ReadData_1 0) a2d dest="99934" vl=0.3*vdd vh=0.7*vdd timex=20n
_ie99935 (\~WriteData_12 0) d2a src="99935" val0=0.0 val1=vdd valx=vdd/2 rise=2p fall=2p
_ie99936 (\~Ack 0) a2d dest="99936" vl=0.3*vdd vh=0.7*vdd timex=20n
_ie99937 (\~WriteData_30 0) d2a src="99937" val0=0.0 val1=vdd valx=vdd/2 rise=2p fall=2p
_ie99938 (\~WAck_0 0) a2d dest="99938" vl=0.3*vdd vh=0.7*vdd timex=20n
_ie99939 (\~ReadData_9 0) a2d dest="99939" vl=0.3*vdd vh=0.7*vdd timex=20n
_ie99940 (\~RAck_7 0) d2a src="99940" val0=0.0 val1=vdd valx=vdd/2 rise=2p fall=2p
_ie99941 (\~A_7 0) d2a src="99941" val0=0.0 val1=vdd valx=vdd/2 rise=2p fall=2p
_ie99942 (\~ReadData_0 0) a2d dest="99942" vl=0.3*vdd vh=0.7*vdd timex=20n
_ie99943 (\~ReadData_16 0) a2d dest="99943" vl=0.3*vdd vh=0.7*vdd timex=20n
_ie99944 (\~ReadData_13 0) a2d dest="99944" vl=0.3*vdd vh=0.7*vdd timex=20n
_ie99945 (\~RAck_4 0) d2a src="99945" val0=0.0 val1=vdd valx=vdd/2 rise=2p fall=2p
_ie99946 (\~ReadData_17 0) a2d dest="99946" vl=0.3*vdd vh=0.7*vdd timex=20n
_ie99947 (\~ReadData_29 0) a2d dest="99947" vl=0.3*vdd vh=0.7*vdd timex=20n
_ie99948 (\~ReadData_18 0) a2d dest="99948" vl=0.3*vdd vh=0.7*vdd timex=20n
_ie99949 (\~ReadData_19 0) a2d dest="99949" vl=0.3*vdd vh=0.7*vdd timex=20n
_ie99950 (\~WriteData_4 0) d2a src="99950" val0=0.0 val1=vdd valx=vdd/2 rise=2p fall=2p
_ie99951 (\~WriteData_9 0) d2a src="99951" val0=0.0 val1=vdd valx=vdd/2 rise=2p fall=2p
_ie99952 (\~WAck_2 0) a2d dest="99952" vl=0.3*vdd vh=0.7*vdd timex=20n
_ie99953 (\~ReadData_21 0) a2d dest="99953" vl=0.3*vdd vh=0.7*vdd timex=20n
_ie99954 (\~RW_0 0) d2a src="99954" val0=0.0 val1=vdd valx=vdd/2 rise=2p fall=2p
_ie99955 (\~ReadData_22 0) a2d dest="99955" vl=0.3*vdd vh=0.7*vdd timex=20n
_ie99956 (\~WAck_3 0) a2d dest="99956" vl=0.3*vdd vh=0.7*vdd timex=20n
_ie99957 (\~A_14 0) d2a src="99957" val0=0.0 val1=vdd valx=vdd/2 rise=2p fall=2p
_ie99958 (\~A_2 0) d2a src="99958" val0=0.0 val1=vdd valx=vdd/2 rise=2p fall=2p
_ie99959 (\~WriteData_0 0) d2a src="99959" val0=0.0 val1=vdd valx=vdd/2 rise=2p fall=2p
_ie99960 (\~ReadData_15 0) a2d dest="99960" vl=0.3*vdd vh=0.7*vdd timex=20n
_ie99961 (\~WriteData_15 0) d2a src="99961" val0=0.0 val1=vdd valx=vdd/2 rise=2p fall=2p
_ie99962 (\~WriteData_22 0) d2a src="99962" val0=0.0 val1=vdd valx=vdd/2 rise=2p fall=2p
_ie99963 (\~WAck_4 0) a2d dest="99963" vl=0.3*vdd vh=0.7*vdd timex=20n
_ie99964 (\~WriteData_1 0) d2a src="99964" val0=0.0 val1=vdd valx=vdd/2 rise=2p fall=2p
_ie99965 (\~WriteData_10 0) d2a src="99965" val0=0.0 val1=vdd valx=vdd/2 rise=2p fall=2p
_ie99966 (\~ReadData_27 0) a2d dest="99966" vl=0.3*vdd vh=0.7*vdd timex=20n
_ie99967 (\~WriteData_29 0) d2a src="99967" val0=0.0 val1=vdd valx=vdd/2 rise=2p fall=2p
_ie99968 (\~WriteData_7 0) d2a src="99968" val0=0.0 val1=vdd valx=vdd/2 rise=2p fall=2p
_ie99969 (\~A_9 0) d2a src="99969" val0=0.0 val1=vdd valx=vdd/2 rise=2p fall=2p
_ie99970 (\~A_10 0) d2a src="99970" val0=0.0 val1=vdd valx=vdd/2 rise=2p fall=2p
_ie99971 (\~ReadData_7 0) a2d dest="99971" vl=0.3*vdd vh=0.7*vdd timex=20n
_ie99972 (\~WriteData_19 0) d2a src="99972" val0=0.0 val1=vdd valx=vdd/2 rise=2p fall=2p
_ie99973 (\~A_11 0) d2a src="99973" val0=0.0 val1=vdd valx=vdd/2 rise=2p fall=2p
_ie99974 (\~ReadData_11 0) a2d dest="99974" vl=0.3*vdd vh=0.7*vdd timex=20n
_ie99975 (\~ReadData_25 0) a2d dest="99975" vl=0.3*vdd vh=0.7*vdd timex=20n
_ie99976 (\~WriteData_27 0) d2a src="99976" val0=0.0 val1=vdd valx=vdd/2 rise=2p fall=2p
_ie99977 (\~ReadData_23 0) a2d dest="99977" vl=0.3*vdd vh=0.7*vdd timex=20n
_ie99978 (\~A_16 0) d2a src="99978" val0=0.0 val1=vdd valx=vdd/2 rise=2p fall=2p
_ie99979 (\~WriteData_28 0) d2a src="99979" val0=0.0 val1=vdd valx=vdd/2 rise=2p fall=2p
_ie99980 (\~A_6 0) d2a src="99980" val0=0.0 val1=vdd valx=vdd/2 rise=2p fall=2p
_ie99981 (\~ReadData_24 0) a2d dest="99981" vl=0.3*vdd vh=0.7*vdd timex=20n
_ie99982 (\~WAck_5 0) a2d dest="99982" vl=0.3*vdd vh=0.7*vdd timex=20n
_ie99983 (\~RAck_5 0) d2a src="99983" val0=0.0 val1=vdd valx=vdd/2 rise=2p fall=2p
_ie99984 (\~RAck_3 0) d2a src="99984" val0=0.0 val1=vdd valx=vdd/2 rise=2p fall=2p
_ie99985 (\~A_15 0) d2a src="99985" val0=0.0 val1=vdd valx=vdd/2 rise=2p fall=2p
_ie99986 (\~ReadData_20 0) a2d dest="99986" vl=0.3*vdd vh=0.7*vdd timex=20n
_ie99987 (net013_1 0) a2d dest="99987" vl=0.3*vdd vh=0.7*vdd timex=20n
_ie99988 (\~RW_1 0) d2a src="99988" val0=0.0 val1=vdd valx=vdd/2 rise=2p fall=2p
_ie99989 (\~A_5 0) d2a src="99989" val0=0.0 val1=vdd valx=vdd/2 rise=2p fall=2p
_ie99990 (\~A_19 0) d2a src="99990" val0=0.0 val1=vdd valx=vdd/2 rise=2p fall=2p
_ie99991 (\~RAck_0 0) d2a src="99991" val0=0.0 val1=vdd valx=vdd/2 rise=2p fall=2p
_ie99992 (\~A_13 0) d2a src="99992" val0=0.0 val1=vdd valx=vdd/2 rise=2p fall=2p
_ie99993 (\~A_8 0) d2a src="99993" val0=0.0 val1=vdd valx=vdd/2 rise=2p fall=2p
_ie99994 (\~WriteData_17 0) d2a src="99994" val0=0.0 val1=vdd valx=vdd/2 rise=2p fall=2p
_ie99995 (\~WriteData_13 0) d2a src="99995" val0=0.0 val1=vdd valx=vdd/2 rise=2p fall=2p
_ie99996 (\~A_4 0) d2a src="99996" val0=0.0 val1=vdd valx=vdd/2 rise=2p fall=2p
_ie99997 (\~ReadData_3 0) a2d dest="99997" vl=0.3*vdd vh=0.7*vdd timex=20n
_ie99998 (\~WriteData_11 0) d2a src="99998" val0=0.0 val1=vdd valx=vdd/2 rise=2p fall=2p
_ie99999 (\~ReadData_10 0) a2d dest="99999" vl=0.3*vdd vh=0.7*vdd timex=20n
// END Hierarchical Interface Elements
ic IBank.IDATA0.IWPCHB1_1.inValid=0 IBank.IDATA0.IWPCHB1_1.outValid=0 IBank.IDATA0.IWPCHB1_1.oE=vdd IBank.IDATA0.IWPCHB1_1.net027=vdd IBank.IDATA0.IWPCHB1_1.inAck=vdd IBank.IDATA0.intWack=vdd IBank.IDATA0.intRack=vdd IBank.IDATA0.IWPCHB0_1.inValid=0 IBank.IDATA0.IWPCHB0_1.outValid=0 IBank.IDATA0.IWWCHB1.b1_1=vdd IBank.IDATA0.IWWCHB1.b1_0=vdd IBank.IDATA0.IWWCHB1.b0_0=vdd IBank.IDATA0.IWWCHB1.b0_1=vdd IBank.IDATA0.IWWCHB1.nxa=vdd IBank.IDATA0.IWWCHB1.n_0=0 IBank.IDATA0.IWWCHB1.n_1=0 IBank.IDATA0.IWWCHB1.n_2=0 IBank.IDATA0.IWWCHB1.n_3=0 IBank.IDATA0.IWWCHB1.\~Out1_0=vdd IBank.IDATA0.IWWCHB1.\~Out0_0=vdd IBank.IDATA0.IWWCHB1.\~Out1_1=vdd IBank.IDATA0.IWWCHB1.\~Out0_1=vdd IBank.IDATA0.IRPCHB_3.\~ack=vdd IBank.IDATA0.IRPCHB_3.oE=vdd IBank.IDATA0.IRPCHB_3.inValid=0 IBank.IDATA0.IRPCHB_3.outValid=0 IBank.IDATA0.IRWCHB_1.outAck=vdd IBank.IDATA0.IRWCHB_1.\~Out_0=vdd IBank.IDATA0.IRWCHB_1.\~Out_1=vdd IBank.IDATA0.IRWCHB_1.\~Out_2=vdd IBank.IDATA0.IRWCHB_1.\~Out_3=vdd IBank.IDATA0.IRWCHB_1.m_1=vdd IBank.IDATA0.IRWCHB_1.m_2=vdd IBank.IDATA0.IRWCHB_1.m_3=vdd IBank.IDATA0.IRWCHB_1.m_0=vdd IBank.IDATA0.IRWCHB_1.n0_0=0 IBank.IDATA0.IRWCHB_1.n1_0=0 IBank.IDATA0.IRWCHB_1.n0_1=0 IBank.IDATA0.IRWCHB_1.n1_1=0 IBank.ICHUNK0.IARRAY0.ISRAM0.I7.I3.Q1=vdd IBank.ICHUNK0.IARRAY0.ISRAM0.I7.I3.Q0=0 IBank.IDATA0.IWWCHB0.n_0=0 IBank.IDATA0.IWWCHB0.n_1=0 IBank.IDATA0.IWWCHB0.n_2=0 IBank.IDATA0.IWWCHB0.n_3=0 IBank.IDATA0.IWWCHB0.nxa=vdd IBank.IDATA0.IWWCHB0.b0_0=vdd IBank.IDATA0.IWWCHB0.b1_1=vdd IBank.IDATA0.IWWCHB0.b0_1=vdd IBank.IDATA0.IWWCHB0.b1_0=vdd IBank.IDATA0.IWWCHB0.\~Out1_0=vdd IBank.IDATA0.IWWCHB0.\~Out0_0=vdd IBank.IDATA0.IWWCHB0.\~Out1_1=vdd IBank.IDATA0.IWWCHB0.\~Out0_1=vdd IBank.IDATA0.IWPCHB0_1.oE=vdd IBank.IDATA0.IWPCHB0_1.inAck=vdd IBank.IDATA0.IWPCHB0_1.net027=vdd IBank.IDATA0.RpAck_3=vdd IBank.IDATA0.RpAck_2=vdd IBank.IDATA0.RpAck_1=vdd IBank.IDATA0.RpAck_0=vdd IBank.IDATA0.R0q_3=0 IBank.IDATA0.R0q_2=0 IBank.IDATA0.R0q_1=0 IBank.IDATA0.R0q_0=0 IBank.IDATA0.R1q_3=0 IBank.IDATA0.R1q_2=0 IBank.IDATA0.R1q_1=0 IBank.IDATA0.R1q_0=0 IBank.IDATA0.R0_3=0 IBank.IDATA0.R0_2=0 IBank.IDATA0.R0_1=0 IBank.IDATA0.R0_0=0 IBank.IDATA0.R1_3=0 IBank.IDATA0.R1_2=0 IBank.IDATA0.R1_1=0 IBank.IDATA0.R1_0=0 IBank.IDATA0.Lack_3=0 IBank.IDATA0.Lack_2=0 IBank.IDATA0.Lack_1=0 IBank.IDATA0.Lack_0=0 IBank.IDATA0.nB1_1=0 IBank.IDATA0.nB1_0=0 IBank.IDATA0.nB0_1=0 IBank.IDATA0.nB0_0=0 IBank.IDATA0.nB1_3=0 IBank.IDATA0.nB1_2=0 IBank.IDATA0.nB0_3=0 IBank.IDATA0.nB0_2=0 IBank.IDATA0.wack_3=0 IBank.IDATA0.wack_2=0 IBank.IDATA0.Wen=0 IBank.IDATA0.wack_1=0 IBank.IDATA0.wack_0=0 IBank.S_4_7=0 IBank.S_4_6=0 IBank.S_4_5=0 IBank.S_4_4=0 IBank.S_4_3=0 IBank.S_4_2=0 IBank.S_4_1=0 IBank.S_4_0=0 IBank.A_4_63=0 IBank.A_4_62=0 IBank.A_4_61=0 IBank.A_4_60=0 IBank.A_4_59=0 IBank.A_4_58=0 IBank.A_4_57=0 IBank.A_4_56=0 IBank.A_4_55=0 IBank.A_4_54=0 IBank.A_4_53=0 IBank.A_4_52=0 IBank.A_4_51=0 IBank.A_4_50=0 IBank.A_4_49=0 IBank.A_4_48=0 IBank.A_4_47=0 IBank.A_4_46=0 IBank.A_4_45=0 IBank.A_4_44=0 IBank.A_4_43=0 IBank.A_4_42=0 IBank.A_4_41=0 IBank.A_4_40=0 IBank.A_4_39=0 IBank.A_4_38=0 IBank.A_4_37=0 IBank.A_4_36=0 IBank.A_4_35=0 IBank.A_4_34=0 IBank.A_4_33=0 IBank.A_4_32=0 IBank.A_4_31=0 IBank.A_4_30=0 IBank.A_4_29=0 IBank.A_4_28=0 IBank.A_4_27=0 IBank.A_4_26=0 IBank.A_4_25=0 IBank.A_4_24=0 IBank.A_4_23=0 IBank.A_4_22=0 IBank.A_4_21=0 IBank.A_4_20=0 IBank.A_4_19=0 IBank.A_4_18=0 IBank.A_4_17=0 IBank.A_4_16=0 IBank.A_4_15=0 IBank.A_4_14=0 IBank.A_4_13=0 IBank.A_4_12=0 IBank.A_4_11=0 IBank.A_4_10=0 IBank.A_4_9=0 IBank.A_4_8=0 IBank.A_4_7=0 IBank.A_4_6=0 IBank.A_4_5=0 IBank.A_4_4=0 IBank.A_4_3=0 IBank.A_4_2=0 IBank.A_4_1=0 IBank.A_4_0=0 IBank.S_3_7=0 IBank.S_3_6=0 IBank.S_3_5=0 IBank.S_3_4=0 IBank.S_3_3=0 IBank.S_3_2=0 IBank.S_3_1=0 IBank.S_3_0=0 IBank.A_3_63=0 IBank.A_3_62=0 IBank.A_3_61=0 IBank.A_3_60=0 IBank.A_3_59=0 IBank.A_3_58=0 IBank.A_3_57=0 IBank.A_3_56=0 IBank.A_3_55=0 IBank.A_3_54=0 IBank.A_3_53=0 IBank.A_3_52=0 IBank.A_3_51=0 IBank.A_3_50=0 IBank.A_3_49=0 IBank.A_3_48=0 IBank.A_3_47=0 IBank.A_3_46=0 IBank.A_3_45=0 IBank.A_3_44=0 IBank.A_3_43=0 IBank.A_3_42=0 IBank.A_3_41=0 IBank.A_3_40=0 IBank.A_3_39=0 IBank.A_3_38=0 IBank.A_3_37=0 IBank.A_3_36=0 IBank.A_3_35=0 IBank.A_3_34=0 IBank.A_3_33=0 IBank.A_3_32=0 IBank.A_3_31=0 IBank.A_3_30=0 IBank.A_3_29=0 IBank.A_3_28=0 IBank.A_3_27=0 IBank.A_3_26=0 IBank.A_3_25=0 IBank.A_3_24=0 IBank.A_3_23=0 IBank.A_3_22=0 IBank.A_3_21=0 IBank.A_3_20=0 IBank.A_3_19=0 IBank.A_3_18=0 IBank.A_3_17=0 IBank.A_3_16=0 IBank.A_3_15=0 IBank.A_3_14=0 IBank.A_3_13=0 IBank.A_3_12=0 IBank.A_3_11=0 IBank.A_3_10=0 IBank.A_3_9=0 IBank.A_3_8=0 IBank.A_3_7=0 IBank.A_3_6=0 IBank.A_3_5=0 IBank.A_3_4=0 IBank.A_3_3=0 IBank.A_3_2=0 IBank.A_3_1=0 IBank.A_3_0=0 IBank.S_2_7=0 IBank.S_2_6=0 IBank.S_2_5=0 IBank.S_2_4=0 IBank.S_2_3=0 IBank.S_2_2=0 IBank.S_2_1=0 IBank.S_2_0=0 IBank.A_2_63=0 IBank.A_2_62=0 IBank.A_2_61=0 IBank.A_2_60=0 IBank.A_2_59=0 IBank.A_2_58=0 IBank.A_2_57=0 IBank.A_2_56=0 IBank.A_2_55=0 IBank.A_2_54=0 IBank.A_2_53=0 IBank.A_2_52=0 IBank.A_2_51=0 IBank.A_2_50=0 IBank.A_2_49=0 IBank.A_2_48=0 IBank.A_2_47=0 IBank.A_2_46=0 IBank.A_2_45=0 IBank.A_2_44=0 IBank.A_2_43=0 IBank.A_2_42=0 IBank.A_2_41=0 IBank.A_2_40=0 IBank.A_2_39=0 IBank.A_2_38=0 IBank.A_2_37=0 IBank.A_2_36=0 IBank.A_2_35=0 IBank.A_2_34=0 IBank.A_2_33=0 IBank.A_2_32=0 IBank.A_2_31=0 IBank.A_2_30=0 IBank.A_2_29=0 IBank.A_2_28=0 IBank.A_2_27=0 IBank.A_2_26=0 IBank.A_2_25=0 IBank.A_2_24=0 IBank.A_2_23=0 IBank.A_2_22=0 IBank.A_2_21=0 IBank.A_2_20=0 IBank.A_2_19=0 IBank.A_2_18=0 IBank.A_2_17=0 IBank.A_2_16=0 IBank.A_2_15=0 IBank.A_2_14=0 IBank.A_2_13=0 IBank.A_2_12=0 IBank.A_2_11=0 IBank.A_2_10=0 IBank.A_2_9=0 IBank.A_2_8=0 IBank.A_2_7=0 IBank.A_2_6=0 IBank.A_2_5=0 IBank.A_2_4=0 IBank.A_2_3=0 IBank.A_2_2=0 IBank.A_2_1=0 IBank.A_2_0=0 CtrlAckT_4=vdd CtrlAckT_3=vdd CtrlAckT_2=vdd CtrlAckT_1=vdd CtrlAckT_0=vdd AckT=0 AckT=0 IBank.\~R1_4_3=vdd IBank.\~R1_4_2=vdd IBank.\~R1_4_1=vdd IBank.\~R1_4_0=vdd IBank.\~R0_4_3=vdd IBank.\~R0_4_2=vdd IBank.\~R0_4_1=vdd IBank.\~R0_4_0=vdd IBank.\~R1_3_3=vdd IBank.\~R1_3_2=vdd IBank.\~R1_3_1=vdd IBank.\~R1_3_0=vdd IBank.\~R0_3_3=vdd IBank.\~R0_3_2=vdd IBank.\~R0_3_1=vdd IBank.\~R0_3_0=vdd IBank.\~R1_2_3=vdd IBank.\~R1_2_2=vdd IBank.\~R1_2_1=vdd IBank.\~R1_2_0=vdd IBank.\~R0_2_3=vdd IBank.\~R0_2_2=vdd IBank.\~R0_2_1=vdd IBank.\~R0_2_0=vdd IBank.\~R0_1_3=vdd IBank.\~R0_1_2=vdd IBank.\~R0_1_1=vdd IBank.\~R0_1_0=vdd IBank.\~R1_1_3=vdd IBank.\~R1_1_2=vdd IBank.\~R1_1_1=vdd IBank.\~R1_1_0=vdd ReadDataAckT_7=0 ReadDataAckT_6=0 WDataAckT_7=0 WDataAckT_6=0 ReadDataAckT_5=0 ReadDataAckT_4=0 WDataAckT_5=0 WDataAckT_4=0 ReadDataAckT_3=0 ReadDataAckT_2=0 WDataAckT_3=0 WDataAckT_2=0 ReaDataT_3=0 ReaDataT_2=0 ReaDataT_1=0 ReaDataT_0=0 ReaDataT_7=0 ReaDataT_6=0 ReaDataT_5=0 ReaDataT_4=0 WDataAckT_1=0 WDataAckT_0=0 WriteDataT_7=0 WriteDataT_6=0 WriteDataT_5=0 WriteDataT_4=0 WriteDataT_3=0 WriteDataT_2=0 WriteDataT_1=0 WriteDataT_0=0 ReadDataAckT_1=0 ReadDataAckT_0=0 ReaDataT_31=0 ReaDataT_30=0 ReaDataT_29=0 ReaDataT_28=0 ReaDataT_27=0 ReaDataT_26=0 ReaDataT_25=0 ReaDataT_24=0 ReaDataT_23=0 ReaDataT_22=0 ReaDataT_21=0 ReaDataT_20=0 ReaDataT_19=0 ReaDataT_18=0 ReaDataT_17=0 ReaDataT_16=0 ReaDataT_15=0 ReaDataT_14=0 ReaDataT_13=0 ReaDataT_12=0 ReaDataT_11=0 ReaDataT_10=0 ReaDataT_9=0 ReaDataT_8=0 WriteDataT_31=0 WriteDataT_30=0 WriteDataT_29=0 WriteDataT_28=0 WriteDataT_27=0 WriteDataT_26=0 WriteDataT_25=0 WriteDataT_24=0 WriteDataT_23=0 WriteDataT_22=0 WriteDataT_21=0 WriteDataT_20=0 WriteDataT_19=0 WriteDataT_18=0 WriteDataT_17=0 WriteDataT_16=0 WriteDataT_15=0 WriteDataT_14=0 WriteDataT_13=0 WriteDataT_12=0 WriteDataT_11=0 WriteDataT_10=0 WriteDataT_9=0 WriteDataT_8=0 IBank.net042=0 IBank.G04=0 IBank.B1_4_3=0 IBank.B1_4_2=0 IBank.B1_4_1=0 IBank.B1_4_0=0 IBank.B0_4_3=0 IBank.B0_4_2=0 IBank.B0_4_1=0 IBank.B0_4_0=0 IBank.W1_4_3=0 IBank.W1_4_2=0 IBank.W1_4_1=0 IBank.W1_4_0=0 IBank.W0_4_3=0 IBank.W0_4_2=0 IBank.W0_4_1=0 IBank.W0_4_0=0 IBank.B1_3_3=0 IBank.B1_3_2=0 IBank.B1_3_1=0 IBank.B1_3_0=0 IBank.B0_3_3=0 IBank.B0_3_2=0 IBank.B0_3_1=0 IBank.B0_3_0=0 IBank.W0_3_3=0 IBank.W0_3_2=0 IBank.W0_3_1=0 IBank.W0_3_0=0 IBank.W1_3_3=0 IBank.W1_3_2=0 IBank.W1_3_1=0 IBank.W1_3_0=0 IBank.G03=0 IBank.ck_3=0 IBank.ck_2=0 IBank.Reset=0 IBank.ck_1=0 IBank.ck_0=0 IBank.ValAddr=0 IBank.RW_1=0 IBank.RW_0=0 RWT_1=0 RWT_0=0 IBank.A_1_63=0 IBank.A_1_62=0 IBank.A_1_61=0 IBank.A_1_60=0 IBank.A_1_59=0 IBank.A_1_58=0 IBank.A_1_57=0 IBank.A_1_56=0 IBank.A_1_55=0 IBank.A_1_54=0 IBank.A_1_53=0 IBank.A_1_52=0 IBank.A_1_51=0 IBank.A_1_50=0 IBank.A_1_49=0 IBank.A_1_48=0 IBank.A_1_47=0 IBank.A_1_46=0 IBank.A_1_45=0 IBank.A_1_44=0 IBank.A_1_43=0 IBank.A_1_42=0 IBank.A_1_41=0 IBank.A_1_40=0 IBank.A_1_39=0 IBank.A_1_38=0 IBank.A_1_37=0 IBank.A_1_36=0 IBank.A_1_35=0 IBank.A_1_34=0 IBank.A_1_33=0 IBank.A_1_32=0 IBank.A_1_31=0 IBank.A_1_30=0 IBank.A_1_29=0 IBank.A_1_28=0 IBank.A_1_27=0 IBank.A_1_26=0 IBank.A_1_25=0 IBank.A_1_24=0 IBank.A_1_23=0 IBank.A_1_22=0 IBank.A_1_21=0 IBank.A_1_20=0 IBank.A_1_19=0 IBank.A_1_18=0 IBank.A_1_17=0 IBank.A_1_16=0 IBank.A_1_15=0 IBank.A_1_14=0 IBank.A_1_13=0 IBank.A_1_12=0 IBank.A_1_11=0 IBank.A_1_10=0 IBank.A_1_9=0 IBank.A_1_8=0 IBank.A_1_7=0 IBank.A_1_6=0 IBank.A_1_5=0 IBank.A_1_4=0 IBank.A_1_3=0 IBank.A_1_2=0 IBank.A_1_1=0 IBank.A_1_0=0 IBank.S_1_7=0 IBank.S_1_6=0 IBank.S_1_5=0 IBank.S_1_4=0 IBank.S_1_3=0 IBank.S_1_2=0 IBank.S_1_1=0 IBank.S_1_0=0 AT_16=0 IBank.AvAck_0=0 AT_7=0 AT_6=0 AT_5=0 AT_4=0 AT_3=0 AT_2=0 AT_1=0 AT_0=0 AT_11=0 AT_10=0 AT_9=0 AT_8=0 AT_15=0 AT_14=0 AT_13=0 AT_12=0 IBank.AvAck_3=0 IBank.AvAck_2=0 IBank.AvAck_1=0 AT_19=0 AT_18=0 AT_17=0 IBank.B1_2_3=0 IBank.B1_2_2=0 IBank.B1_2_1=0 IBank.B1_2_0=0 IBank.B0_2_3=0 IBank.B0_2_2=0 IBank.B0_2_1=0 IBank.B0_2_0=0 IBank.W1_2_3=0 IBank.W1_2_2=0 IBank.W1_2_1=0 IBank.W1_2_0=0 IBank.W0_2_3=0 IBank.W0_2_2=0 IBank.W0_2_1=0 IBank.W0_2_0=0 IBank.G02=0 IBank.B0_1_3=0 IBank.B0_1_2=0 IBank.B0_1_1=0 IBank.B0_1_0=0 IBank.B1_1_3=0 IBank.B1_1_2=0 IBank.B1_1_1=0 IBank.B1_1_0=0 IBank.W1_1_3=0 IBank.W1_1_2=0 IBank.W1_1_1=0 IBank.W1_1_0=0 IBank.W0_1_3=0 IBank.W0_1_2=0 IBank.W0_1_1=0 IBank.W0_1_0=0 IBank.G01=0
simulatorOptions options temp=30.0 inventory=detailed narrate=yes
tran tran stop=6n errpreset=conservative
save IBank.IDATA0:47 IBank.IDATA0:48 IBank.IDATA0:22 IBank.IDATA0:1 IBank.IDATA0:10 V0:p V0:p V1:p V1:p vcc! vdd!
