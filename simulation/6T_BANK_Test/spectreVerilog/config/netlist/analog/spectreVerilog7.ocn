simulator( 'spectreVerilog )
design(	 "/net/kafka/nfs/rstdenis/Cadence/simulation/6T_BANK_Test/spectreVerilog/config/netlist/analog/netlist")
resultsDir( "/net/kafka/nfs/rstdenis/Cadence/simulation/6T_BANK_Test/spectreVerilog/config" )
modelFile(
    '("/software/cadence/ncsu-FreePDK15/hspice_16nm_hp.include" "")
)
analysis('tran ?stop "6n "  ?errpreset "conservative"  )
desVar(	  "vcc" "vdd"	)
desVar(	  "vdd" .7	)
envOption(
	'mspSetupNetlistSimPrecisionUnit  "ps"
	'mspSetupNetlistSimTimeUnit  "ps"
	'mspSetupNetlistSwitchRC  t
	'analysisOrder  list("tran")
)
option(	'inventory  "detailed"
	'multithread  "on"
	'temp  "30.0"
)
saveOption( ?simOutputFormat "psfxl" )
converge( 'ic "/IBank/G01" "0" )
converge( 'ic "/IBank/W0_1<0>" "0" )
converge( 'ic "/IBank/W0_1<1>" "0" )
converge( 'ic "/IBank/W0_1<2>" "0" )
converge( 'ic "/IBank/W0_1<3>" "0" )
converge( 'ic "/IBank/W1_1<0>" "0" )
converge( 'ic "/IBank/W1_1<1>" "0" )
converge( 'ic "/IBank/W1_1<2>" "0" )
converge( 'ic "/IBank/W1_1<3>" "0" )
converge( 'ic "/IBank/B1_1<0>" "0" )
converge( 'ic "/IBank/B1_1<1>" "0" )
converge( 'ic "/IBank/B1_1<2>" "0" )
converge( 'ic "/IBank/B1_1<3>" "0" )
converge( 'ic "/IBank/B0_1<0>" "0" )
converge( 'ic "/IBank/B0_1<1>" "0" )
converge( 'ic "/IBank/B0_1<2>" "0" )
converge( 'ic "/IBank/B0_1<3>" "0" )
converge( 'ic "/IBank/G02" "0" )
converge( 'ic "/IBank/W0_2<0>" "0" )
converge( 'ic "/IBank/W0_2<1>" "0" )
converge( 'ic "/IBank/W0_2<2>" "0" )
converge( 'ic "/IBank/W0_2<3>" "0" )
converge( 'ic "/IBank/W1_2<0>" "0" )
converge( 'ic "/IBank/W1_2<1>" "0" )
converge( 'ic "/IBank/W1_2<2>" "0" )
converge( 'ic "/IBank/W1_2<3>" "0" )
converge( 'ic "/IBank/B0_2<0>" "0" )
converge( 'ic "/IBank/B0_2<1>" "0" )
converge( 'ic "/IBank/B0_2<2>" "0" )
converge( 'ic "/IBank/B0_2<3>" "0" )
converge( 'ic "/IBank/B1_2<0>" "0" )
converge( 'ic "/IBank/B1_2<1>" "0" )
converge( 'ic "/IBank/B1_2<2>" "0" )
converge( 'ic "/IBank/B1_2<3>" "0" )
converge( 'ic "/AT<17>" "0" )
converge( 'ic "/AT<18>" "0" )
converge( 'ic "/AT<19>" "0" )
converge( 'ic "/IBank/AvAck<1>" "0" )
converge( 'ic "/IBank/AvAck<2>" "0" )
converge( 'ic "/IBank/AvAck<3>" "0" )
converge( 'ic "/AT<12>" "0" )
converge( 'ic "/AT<13>" "0" )
converge( 'ic "/AT<14>" "0" )
converge( 'ic "/AT<15>" "0" )
converge( 'ic "/AT<8>" "0" )
converge( 'ic "/AT<9>" "0" )
converge( 'ic "/AT<10>" "0" )
converge( 'ic "/AT<11>" "0" )
converge( 'ic "/AT<0>" "0" )
converge( 'ic "/AT<1>" "0" )
converge( 'ic "/AT<2>" "0" )
converge( 'ic "/AT<3>" "0" )
converge( 'ic "/AT<4>" "0" )
converge( 'ic "/AT<5>" "0" )
converge( 'ic "/AT<6>" "0" )
converge( 'ic "/AT<7>" "0" )
converge( 'ic "/IBank/AvAck<0>" "0" )
converge( 'ic "/AT<16>" "0" )
converge( 'ic "/IBank/S_1<0>" "0" )
converge( 'ic "/IBank/S_1<1>" "0" )
converge( 'ic "/IBank/S_1<2>" "0" )
converge( 'ic "/IBank/S_1<3>" "0" )
converge( 'ic "/IBank/S_1<4>" "0" )
converge( 'ic "/IBank/S_1<5>" "0" )
converge( 'ic "/IBank/S_1<6>" "0" )
converge( 'ic "/IBank/S_1<7>" "0" )
converge( 'ic "/IBank/A_1<0>" "0" )
converge( 'ic "/IBank/A_1<1>" "0" )
converge( 'ic "/IBank/A_1<2>" "0" )
converge( 'ic "/IBank/A_1<3>" "0" )
converge( 'ic "/IBank/A_1<4>" "0" )
converge( 'ic "/IBank/A_1<5>" "0" )
converge( 'ic "/IBank/A_1<6>" "0" )
converge( 'ic "/IBank/A_1<7>" "0" )
converge( 'ic "/IBank/A_1<8>" "0" )
converge( 'ic "/IBank/A_1<9>" "0" )
converge( 'ic "/IBank/A_1<10>" "0" )
converge( 'ic "/IBank/A_1<11>" "0" )
converge( 'ic "/IBank/A_1<12>" "0" )
converge( 'ic "/IBank/A_1<13>" "0" )
converge( 'ic "/IBank/A_1<14>" "0" )
converge( 'ic "/IBank/A_1<15>" "0" )
converge( 'ic "/IBank/A_1<16>" "0" )
converge( 'ic "/IBank/A_1<17>" "0" )
converge( 'ic "/IBank/A_1<18>" "0" )
converge( 'ic "/IBank/A_1<19>" "0" )
converge( 'ic "/IBank/A_1<20>" "0" )
converge( 'ic "/IBank/A_1<21>" "0" )
converge( 'ic "/IBank/A_1<22>" "0" )
converge( 'ic "/IBank/A_1<23>" "0" )
converge( 'ic "/IBank/A_1<24>" "0" )
converge( 'ic "/IBank/A_1<25>" "0" )
converge( 'ic "/IBank/A_1<26>" "0" )
converge( 'ic "/IBank/A_1<27>" "0" )
converge( 'ic "/IBank/A_1<28>" "0" )
converge( 'ic "/IBank/A_1<29>" "0" )
converge( 'ic "/IBank/A_1<30>" "0" )
converge( 'ic "/IBank/A_1<31>" "0" )
converge( 'ic "/IBank/A_1<32>" "0" )
converge( 'ic "/IBank/A_1<33>" "0" )
converge( 'ic "/IBank/A_1<34>" "0" )
converge( 'ic "/IBank/A_1<35>" "0" )
converge( 'ic "/IBank/A_1<36>" "0" )
converge( 'ic "/IBank/A_1<37>" "0" )
converge( 'ic "/IBank/A_1<38>" "0" )
converge( 'ic "/IBank/A_1<39>" "0" )
converge( 'ic "/IBank/A_1<40>" "0" )
converge( 'ic "/IBank/A_1<41>" "0" )
converge( 'ic "/IBank/A_1<42>" "0" )
converge( 'ic "/IBank/A_1<43>" "0" )
converge( 'ic "/IBank/A_1<44>" "0" )
converge( 'ic "/IBank/A_1<45>" "0" )
converge( 'ic "/IBank/A_1<46>" "0" )
converge( 'ic "/IBank/A_1<47>" "0" )
converge( 'ic "/IBank/A_1<48>" "0" )
converge( 'ic "/IBank/A_1<49>" "0" )
converge( 'ic "/IBank/A_1<50>" "0" )
converge( 'ic "/IBank/A_1<51>" "0" )
converge( 'ic "/IBank/A_1<52>" "0" )
converge( 'ic "/IBank/A_1<53>" "0" )
converge( 'ic "/IBank/A_1<54>" "0" )
converge( 'ic "/IBank/A_1<55>" "0" )
converge( 'ic "/IBank/A_1<56>" "0" )
converge( 'ic "/IBank/A_1<57>" "0" )
converge( 'ic "/IBank/A_1<58>" "0" )
converge( 'ic "/IBank/A_1<59>" "0" )
converge( 'ic "/IBank/A_1<60>" "0" )
converge( 'ic "/IBank/A_1<61>" "0" )
converge( 'ic "/IBank/A_1<62>" "0" )
converge( 'ic "/IBank/A_1<63>" "0" )
converge( 'ic "/IBank/net068<7>" "0" )
converge( 'ic "/IBank/net068<6>" "0" )
converge( 'ic "/IBank/net068<5>" "0" )
converge( 'ic "/IBank/net068<4>" "0" )
converge( 'ic "/IBank/net068<3>" "0" )
converge( 'ic "/IBank/net068<2>" "0" )
converge( 'ic "/IBank/net068<1>" "0" )
converge( 'ic "/IBank/net068<0>" "0" )
converge( 'ic "/IBank/net096<63>" "0" )
converge( 'ic "/IBank/net096<62>" "0" )
converge( 'ic "/IBank/net096<61>" "0" )
converge( 'ic "/IBank/net096<60>" "0" )
converge( 'ic "/IBank/net096<59>" "0" )
converge( 'ic "/IBank/net096<58>" "0" )
converge( 'ic "/IBank/net096<57>" "0" )
converge( 'ic "/IBank/net096<56>" "0" )
converge( 'ic "/IBank/net096<55>" "0" )
converge( 'ic "/IBank/net096<54>" "0" )
converge( 'ic "/IBank/net096<53>" "0" )
converge( 'ic "/IBank/net096<52>" "0" )
converge( 'ic "/IBank/net096<51>" "0" )
converge( 'ic "/IBank/net096<50>" "0" )
converge( 'ic "/IBank/net096<49>" "0" )
converge( 'ic "/IBank/net096<48>" "0" )
converge( 'ic "/IBank/net096<47>" "0" )
converge( 'ic "/IBank/net096<46>" "0" )
converge( 'ic "/IBank/net096<45>" "0" )
converge( 'ic "/IBank/net096<44>" "0" )
converge( 'ic "/IBank/net096<43>" "0" )
converge( 'ic "/IBank/net096<42>" "0" )
converge( 'ic "/IBank/net096<41>" "0" )
converge( 'ic "/IBank/net096<40>" "0" )
converge( 'ic "/IBank/net096<39>" "0" )
converge( 'ic "/IBank/net096<38>" "0" )
converge( 'ic "/IBank/net096<37>" "0" )
converge( 'ic "/IBank/net096<36>" "0" )
converge( 'ic "/IBank/net096<35>" "0" )
converge( 'ic "/IBank/net096<34>" "0" )
converge( 'ic "/IBank/net096<33>" "0" )
converge( 'ic "/IBank/net096<32>" "0" )
converge( 'ic "/IBank/net096<31>" "0" )
converge( 'ic "/IBank/net096<30>" "0" )
converge( 'ic "/IBank/net096<29>" "0" )
converge( 'ic "/IBank/net096<28>" "0" )
converge( 'ic "/IBank/net096<27>" "0" )
converge( 'ic "/IBank/net096<26>" "0" )
converge( 'ic "/IBank/net096<25>" "0" )
converge( 'ic "/IBank/net096<24>" "0" )
converge( 'ic "/IBank/net096<23>" "0" )
converge( 'ic "/IBank/net096<22>" "0" )
converge( 'ic "/IBank/net096<21>" "0" )
converge( 'ic "/IBank/net096<20>" "0" )
converge( 'ic "/IBank/net096<19>" "0" )
converge( 'ic "/IBank/net096<18>" "0" )
converge( 'ic "/IBank/net096<17>" "0" )
converge( 'ic "/IBank/net096<16>" "0" )
converge( 'ic "/IBank/net096<15>" "0" )
converge( 'ic "/IBank/net096<14>" "0" )
converge( 'ic "/IBank/net096<13>" "0" )
converge( 'ic "/IBank/net096<12>" "0" )
converge( 'ic "/IBank/net096<11>" "0" )
converge( 'ic "/IBank/net096<10>" "0" )
converge( 'ic "/IBank/net096<9>" "0" )
converge( 'ic "/IBank/net096<8>" "0" )
converge( 'ic "/IBank/net096<7>" "0" )
converge( 'ic "/IBank/net096<6>" "0" )
converge( 'ic "/IBank/net096<5>" "0" )
converge( 'ic "/IBank/net096<4>" "0" )
converge( 'ic "/IBank/net096<3>" "0" )
converge( 'ic "/IBank/net096<2>" "0" )
converge( 'ic "/IBank/net096<1>" "0" )
converge( 'ic "/IBank/net096<0>" "0" )
converge( 'ic "/IBank/net0131<7>" "0" )
converge( 'ic "/IBank/net0131<6>" "0" )
converge( 'ic "/IBank/net0131<5>" "0" )
converge( 'ic "/IBank/net0131<4>" "0" )
converge( 'ic "/IBank/net0131<3>" "0" )
converge( 'ic "/IBank/net0131<2>" "0" )
converge( 'ic "/IBank/net0131<1>" "0" )
converge( 'ic "/IBank/net0131<0>" "0" )
converge( 'ic "/IBank/net0157<63>" "0" )
converge( 'ic "/IBank/net0157<62>" "0" )
converge( 'ic "/IBank/net0157<61>" "0" )
converge( 'ic "/IBank/net0157<60>" "0" )
converge( 'ic "/IBank/net0157<59>" "0" )
converge( 'ic "/IBank/net0157<58>" "0" )
converge( 'ic "/IBank/net0157<57>" "0" )
converge( 'ic "/IBank/net0157<56>" "0" )
converge( 'ic "/IBank/net0157<55>" "0" )
converge( 'ic "/IBank/net0157<54>" "0" )
converge( 'ic "/IBank/net0157<53>" "0" )
converge( 'ic "/IBank/net0157<52>" "0" )
converge( 'ic "/IBank/net0157<51>" "0" )
converge( 'ic "/IBank/net0157<50>" "0" )
converge( 'ic "/IBank/net0157<49>" "0" )
converge( 'ic "/IBank/net0157<48>" "0" )
converge( 'ic "/IBank/net0157<47>" "0" )
converge( 'ic "/IBank/net0157<46>" "0" )
converge( 'ic "/IBank/net0157<45>" "0" )
converge( 'ic "/IBank/net0157<44>" "0" )
converge( 'ic "/IBank/net0157<43>" "0" )
converge( 'ic "/IBank/net0157<42>" "0" )
converge( 'ic "/IBank/net0157<41>" "0" )
converge( 'ic "/IBank/net0157<40>" "0" )
converge( 'ic "/IBank/net0157<39>" "0" )
converge( 'ic "/IBank/net0157<38>" "0" )
converge( 'ic "/IBank/net0157<37>" "0" )
converge( 'ic "/IBank/net0157<36>" "0" )
converge( 'ic "/IBank/net0157<35>" "0" )
converge( 'ic "/IBank/net0157<34>" "0" )
converge( 'ic "/IBank/net0157<33>" "0" )
converge( 'ic "/IBank/net0157<32>" "0" )
converge( 'ic "/IBank/net0157<31>" "0" )
converge( 'ic "/IBank/net0157<30>" "0" )
converge( 'ic "/IBank/net0157<29>" "0" )
converge( 'ic "/IBank/net0157<28>" "0" )
converge( 'ic "/IBank/net0157<27>" "0" )
converge( 'ic "/IBank/net0157<26>" "0" )
converge( 'ic "/IBank/net0157<25>" "0" )
converge( 'ic "/IBank/net0157<24>" "0" )
converge( 'ic "/IBank/net0157<23>" "0" )
converge( 'ic "/IBank/net0157<22>" "0" )
converge( 'ic "/IBank/net0157<21>" "0" )
converge( 'ic "/IBank/net0157<20>" "0" )
converge( 'ic "/IBank/net0157<19>" "0" )
converge( 'ic "/IBank/net0157<18>" "0" )
converge( 'ic "/IBank/net0157<17>" "0" )
converge( 'ic "/IBank/net0157<16>" "0" )
converge( 'ic "/IBank/net0157<15>" "0" )
converge( 'ic "/IBank/net0157<14>" "0" )
converge( 'ic "/IBank/net0157<13>" "0" )
converge( 'ic "/IBank/net0157<12>" "0" )
converge( 'ic "/IBank/net0157<11>" "0" )
converge( 'ic "/IBank/net0157<10>" "0" )
converge( 'ic "/IBank/net0157<9>" "0" )
converge( 'ic "/IBank/net0157<8>" "0" )
converge( 'ic "/IBank/net0157<7>" "0" )
converge( 'ic "/IBank/net0157<6>" "0" )
converge( 'ic "/IBank/net0157<5>" "0" )
converge( 'ic "/IBank/net0157<4>" "0" )
converge( 'ic "/IBank/net0157<3>" "0" )
converge( 'ic "/IBank/net0157<2>" "0" )
converge( 'ic "/IBank/net0157<1>" "0" )
converge( 'ic "/IBank/net0157<0>" "0" )
converge( 'ic "/IBank/net087<63>" "0" )
converge( 'ic "/IBank/net087<62>" "0" )
converge( 'ic "/IBank/net087<61>" "0" )
converge( 'ic "/IBank/net087<60>" "0" )
converge( 'ic "/IBank/net087<59>" "0" )
converge( 'ic "/IBank/net087<58>" "0" )
converge( 'ic "/IBank/net087<57>" "0" )
converge( 'ic "/IBank/net087<56>" "0" )
converge( 'ic "/IBank/net087<55>" "0" )
converge( 'ic "/IBank/net087<54>" "0" )
converge( 'ic "/IBank/net087<53>" "0" )
converge( 'ic "/IBank/net087<52>" "0" )
converge( 'ic "/IBank/net087<51>" "0" )
converge( 'ic "/IBank/net087<50>" "0" )
converge( 'ic "/IBank/net087<49>" "0" )
converge( 'ic "/IBank/net087<48>" "0" )
converge( 'ic "/IBank/net087<47>" "0" )
converge( 'ic "/IBank/net087<46>" "0" )
converge( 'ic "/IBank/net087<45>" "0" )
converge( 'ic "/IBank/net087<44>" "0" )
converge( 'ic "/IBank/net087<43>" "0" )
converge( 'ic "/IBank/net087<42>" "0" )
converge( 'ic "/IBank/net087<41>" "0" )
converge( 'ic "/IBank/net087<40>" "0" )
converge( 'ic "/IBank/net087<39>" "0" )
converge( 'ic "/IBank/net087<38>" "0" )
converge( 'ic "/IBank/net087<37>" "0" )
converge( 'ic "/IBank/net087<36>" "0" )
converge( 'ic "/IBank/net087<35>" "0" )
converge( 'ic "/IBank/net087<34>" "0" )
converge( 'ic "/IBank/net087<33>" "0" )
converge( 'ic "/IBank/net087<32>" "0" )
converge( 'ic "/IBank/net087<31>" "0" )
converge( 'ic "/IBank/net087<30>" "0" )
converge( 'ic "/IBank/net087<29>" "0" )
converge( 'ic "/IBank/net087<28>" "0" )
converge( 'ic "/IBank/net087<27>" "0" )
converge( 'ic "/IBank/net087<26>" "0" )
converge( 'ic "/IBank/net087<25>" "0" )
converge( 'ic "/IBank/net087<24>" "0" )
converge( 'ic "/IBank/net087<23>" "0" )
converge( 'ic "/IBank/net087<22>" "0" )
converge( 'ic "/IBank/net087<21>" "0" )
converge( 'ic "/IBank/net087<20>" "0" )
converge( 'ic "/IBank/net087<19>" "0" )
converge( 'ic "/IBank/net087<18>" "0" )
converge( 'ic "/IBank/net087<17>" "0" )
converge( 'ic "/IBank/net087<16>" "0" )
converge( 'ic "/IBank/net087<15>" "0" )
converge( 'ic "/IBank/net087<14>" "0" )
converge( 'ic "/IBank/net087<13>" "0" )
converge( 'ic "/IBank/net087<12>" "0" )
converge( 'ic "/IBank/net087<11>" "0" )
converge( 'ic "/IBank/net087<10>" "0" )
converge( 'ic "/IBank/net087<9>" "0" )
converge( 'ic "/IBank/net087<8>" "0" )
converge( 'ic "/IBank/net087<7>" "0" )
converge( 'ic "/IBank/net087<6>" "0" )
converge( 'ic "/IBank/net087<5>" "0" )
converge( 'ic "/IBank/net087<4>" "0" )
converge( 'ic "/IBank/net087<3>" "0" )
converge( 'ic "/IBank/net087<2>" "0" )
converge( 'ic "/IBank/net087<1>" "0" )
converge( 'ic "/IBank/net087<0>" "0" )
converge( 'ic "/IBank/net059<7>" "0" )
converge( 'ic "/IBank/net059<6>" "0" )
converge( 'ic "/IBank/net059<5>" "0" )
converge( 'ic "/IBank/net059<4>" "0" )
converge( 'ic "/IBank/net059<3>" "0" )
converge( 'ic "/IBank/net059<2>" "0" )
converge( 'ic "/IBank/net059<1>" "0" )
converge( 'ic "/IBank/net059<0>" "0" )
converge( 'ic "/RWT<0>" "0" )
converge( 'ic "/RWT<1>" "0" )
converge( 'ic "/IBank/RW<1:0>" "0" )
converge( 'ic "/IBank/ValAddr" "0" )
converge( 'ic "/IBank/ck<0>" "0" )
converge( 'ic "/IBank/ck<1>" "0" )
converge( 'ic "/IBank/Reset" "0" )
converge( 'ic "/IBank/ck<2>" "0" )
converge( 'ic "/IBank/ck<3>" "0" )
converge( 'ic "/IBank/G03" "0" )
converge( 'ic "/IBank/W1_3<0>" "0" )
converge( 'ic "/IBank/W1_3<1>" "0" )
converge( 'ic "/IBank/W1_3<2>" "0" )
converge( 'ic "/IBank/W1_3<3>" "0" )
converge( 'ic "/IBank/W0_3<0>" "0" )
converge( 'ic "/IBank/W0_3<1>" "0" )
converge( 'ic "/IBank/W0_3<2>" "0" )
converge( 'ic "/IBank/W0_3<3>" "0" )
converge( 'ic "/IBank/B0_3<0>" "0" )
converge( 'ic "/IBank/B0_3<1>" "0" )
converge( 'ic "/IBank/B0_3<2>" "0" )
converge( 'ic "/IBank/B0_3<3>" "0" )
converge( 'ic "/IBank/B1_3<0>" "0" )
converge( 'ic "/IBank/B1_3<1>" "0" )
converge( 'ic "/IBank/B1_3<2>" "0" )
converge( 'ic "/IBank/B1_3<3>" "0" )
converge( 'ic "/IBank/W0_4<0>" "0" )
converge( 'ic "/IBank/W0_4<1>" "0" )
converge( 'ic "/IBank/W0_4<2>" "0" )
converge( 'ic "/IBank/W0_4<3>" "0" )
converge( 'ic "/IBank/W1_4<0>" "0" )
converge( 'ic "/IBank/W1_4<1>" "0" )
converge( 'ic "/IBank/W1_4<2>" "0" )
converge( 'ic "/IBank/W1_4<3>" "0" )
converge( 'ic "/IBank/B0_4<0>" "0" )
converge( 'ic "/IBank/B0_4<1>" "0" )
converge( 'ic "/IBank/B0_4<2>" "0" )
converge( 'ic "/IBank/B0_4<3>" "0" )
converge( 'ic "/IBank/B1_4<0>" "0" )
converge( 'ic "/IBank/B1_4<1>" "0" )
converge( 'ic "/IBank/B1_4<2>" "0" )
converge( 'ic "/IBank/B1_4<3>" "0" )
converge( 'ic "/IBank/G04" "0" )
converge( 'ic "/IBank/net042" "0" )
converge( 'ic "/WriteDataT<8>" "0" )
converge( 'ic "/WriteDataT<9>" "0" )
converge( 'ic "/WriteDataT<10>" "0" )
converge( 'ic "/WriteDataT<11>" "0" )
converge( 'ic "/WriteDataT<12>" "0" )
converge( 'ic "/WriteDataT<13>" "0" )
converge( 'ic "/WriteDataT<14>" "0" )
converge( 'ic "/WriteDataT<15>" "0" )
converge( 'ic "/WriteDataT<16>" "0" )
converge( 'ic "/WriteDataT<17>" "0" )
converge( 'ic "/WriteDataT<18>" "0" )
converge( 'ic "/WriteDataT<19>" "0" )
converge( 'ic "/WriteDataT<20>" "0" )
converge( 'ic "/WriteDataT<21>" "0" )
converge( 'ic "/WriteDataT<22>" "0" )
converge( 'ic "/WriteDataT<23>" "0" )
converge( 'ic "/WriteDataT<24>" "0" )
converge( 'ic "/WriteDataT<25>" "0" )
converge( 'ic "/WriteDataT<26>" "0" )
converge( 'ic "/WriteDataT<27>" "0" )
converge( 'ic "/WriteDataT<28>" "0" )
converge( 'ic "/WriteDataT<29>" "0" )
converge( 'ic "/WriteDataT<30>" "0" )
converge( 'ic "/WriteDataT<31>" "0" )
converge( 'ic "/ReaDataT<8>" "0" )
converge( 'ic "/ReaDataT<9>" "0" )
converge( 'ic "/ReaDataT<10>" "0" )
converge( 'ic "/ReaDataT<11>" "0" )
converge( 'ic "/ReaDataT<12>" "0" )
converge( 'ic "/ReaDataT<13>" "0" )
converge( 'ic "/ReaDataT<14>" "0" )
converge( 'ic "/ReaDataT<15>" "0" )
converge( 'ic "/ReaDataT<16>" "0" )
converge( 'ic "/ReaDataT<17>" "0" )
converge( 'ic "/ReaDataT<18>" "0" )
converge( 'ic "/ReaDataT<19>" "0" )
converge( 'ic "/ReaDataT<20>" "0" )
converge( 'ic "/ReaDataT<21>" "0" )
converge( 'ic "/ReaDataT<22>" "0" )
converge( 'ic "/ReaDataT<23>" "0" )
converge( 'ic "/ReaDataT<24>" "0" )
converge( 'ic "/ReaDataT<25>" "0" )
converge( 'ic "/ReaDataT<26>" "0" )
converge( 'ic "/ReaDataT<27>" "0" )
converge( 'ic "/ReaDataT<28>" "0" )
converge( 'ic "/ReaDataT<29>" "0" )
converge( 'ic "/ReaDataT<30>" "0" )
converge( 'ic "/ReaDataT<31>" "0" )
converge( 'ic "/ReadDataAckT<0>" "0" )
converge( 'ic "/ReadDataAckT<1>" "0" )
converge( 'ic "/WriteDataT<0>" "0" )
converge( 'ic "/WriteDataT<1>" "0" )
converge( 'ic "/WriteDataT<2>" "0" )
converge( 'ic "/WriteDataT<3>" "0" )
converge( 'ic "/WriteDataT<4>" "0" )
converge( 'ic "/WriteDataT<5>" "0" )
converge( 'ic "/WriteDataT<6>" "0" )
converge( 'ic "/WriteDataT<7>" "0" )
converge( 'ic "/WDataAckT<0>" "0" )
converge( 'ic "/WDataAckT<1>" "0" )
converge( 'ic "/ReaDataT<4>" "0" )
converge( 'ic "/ReaDataT<5>" "0" )
converge( 'ic "/ReaDataT<6>" "0" )
converge( 'ic "/ReaDataT<7>" "0" )
converge( 'ic "/ReaDataT<0>" "0" )
converge( 'ic "/ReaDataT<1>" "0" )
converge( 'ic "/ReaDataT<2>" "0" )
converge( 'ic "/ReaDataT<3>" "0" )
converge( 'ic "/WDataAckT<2>" "0" )
converge( 'ic "/WDataAckT<3>" "0" )
converge( 'ic "/ReadDataAckT<2>" "0" )
converge( 'ic "/ReadDataAckT<3>" "0" )
converge( 'ic "/WDataAckT<4>" "0" )
converge( 'ic "/WDataAckT<5>" "0" )
converge( 'ic "/ReadDataAckT<4>" "0" )
converge( 'ic "/ReadDataAckT<5>" "0" )
converge( 'ic "/WDataAckT<6>" "0" )
converge( 'ic "/WDataAckT<7>" "0" )
converge( 'ic "/ReadDataAckT<6>" "0" )
converge( 'ic "/ReadDataAckT<7>" "0" )
converge( 'ic "/IBank/~R1_1<0>" "vdd" )
converge( 'ic "/IBank/~R1_1<1>" "vdd" )
converge( 'ic "/IBank/~R1_1<2>" "vdd" )
converge( 'ic "/IBank/~R1_1<3>" "vdd" )
converge( 'ic "/IBank/~R0_1<0>" "vdd" )
converge( 'ic "/IBank/~R0_1<1>" "vdd" )
converge( 'ic "/IBank/~R0_1<2>" "vdd" )
converge( 'ic "/IBank/~R0_1<3>" "vdd" )
converge( 'ic "/IBank/~R0_2<0>" "vdd" )
converge( 'ic "/IBank/~R0_2<1>" "vdd" )
converge( 'ic "/IBank/~R0_2<2>" "vdd" )
converge( 'ic "/IBank/~R0_2<3>" "vdd" )
converge( 'ic "/IBank/~R1_2<0>" "vdd" )
converge( 'ic "/IBank/~R1_2<1>" "vdd" )
converge( 'ic "/IBank/~R1_2<2>" "vdd" )
converge( 'ic "/IBank/~R1_2<3>" "vdd" )
converge( 'ic "/IBank/~R0_3<0>" "vdd" )
converge( 'ic "/IBank/~R0_3<1>" "vdd" )
converge( 'ic "/IBank/~R0_3<2>" "vdd" )
converge( 'ic "/IBank/~R0_3<3>" "vdd" )
converge( 'ic "/IBank/~R1_3<0>" "vdd" )
converge( 'ic "/IBank/~R1_3<1>" "vdd" )
converge( 'ic "/IBank/~R1_3<2>" "vdd" )
converge( 'ic "/IBank/~R1_3<3>" "vdd" )
converge( 'ic "/IBank/~R0_4<0>" "vdd" )
converge( 'ic "/IBank/~R0_4<1>" "vdd" )
converge( 'ic "/IBank/~R0_4<2>" "vdd" )
converge( 'ic "/IBank/~R0_4<3>" "vdd" )
converge( 'ic "/IBank/~R1_4<0>" "vdd" )
converge( 'ic "/IBank/~R1_4<1>" "vdd" )
converge( 'ic "/IBank/~R1_4<2>" "vdd" )
converge( 'ic "/IBank/~R1_4<3>" "vdd" )
converge( 'ic "/IBank/outAck" "0" )
converge( 'ic "/IBank/net027" "0" )
converge( 'ic "/IBank/I0/I0/I0/I7/I3/Q0" "0" )
converge( 'ic "/IBank/I0/I0/I0/I7/I3/Q1" "vdd" )
converge( 'ic "/IBank/I0/I0/B1P1" "vdd" )
converge( 'ic "/IBank/I0/I0/B0P1" "vdd" )
converge( 'ic "/IBank/I20/I10/nxa" "vdd" )
converge( 'ic "/IBank/I20/I10/b1<0>" "vdd" )
converge( 'ic "/IBank/I20/I10/b0<0>" "vdd" )
converge( 'ic "/IBank/I20/I10/b1<1>" "vdd" )
converge( 'ic "/IBank/I20/I10/b0<1>" "vdd" )
converge( 'ic "/IBank/I20/I10/net11" "vdd" )
converge( 'ic "/IBank/I20/I10/net12" "vdd" )
converge( 'ic "/IBank/I20/I10/net13" "vdd" )
converge( 'ic "/IBank/I20/I10/net14" "vdd" )
converge( 'ic "/IBank/I20/I10/n<3>" "0" )
converge( 'ic "/IBank/I20/I10/n<2>" "0" )
converge( 'ic "/IBank/I20/I10/n<1>" "0" )
converge( 'ic "/IBank/I20/I10/n<0>" "0" )
converge( 'ic "/IBank/I20/I12<1>/inValid" "0" )
converge( 'ic "/IBank/I20/I12<1>/outValid" "0" )
converge( 'ic "/IBank/I20/I12<1>/net027" "vdd" )
converge( 'ic "/IBank/I20/I12<1>/inAck" "vdd" )
converge( 'ic "/IBank/I20/I12<1>/oE" "vdd" )
converge( 'ic "/IBank/I20/R1q<2>" "0" )
converge( 'ic "/IBank/I20/R1q<3>" "0" )
converge( 'ic "/IBank/I20/R0q<2>" "0" )
converge( 'ic "/IBank/I20/R0q<3>" "0" )
converge( 'ic "/IBank/I20/I3<1>/n1<1>" "0" )
converge( 'ic "/IBank/I20/I3<1>/n0<1>" "0" )
converge( 'ic "/IBank/I20/I3<1>/n1<0>" "0" )
converge( 'ic "/IBank/I20/I3<1>/n0<0>" "0" )
converge( 'ic "/IBank/I20/I3<1>/m<0>" "vdd" )
converge( 'ic "/IBank/I20/I3<1>/m<1>" "vdd" )
converge( 'ic "/IBank/I20/I3<1>/m<2>" "vdd" )
converge( 'ic "/IBank/I20/I3<1>/m<3>" "vdd" )
converge( 'ic "/IBank/I20/I3<1>/net20" "vdd" )
converge( 'ic "/IBank/I20/I3<1>/net24" "vdd" )
converge( 'ic "/IBank/I20/I3<1>/net27" "vdd" )
converge( 'ic "/IBank/I20/I3<1>/net31" "vdd" )
converge( 'ic "/IBank/I20/I3<1>/outAck" "vdd" )
converge( 'ic "/IBank/I20/RpAck<2>" "vdd" )
converge( 'ic "/IBank/I20/RpAck<3>" "vdd" )
converge( 'ic "/IBank/I20/R1<0>" "0" )
converge( 'ic "/IBank/I20/R1<1>" "0" )
converge( 'ic "/IBank/I20/R1<2>" "0" )
converge( 'ic "/IBank/I20/R1<3>" "0" )
converge( 'ic "/IBank/I20/R0<0>" "0" )
converge( 'ic "/IBank/I20/R0<1>" "0" )
converge( 'ic "/IBank/I20/R0<2>" "0" )
converge( 'ic "/IBank/I20/R0<3>" "0" )
converge( 'ic "/IBank/I20/Lack<0>" "0" )
converge( 'ic "/IBank/I20/Lack<1>" "0" )
converge( 'ic "/IBank/I20/Lack<2>" "0" )
converge( 'ic "/IBank/I20/Lack<3>" "0" )
converge( 'ic "/IBank/I20/wack<3>" "0" )
converge( 'ic "/IBank/I20/wack<2>" "0" )
converge( 'ic "/IBank/I20/nB0<2>" "0" )
converge( 'ic "/IBank/I20/nB0<3>" "0" )
converge( 'ic "/IBank/I20/nB1<2>" "0" )
converge( 'ic "/IBank/I20/nB1<3>" "0" )
converge( 'ic "/IBank/I20/wack<1>" "0" )
converge( 'ic "/IBank/I20/nB0<0>" "0" )
converge( 'ic "/IBank/I20/nB0<1>" "0" )
converge( 'ic "/IBank/I20/wack<0>" "0" )
converge( 'ic "/IBank/I20/nB1<0>" "0" )
converge( 'ic "/IBank/I20/nB1<1>" "0" )
converge( 'ic "/IBank/I20/Wen" "0" )
converge( 'ic "/IBank/I20/intWack" "vdd" )
converge( 'ic "/IBank/I20/intRack" "vdd" )
temp( 30.0 )
run()
selectResult( 'tran )
plot(getData("/IBank/I0/I0/B1P1") getData("/IBank/I0/I0/B0P1") getData("/IBank/I0/I0/I0/I7/I3/Q0") getData("/IBank/I0/I0/I0/I7/I3/Q1") getData("/IBank/outAck") getData("/IBank/ck<2>") getData("/IBank/ck<3>") getData("/RWT<1>") getData("/RWT<0>") getData("/IBank/ValAddr") getData("/IBank/ck<0>") getData("/IBank/ck<1>") getData("/IBank/Reset") getData("/AT<7>") getData("/AT<6>") getData("/AT<5>") getData("/AT<4>") getData("/AT<3>") getData("/AT<2>") getData("/AT<1>") getData("/AT<0>") getData("/AT<11>") getData("/AT<10>") getData("/AT<9>") getData("/AT<8>") getData("/AT<15>") getData("/AT<14>") getData("/AT<13>") getData("/AT<12>") getData("/IBank/AvAck<3>") getData("/IBank/AvAck<2>") getData("/IBank/AvAck<1>") getData("/IBank/AvAck<0>") getData("/AT<19>") getData("/AT<18>") getData("/AT<17>") getData("/AT<16>") getData("/IBank/S_1<7>") getData("/IBank/S_1<6>") getData("/IBank/S_1<5>") getData("/IBank/S_1<4>") getData("/IBank/S_1<3>") getData("/IBank/S_1<2>") getData("/IBank/S_1<1>") getData("/IBank/S_1<0>") getData("/IBank/A_1<63>") getData("/IBank/A_1<62>") getData("/IBank/A_1<61>") getData("/IBank/A_1<60>") getData("/IBank/A_1<59>") getData("/IBank/A_1<58>") getData("/IBank/A_1<57>") getData("/IBank/A_1<56>") getData("/IBank/A_1<55>") getData("/IBank/A_1<54>") getData("/IBank/A_1<53>") getData("/IBank/A_1<52>") getData("/IBank/A_1<51>") getData("/IBank/A_1<50>") getData("/IBank/A_1<49>") getData("/IBank/A_1<48>") getData("/IBank/A_1<47>") getData("/IBank/A_1<46>") getData("/IBank/A_1<45>") getData("/IBank/A_1<44>") getData("/IBank/A_1<43>") getData("/IBank/A_1<42>") getData("/IBank/A_1<41>") getData("/IBank/A_1<40>") getData("/IBank/A_1<39>") getData("/IBank/A_1<38>") getData("/IBank/A_1<37>") getData("/IBank/A_1<36>") getData("/IBank/A_1<35>") getData("/IBank/A_1<34>") getData("/IBank/A_1<33>") getData("/IBank/A_1<32>") getData("/IBank/A_1<31>") getData("/IBank/A_1<30>") getData("/IBank/A_1<29>") getData("/IBank/A_1<28>") getData("/IBank/A_1<27>") getData("/IBank/A_1<26>") getData("/IBank/A_1<25>") getData("/IBank/A_1<24>") getData("/IBank/A_1<23>") getData("/IBank/A_1<22>") getData("/IBank/A_1<21>") getData("/IBank/A_1<20>") getData("/IBank/A_1<19>") getData("/IBank/A_1<18>") getData("/IBank/A_1<17>") getData("/IBank/A_1<16>") getData("/IBank/A_1<15>") getData("/IBank/A_1<14>") getData("/IBank/A_1<13>") getData("/IBank/A_1<12>") getData("/IBank/A_1<11>") getData("/IBank/A_1<10>") getData("/IBank/A_1<9>") getData("/IBank/A_1<8>") getData("/IBank/A_1<7>") getData("/IBank/A_1<6>") getData("/IBank/A_1<5>") getData("/IBank/A_1<4>") getData("/IBank/A_1<3>") getData("/IBank/A_1<2>") getData("/IBank/A_1<1>") getData("/IBank/A_1<0>") getData("/IBank/~R0_1<3>") getData("/IBank/~R0_1<2>") getData("/IBank/~R0_1<1>") getData("/IBank/~R0_1<0>") getData("/IBank/B0_1<3>") getData("/IBank/B0_1<2>") getData("/IBank/B0_1<1>") getData("/IBank/B0_1<0>") getData("/IBank/B1_1<3>") getData("/IBank/B1_1<2>") getData("/IBank/B1_1<1>") getData("/IBank/B1_1<0>") getData("/IBank/W1_1<3>") getData("/IBank/W1_1<2>") getData("/IBank/W1_1<1>") getData("/IBank/W1_1<0>") getData("/IBank/W0_1<3>") getData("/IBank/W0_1<2>") getData("/IBank/W0_1<1>") getData("/IBank/W0_1<0>") getData("/IBank/G01") getData("/IBank/~R1_1<3>") getData("/IBank/~R1_1<2>") getData("/IBank/~R1_1<1>") getData("/IBank/~R1_1<0>") getData("/ReadDataAck<7:0>") getData("/ReadData<31:0>") getData("/Ack") getData("/Ctrl_Ack<4:0>") getData("/RW<1:0>") getData("/A<19:0>") getData("/WriteDataAck<7:0>") getData("/WriteData<31:0>") )
modelFile(
    '("/software/cadence/ncsu-FreePDK15/hspice_16nm_hp.include" "")
)
save( 'i "/V0/PLUS" "/V1/PLUS" "/V1/MINUS" "/V0/MINUS" )
run()
selectResult( 'tran )
plot(getData("/WriteData<31:0>") getData("/WriteDataAck<7:0>") getData("/A<19:0>") getData("/RW<1:0>") getData("/Ctrl_Ack<4:0>") getData("/Ack") getData("/ReadData<31:0>") getData("/ReadDataAck<7:0>") getData("/IBank/~R0_1<3>") getData("/IBank/~R0_1<2>") getData("/IBank/~R0_1<1>") getData("/IBank/~R0_1<0>") getData("/IBank/B0_1<3>") getData("/IBank/B0_1<2>") getData("/IBank/B0_1<1>") getData("/IBank/B0_1<0>") getData("/IBank/B1_1<3>") getData("/IBank/B1_1<2>") getData("/IBank/B1_1<1>") getData("/IBank/B1_1<0>") getData("/IBank/W1_1<3>") getData("/IBank/W1_1<2>") getData("/IBank/W1_1<1>") getData("/IBank/W1_1<0>") getData("/IBank/W0_1<3>") getData("/IBank/W0_1<2>") getData("/IBank/W0_1<1>") getData("/IBank/W0_1<0>") getData("/IBank/G01") getData("/IBank/~R1_1<3>") getData("/IBank/~R1_1<2>") getData("/IBank/~R1_1<1>") getData("/IBank/~R1_1<0>") getData("/IBank/A_1<63>") getData("/IBank/A_1<62>") getData("/IBank/A_1<61>") getData("/IBank/A_1<60>") getData("/IBank/A_1<59>") getData("/IBank/A_1<58>") getData("/IBank/A_1<57>") getData("/IBank/A_1<56>") getData("/IBank/A_1<55>") getData("/IBank/A_1<54>") getData("/IBank/A_1<53>") getData("/IBank/A_1<52>") getData("/IBank/A_1<51>") getData("/IBank/A_1<50>") getData("/IBank/A_1<49>") getData("/IBank/A_1<48>") getData("/IBank/A_1<47>") getData("/IBank/A_1<46>") getData("/IBank/A_1<45>") getData("/IBank/A_1<44>") getData("/IBank/A_1<43>") getData("/IBank/A_1<42>") getData("/IBank/A_1<41>") getData("/IBank/A_1<40>") getData("/IBank/A_1<39>") getData("/IBank/A_1<38>") getData("/IBank/A_1<37>") getData("/IBank/A_1<36>") getData("/IBank/A_1<35>") getData("/IBank/A_1<34>") getData("/IBank/A_1<33>") getData("/IBank/A_1<32>") getData("/IBank/A_1<31>") getData("/IBank/A_1<30>") getData("/IBank/A_1<29>") getData("/IBank/A_1<28>") getData("/IBank/A_1<27>") getData("/IBank/A_1<26>") getData("/IBank/A_1<25>") getData("/IBank/A_1<24>") getData("/IBank/A_1<23>") getData("/IBank/A_1<22>") getData("/IBank/A_1<21>") getData("/IBank/A_1<20>") getData("/IBank/A_1<19>") getData("/IBank/A_1<18>") getData("/IBank/A_1<17>") getData("/IBank/A_1<16>") getData("/IBank/A_1<15>") getData("/IBank/A_1<14>") getData("/IBank/A_1<13>") getData("/IBank/A_1<12>") getData("/IBank/A_1<11>") getData("/IBank/A_1<10>") getData("/IBank/A_1<9>") getData("/IBank/A_1<8>") getData("/IBank/A_1<7>") getData("/IBank/A_1<6>") getData("/IBank/A_1<5>") getData("/IBank/A_1<4>") getData("/IBank/A_1<3>") getData("/IBank/A_1<2>") getData("/IBank/A_1<1>") getData("/IBank/A_1<0>") getData("/IBank/S_1<7>") getData("/IBank/S_1<6>") getData("/IBank/S_1<5>") getData("/IBank/S_1<4>") getData("/IBank/S_1<3>") getData("/IBank/S_1<2>") getData("/IBank/S_1<1>") getData("/IBank/S_1<0>") getData("/AT<7>") getData("/AT<6>") getData("/AT<5>") getData("/AT<4>") getData("/AT<3>") getData("/AT<2>") getData("/AT<1>") getData("/AT<0>") getData("/AT<11>") getData("/AT<10>") getData("/AT<9>") getData("/AT<8>") getData("/AT<15>") getData("/AT<14>") getData("/AT<13>") getData("/AT<12>") getData("/IBank/AvAck<3>") getData("/IBank/AvAck<2>") getData("/IBank/AvAck<1>") getData("/IBank/AvAck<0>") getData("/AT<19>") getData("/AT<18>") getData("/AT<17>") getData("/AT<16>") getData("/RWT<1>") getData("/RWT<0>") getData("/IBank/ValAddr") getData("/IBank/ck<0>") getData("/IBank/ck<1>") getData("/IBank/Reset") getData("/IBank/ck<3>") getData("/IBank/ck<2>") getData("/IBank/outAck") getData("/IBank/I0/I0/I0/I7/I3/Q1") getData("/IBank/I0/I0/I0/I7/I3/Q0") getData("/IBank/I0/I0/B0P1") getData("/IBank/I0/I0/B1P1") getData("/V0/PLUS") getData("/vcc!") getData("/vdd!") getData("/V1/PLUS") getData("/V1/MINUS") getData("/V0/MINUS") )
