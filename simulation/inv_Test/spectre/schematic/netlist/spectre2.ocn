simulator( 'spectre )
design(	 "/net/kafka/nfs/rstdenis/Cadence/simulation/inv_Test/spectre/schematic/netlist/netlist")
resultsDir( "/net/kafka/nfs/rstdenis/Cadence/simulation/inv_Test/spectre/schematic" )
modelFile(
    '("/root/Desktop/Cadence/ncsu-FreePDK15/hspice_16nm_lstp.include" "")
)
analysis('tran ?stop "2*VAR(\"time2\")"  ?errpreset "conservative"  )
desVar(	  "nfinp" "wp/40n"	)
desVar(	  "nfinn" "wn/40n"	)
desVar(	  "vdd" 850m	)
desVar(	  "time2" 200n	)
desVar(	  "l" 20n	)
desVar(	  "wp" 120n	)
desVar(	  "wn" 80n	)
envOption(
	'analysisOrder  list("tran")
)
save( 'v "/in" "/out" )
save( 'i "/V0/MINUS" )
temp( 27 )
run()
selectResult( 'tran )
plot(getData("/in") getData("/out") getData("/V0/MINUS") )
