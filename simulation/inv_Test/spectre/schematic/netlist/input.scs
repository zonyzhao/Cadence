// Design: 16nm_Tests/inv_Test
simulator lang=spectre
global 0 vdd!
parameters _EXPR_2=4e-07 wn=8e-08 wp=1.2e-07 l=20n time2=200n vdd=850m nfinn=wn/40n nfinp=wp/40n
include "/root/Desktop/Cadence/ncsu-FreePDK15/hspice_16nm_lstp.include"

// 16nm_Tests/inv_Test/schematic
M0 (out in vdd! vdd!) pfet w=wp l=l nfin=nfinp m=1 degradation=yes
V1 (in 0) vsource type=pwl mag=0 phase=0 wave=[ 0 0 time2 vdd ]
M1 (out in 0 0) nfet w=wn l=l nfin=nfinn m=1 degradation=no
V0 (vdd! 0) vsource type=dc dc=vdd
simulatorOptions options temp=27
tran tran stop=_EXPR_2 errpreset=conservative
save in out V0:p
