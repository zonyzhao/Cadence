simulator( 'spectre )
design(	 "/net/kafka/nfs/rstdenis/Cadence/simulation/inv_Test/spectre/schematic/netlist/netlist")
resultsDir( "/net/kafka/nfs/rstdenis/Cadence/simulation/inv_Test/spectre/schematic" )
modelFile(
    '("/root/Desktop/Cadence/ncsu-FreePDK15/hspice_16nm_lstp.include" "")
)
analysis('tran ?stop "10n"  ?errpreset "conservative"  )
desVar(	  "vdd" .850	)
envOption(
	'analysisOrder  list("tran")
)
save( 'v "/in" "/out" )
save( 'i "/Iin/PLUS" )
temp( 27 )
run()
selectResult( 'tran )
plot(getData("/in") getData("/out") getData("/Iin/PLUS") )
modelFile(
    '("/root/Desktop/Cadence/ncsu-FreePDK15/hspice_16nm_lstp.include" "")
)
analysis('tran ?stop "VAR(\"time2\")"  )
desVar(	  "time2" 100n	)
save( 'i /Iin/PLUS )
run()
selectResult( 'tran )
plot(getData("/in") getData("/out") )
modelFile(
    '("/root/Desktop/Cadence/ncsu-FreePDK15/hspice_16nm_lstp.include" "")
)
run()
selectResult( 'tran )
plot(getData("/in") getData("/out") )
modelFile(
    '("/root/Desktop/Cadence/ncsu-FreePDK15/hspice_16nm_lstp.include" "")
)
desVar(	  "nfinp" "wp/100n"	)
desVar(	  "nfinn" "wn/60n"	)
desVar(	  "l" 20n	)
desVar(	  "wp" 60n	)
desVar(	  "wn" 100n	)
save( 'i "/V0/MINUS" )
run()
selectResult( 'tran )
plot(getData("/in") getData("/out") getData("/V0/MINUS") )
modelFile(
    '("/root/Desktop/Cadence/ncsu-FreePDK15/hspice_16nm_lstp.include" "")
)
run()
selectResult( 'tran )
plot(getData("/in") getData("/out") getData("/V0/MINUS") )
modelFile(
    '("/root/Desktop/Cadence/ncsu-FreePDK15/hspice_16nm_lstp.include" "")
)
desVar(	  "nfinp" "wp/60n"	)
desVar(	  "time2" 100p	)
run()
selectResult( 'tran )
plot(getData("/in") getData("/out") getData("/V0/MINUS") )
modelFile(
    '("/root/Desktop/Cadence/ncsu-FreePDK15/hspice_16nm_lstp.include" "")
)
desVar(	  "time2" 50p	)
run()
selectResult( 'tran )
plot(getData("/in") getData("/out") getData("/V0/MINUS") )
modelFile(
    '("/root/Desktop/Cadence/ncsu-FreePDK15/hspice_16nm_lstp.include" "")
)
desVar(	  "time2" 2p	)
run()
selectResult( 'tran )
plot(getData("/in") getData("/out") getData("/V0/MINUS") )
modelFile(
    '("/root/Desktop/Cadence/ncsu-FreePDK15/hspice_16nm_lstp.include" "")
)
analysis('tran ?stop "10*VAR(\"time2\")"  )
run()
selectResult( 'tran )
plot(getData("/in") getData("/out") getData("/V0/MINUS") )
modelFile(
    '("/root/Desktop/Cadence/ncsu-FreePDK15/hspice_16nm_lstp.include" "")
)
desVar(	  "time2" 50p	)
run()
selectResult( 'tran )
plot(getData("/in") getData("/out") getData("/V0/MINUS") )
modelFile(
    '("/root/Desktop/Cadence/ncsu-FreePDK15/hspice_16nm_lstp.include" "")
)
desVar(	  "time2" 100p	)
run()
selectResult( 'tran )
plot(getData("/in") getData("/out") getData("/V0/MINUS") )
modelFile(
    '("/root/Desktop/Cadence/ncsu-FreePDK15/hspice_16nm_lstp.include" "")
)
desVar(	  "time2" 1n	)
run()
selectResult( 'tran )
plot(getData("/in") getData("/out") getData("/V0/MINUS") )
modelFile(
    '("/root/Desktop/Cadence/ncsu-FreePDK15/hspice_16nm_lstp.include" "")
)
analysis('tran ?stop "VAR(\"time2\")"  )
desVar(	  "time2" 2n	)
run()
selectResult( 'tran )
plot(getData("/in") getData("/out") getData("/V0/MINUS") )
modelFile(
    '("/root/Desktop/Cadence/ncsu-FreePDK15/hspice_16nm_lstp.include" "")
)
analysis('tran ?stop "2*VAR(\"time2\")"  )
desVar(	  "vdd" .5	)
desVar(	  "time2" 10n	)
run()
selectResult( 'tran )
plot(getData("/in") getData("/out") getData("/V0/MINUS") )
modelFile(
    '("/root/Desktop/Cadence/ncsu-FreePDK15/hspice_16nm_lstp.include" "")
)
desVar(	  "time2" 100n	)
run()
selectResult( 'tran )
plot(getData("/in") getData("/out") getData("/V0/MINUS") )
modelFile(
    '("/root/Desktop/Cadence/ncsu-FreePDK15/hspice_16nm_lstp.include" "")
)
desVar(	  "time2" 200n	)
run()
selectResult( 'tran )
plot(getData("/in") getData("/out") getData("/V0/MINUS") )
modelFile(
    '("/root/Desktop/Cadence/ncsu-FreePDK15/hspice_16nm_lstp.include" "")
)
desVar(	  "vdd" 850m	)
run()
selectResult( 'tran )
plot(getData("/in") getData("/out") getData("/V0/MINUS") )
