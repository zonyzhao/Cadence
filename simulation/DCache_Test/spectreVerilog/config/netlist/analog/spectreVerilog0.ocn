simulator( 'spectreVerilog )
design(	 "/cerl/kstraube/Cadence/KramerSimulation/DCache_Test/spectreVerilog/config/netlist/analog/netlist")
resultsDir( "/cerl/kstraube/Cadence/KramerSimulation/DCache_Test/spectreVerilog/config" )
modelFile(
    '("/software/cadence/ncsu-FreePDK15/hspice_16nm_hp.include" "")
)
analysis('tran ?stop "10n"  ?errpreset "conservative"  )
desVar(	  "vdd" 0.85	)
desVar(	  "vcc" 0.85	)
envOption(
	'analysisOrder  list("tran")
)
saveOption( ?simOutputFormat "psfxl" )
converge( 'ic "/L1RE" "0" )
converge( 'ic "/net089" "0" )
converge( 'ic "/net090" "0" )
converge( 'ic "/net097" "0" )
converge( 'ic "/net095" "0" )
converge( 'ic "/net068" "0" )
converge( 'ic "/net056" "0" )
converge( 'ic "/net0133" "0" )
converge( 'ic "/net0102" "0" )
converge( 'ic "/net069" "0" )
converge( 'ic "/net047" "0" )
converge( 'ic "/net019" "0" )
converge( 'ic "/net0105" "0" )
converge( 'ic "/net071" "0" )
converge( 'ic "/net070" "0" )
converge( 'ic "/AckT" "0" )
converge( 'ic "/net016" "0" )
converge( 'ic "/net074" "0" )
converge( 'ic "/ReadEnable" "0" )
converge( 'ic "/WriteEnable" "0" )
converge( 'ic "/I21/I0/I0/I0/I0/I0/I1/I0/Q1" "0" )
converge( 'ic "/I21/I0/I0/I0/I0/I0/I1/I0/Q0" "vdd" )
converge( 'ic "/I17/I0/I1/I7/I0/Q" "vdd" )
converge( 'ic "/I17/I0/I1/I7/I0/Qb" "0" )
temp( 27 )
run()
selectResult( 'tran )
plot(getData("/OutFIFOReq") getData("/OutFIFOAck") getData("/AckT") getData("/net016") getData("/MissInvalid") getData("/TagRAck") )
modelFile(
    '("/software/cadence/ncsu-FreePDK15/hspice_16nm_hp.include" "")
)
run()
selectResult( 'tran )
plot(getData("/OutFIFOReq") getData("/OutFIFOAck") getData("/AckT") getData("/net016") getData("/MissInvalid") getData("/TagRAck") )
modelFile(
    '("/software/cadence/ncsu-FreePDK15/hspice_16nm_hp.include" "")
)
save( 'i "/I32/WriteToL1MissTagAck" "/I32/WriteToL1MissReq" "/I32/TagWrRegReq" "/I32/TagWrRegAck" "/I32/TagWE" "/I32/TagWDataSel" "/I32/TagWAck" "/I32/L2DataOutTagAck" "/I32/L2DataOutReq" "/I34/ReadWBFromL1Req" "/I34/ReadWBFromL1Ack" "/I34/ReadFromL1Req" "/I34/ReadFromL1Ack" "/I34/OutFIFOReq" "/I34/OutFIFOAck" "/I34/L1WBRegReq" "/I34/L1WBRegAck" "/I34/L1RdRegReq" "/I34/L1RdRegAck" "/I34/L1RE" "/I34/L1RAck" )
run()
selectResult( 'tran )
plot(getData("/TagRAck") getData("/MissInvalid") getData("/net016") getData("/AckT") getData("/OutFIFOAck") getData("/OutFIFOReq") getData("/I32/WriteToL1MissTagAck") getData("/I32/WriteToL1MissReq") getData("/I32/TagWrRegReq") getData("/I32/TagWrRegAck") getData("/I32/TagWE") getData("/I32/TagWDataSel") getData("/I32/TagWAck") getData("/I32/L2DataOutTagAck") getData("/I32/L2DataOutReq") getData("/I34/ReadWBFromL1Req") getData("/I34/ReadWBFromL1Ack") getData("/I34/ReadFromL1Req") getData("/I34/ReadFromL1Ack") getData("/I34/OutFIFOReq") getData("/I34/OutFIFOAck") getData("/I34/L1WBRegReq") getData("/I34/L1WBRegAck") getData("/I34/L1RdRegReq") getData("/I34/L1RdRegAck") getData("/I34/L1RE") getData("/I34/L1RAck") )
modelFile(
    '("/software/cadence/ncsu-FreePDK15/hspice_16nm_hp.include" "")
    '("/cerl/kstraube/Cadence/ATSim/Tag_write_ctrl_rev3/spectreText/spectre.scs" "")
    '("/cerl/kstraube/Cadence/ATSim/L1_write_ctrl_rev3/spectreText/spectre.scs" "")
    '("/cerl/kstraube/Cadence/ATSim/L1_read_ctrl_rev3/spectreText/spectre.scs" "")
)
run()
selectResult( 'tran )
plot(getData("/TagRAck") getData("/MissInvalid") getData("/net016") getData("/AckT") getData("/OutFIFOAck") getData("/OutFIFOReq") getData("/I32/WriteToL1MissTagAck") getData("/I32/WriteToL1MissReq") getData("/I32/TagWrRegReq") getData("/I32/TagWrRegAck") getData("/I32/TagWE") getData("/I32/TagWDataSel") getData("/I32/TagWAck") getData("/I32/L2DataOutTagAck") getData("/I32/L2DataOutReq") getData("/I34/ReadWBFromL1Req") getData("/I34/ReadWBFromL1Ack") getData("/I34/ReadFromL1Req") getData("/I34/ReadFromL1Ack") getData("/I34/OutFIFOReq") getData("/I34/OutFIFOAck") getData("/I34/L1WBRegReq") getData("/I34/L1WBRegAck") getData("/I34/L1RdRegReq") getData("/I34/L1RdRegAck") getData("/I34/L1RE") getData("/I34/L1RAck") )
modelFile(
    '("/software/cadence/ncsu-FreePDK15/hspice_16nm_hp.include" "")
    '("/cerl/kstraube/Cadence/ATSim/Tag_write_ctrl_rev3/spectreText/spectre.scs" "")
    '("/cerl/kstraube/Cadence/ATSim/L1_write_ctrl_rev3/spectreText/spectre.scs" "")
    '("/cerl/kstraube/Cadence/ATSim/L1_read_ctrl_rev3/spectreText/spectre.scs" "")
)
run()
selectResult( 'tran )
plot(getData("/TagRAck") getData("/MissInvalid") getData("/net016") getData("/AckT") getData("/OutFIFOAck") getData("/OutFIFOReq") getData("/I32/WriteToL1MissTagAck") getData("/I32/WriteToL1MissReq") getData("/I32/TagWrRegReq") getData("/I32/TagWrRegAck") getData("/I32/TagWE") getData("/I32/TagWDataSel") getData("/I32/TagWAck") getData("/I32/L2DataOutTagAck") getData("/I32/L2DataOutReq") getData("/I34/ReadWBFromL1Req") getData("/I34/ReadWBFromL1Ack") getData("/I34/ReadFromL1Req") getData("/I34/ReadFromL1Ack") getData("/I34/OutFIFOReq") getData("/I34/OutFIFOAck") getData("/I34/L1WBRegReq") getData("/I34/L1WBRegAck") getData("/I34/L1RdRegReq") getData("/I34/L1RdRegAck") getData("/I34/L1RE") getData("/I34/L1RAck") )
modelFile(
    '("/software/cadence/ncsu-FreePDK15/hspice_16nm_hp.include" "")
    '("/cerl/kstraube/Cadence/ATSim/Tag_write_ctrl_rev3/spectreText/spectre.scs" "")
    '("/cerl/kstraube/Cadence/ATSim/L1_write_ctrl_rev3/spectreText/spectre.scs" "")
    '("/cerl/kstraube/Cadence/ATSim/L1_read_ctrl_rev3/spectreText/spectre.scs" "")
)
run()
selectResult( 'tran )
plot(getData("/TagRAck") getData("/MissInvalid") getData("/net016") getData("/AckT") getData("/OutFIFOAck") getData("/OutFIFOReq") getData("/I32/WriteToL1MissTagAck") getData("/I32/WriteToL1MissReq") getData("/I32/TagWrRegReq") getData("/I32/TagWrRegAck") getData("/I32/TagWE") getData("/I32/TagWDataSel") getData("/I32/TagWAck") getData("/I32/L2DataOutTagAck") getData("/I32/L2DataOutReq") getData("/I34/ReadWBFromL1Req") getData("/I34/ReadWBFromL1Ack") getData("/I34/ReadFromL1Req") getData("/I34/ReadFromL1Ack") getData("/I34/OutFIFOReq") getData("/I34/OutFIFOAck") getData("/I34/L1WBRegReq") getData("/I34/L1WBRegAck") getData("/I34/L1RdRegReq") getData("/I34/L1RdRegAck") getData("/I34/L1RE") getData("/I34/L1RAck") )
modelFile(
    '("/software/cadence/ncsu-FreePDK15/hspice_16nm_hp.include" "")
    '("/cerl/kstraube/Cadence/ATSim/Tag_write_ctrl_rev3/spectreText/spectre.scs" "")
    '("/cerl/kstraube/Cadence/ATSim/L1_write_ctrl_rev3/spectreText/spectre.scs" "")
    '("/cerl/kstraube/Cadence/ATSim/L1_read_ctrl_rev3/spectreText/spectre.scs" "")
)
run()
selectResult( 'tran )
plot(getData("/TagRAck") getData("/MissInvalid") getData("/net016") getData("/AckT") getData("/OutFIFOAck") getData("/OutFIFOReq") getData("/I32/WriteToL1MissTagAck") getData("/I32/WriteToL1MissReq") getData("/I32/TagWrRegReq") getData("/I32/TagWrRegAck") getData("/I32/TagWE") getData("/I32/TagWDataSel") getData("/I32/TagWAck") getData("/I32/L2DataOutTagAck") getData("/I32/L2DataOutReq") getData("/I34/ReadWBFromL1Req") getData("/I34/ReadWBFromL1Ack") getData("/I34/ReadFromL1Req") getData("/I34/ReadFromL1Ack") getData("/I34/OutFIFOReq") getData("/I34/OutFIFOAck") getData("/I34/L1WBRegReq") getData("/I34/L1WBRegAck") getData("/I34/L1RdRegReq") getData("/I34/L1RdRegAck") getData("/I34/L1RE") getData("/I34/L1RAck") )
