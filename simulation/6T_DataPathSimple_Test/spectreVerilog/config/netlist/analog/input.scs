// Design: 16nm_Tests/6T_DataPathSimple_Test
simulator lang=spectre
global 0 vdd! vcc!
parameters vdd=.850
include "/software/cadence/ncsu-FreePDK15/hspice_16nm_hp.include"

// 16nm/6T/schematic
//system verilogNetlist schematic cmos.sch cmos_sch veriloga ahdl
subckt _sub0 A B0 B1
    M5 (Q0 Q1 0 0) nfet w=60n l=20n nfin=1 m=1 degradation=no
    M4 (Q1 Q0 0 0) nfet w=60n l=20n nfin=1 m=1 degradation=no
    M1 (Q1 A B1 0) nfet w=120n l=20n nfin=2 m=1 degradation=no
    M0 (Q0 A B0 0) nfet w=120n l=20n nfin=2 m=1 degradation=no
    M3 (Q0 Q1 vdd! vdd!) pfet w=100n l=20n nfin=1 m=1 degradation=no
    M2 (Q1 Q0 vdd! vdd!) pfet w=100n l=20n nfin=1 m=1 degradation=no
ends _sub0

// 16nm/6T_4x/schematic
//system verilogNetlist schematic cmos.sch cmos_sch veriloga ahdl
subckt _sub1 A_3 A_2 A_1 A_0 B0 B1
    I3 (A_0 B0 B1) _sub0
    I2 (A_1 B0 B1) _sub0
    I1 (A_2 B0 B1) _sub0
    I0 (A_3 B0 B1) _sub0
ends _sub1

// 16nm/6T_32x/schematic
//system verilogNetlist schematic cmos.sch cmos_sch veriloga ahdl
subckt _sub2 B0 B1 A_31 A_30 A_29 A_28 A_27 A_26 A_25 A_24 A_23 A_22 A_21 A_20 A_19 A_18 A_17 A_16 A_15 A_14 A_13 A_12 A_11 A_10 A_9 A_8 A_7 A_6 A_5 A_4 A_3 A_2 A_1 A_0
    I7 (A_3 A_2 A_1 A_0 B0 B1) _sub1
    I6 (A_7 A_6 A_5 A_4 B0 B1) _sub1
    I5 (A_11 A_10 A_9 A_8 B0 B1) _sub1
    I4 (A_15 A_14 A_13 A_12 B0 B1) _sub1
    I3 (A_19 A_18 A_17 A_16 B0 B1) _sub1
    I2 (A_23 A_22 A_21 A_20 B0 B1) _sub1
    I1 (A_27 A_26 A_25 A_24 B0 B1) _sub1
    I0 (A_31 A_30 A_29 A_28 B0 B1) _sub1
ends _sub2

// 16nm/6T_32x_CTRL/schematic
//system verilogNetlist schematic cmos.sch cmos_sch veriloga ahdl
subckt _sub3 B0 B1 S W0 W1
    M10 (B1 B0 net22 vdd!) pfet w=100n l=20n nfin=1 m=1 degradation=no
    M9 (net22 W1 vdd! vdd!) pfet w=100n l=20n nfin=1 m=1 degradation=no
    M8 (B0 B1 net23 vdd!) pfet w=100n l=20n nfin=1 m=1 degradation=no
    M7 (net23 W0 vdd! vdd!) pfet w=100n l=20n nfin=1 m=1 degradation=no
    M2 (B1 S vdd! vdd!) pfet w=100n l=20n nfin=1 m=1 degradation=no
    M0 (B0 S vdd! vdd!) pfet w=100n l=20n nfin=1 m=1 degradation=no
    M6 (B1 W1 net24 0) nfet w=60n l=20n nfin=1 m=1 degradation=no
    M5 (net24 S 0 0) nfet w=60n l=20n nfin=1 m=1 degradation=no
    M4 (net25 S 0 0) nfet w=60n l=20n nfin=1 m=1 degradation=no
    M3 (B0 W0 net25 0) nfet w=60n l=20n nfin=1 m=1 degradation=no
ends _sub3

// 16nm/nand4_1x/schematic
//system verilogNetlist schematic cmos.sch cmos_sch veriloga ahdl
subckt nand4_1x A B C D Y
    M5 (Y D vdd! vdd!) pfet w=100n l=20n nfin=1 m=1 degradation=no
    M4 (Y C vdd! vdd!) pfet w=100n l=20n nfin=1 m=1 degradation=no
    M1 (Y B vdd! vdd!) pfet w=100n l=20n nfin=1 m=1 degradation=no
    M0 (Y A vdd! vdd!) pfet w=100n l=20n nfin=1 m=1 degradation=no
    M7 (net23 D 0 0) nfet w=240n l=20n nfin=1 m=1 degradation=no
    M6 (net25 C net23 0) nfet w=240n l=20n nfin=1 m=1 degradation=no
    M3 (net24 B net25 0) nfet w=240n l=20n nfin=1 m=1 degradation=no
    M2 (Y A net24 0) nfet w=240n l=20n nfin=1 m=1 degradation=no
ends nand4_1x

// 16nm/6T_32x4/schematic
//system verilogNetlist schematic cmos.sch cmos_sch veriloga ahdl
subckt _sub4 A_31 A_30 A_29 A_28 A_27 A_26 A_25 A_24 A_23 A_22 A_21 A_20 A_19 A_18 A_17 A_16 A_15 A_14 A_13 A_12 A_11 A_10 A_9 A_8 A_7 A_6 A_5 A_4 A_3 A_2 A_1 A_0 B0 B1 S_3 S_2 S_1 S_0 W0 W1 SM1 SM0
    I3 (B0P4 B1P4 A_31 A_30 A_29 A_28 A_27 A_26 A_25 A_24 A_23 A_22 A_21 A_20 A_19 A_18 A_17 A_16 A_15 A_14 A_13 A_12 A_11 A_10 A_9 A_8 A_7 A_6 A_5 A_4 A_3 A_2 A_1 A_0) _sub2
    I1 (B0P2 B1P2 A_31 A_30 A_29 A_28 A_27 A_26 A_25 A_24 A_23 A_22 A_21 A_20 A_19 A_18 A_17 A_16 A_15 A_14 A_13 A_12 A_11 A_10 A_9 A_8 A_7 A_6 A_5 A_4 A_3 A_2 A_1 A_0) _sub2
    I2 (B0P3 B1P3 A_31 A_30 A_29 A_28 A_27 A_26 A_25 A_24 A_23 A_22 A_21 A_20 A_19 A_18 A_17 A_16 A_15 A_14 A_13 A_12 A_11 A_10 A_9 A_8 A_7 A_6 A_5 A_4 A_3 A_2 A_1 A_0) _sub2
    I0 (B0P1 B1P1 A_31 A_30 A_29 A_28 A_27 A_26 A_25 A_24 A_23 A_22 A_21 A_20 A_19 A_18 A_17 A_16 A_15 A_14 A_13 A_12 A_11 A_10 A_9 A_8 A_7 A_6 A_5 A_4 A_3 A_2 A_1 A_0) _sub2
    M0 (B0P1 B0 net67 0) nfet w=60n l=20n nfin=1 m=1 degradation=no
    M1 (net67 S_0 0 0) nfet w=60n l=20n nfin=1 m=1 degradation=no
    M2 (net66 S_0 0 0) nfet w=60n l=20n nfin=1 m=1 degradation=no
    M8 (B1P2 B1 net65 0) nfet w=60n l=20n nfin=1 m=1 degradation=no
    M9 (net65 S_1 0 0) nfet w=60n l=20n nfin=1 m=1 degradation=no
    M10 (net64 S_1 0 0) nfet w=60n l=20n nfin=1 m=1 degradation=no
    M11 (B0P2 B0 net64 0) nfet w=60n l=20n nfin=1 m=1 degradation=no
    M12 (B0P3 B0 net63 0) nfet w=60n l=20n nfin=1 m=1 degradation=no
    M13 (net63 S_2 0 0) nfet w=60n l=20n nfin=1 m=1 degradation=no
    M14 (net62 S_2 0 0) nfet w=60n l=20n nfin=1 m=1 degradation=no
    M15 (B1P3 B1 net62 0) nfet w=60n l=20n nfin=1 m=1 degradation=no
    M16 (B1P4 B1 net61 0) nfet w=60n l=20n nfin=1 m=1 degradation=no
    M17 (net61 S_3 0 0) nfet w=60n l=20n nfin=1 m=1 degradation=no
    M18 (net60 S_3 0 0) nfet w=60n l=20n nfin=1 m=1 degradation=no
    M19 (B0P4 B0 net60 0) nfet w=60n l=20n nfin=1 m=1 degradation=no
    M3 (B1P1 B1 net66 0) nfet w=60n l=20n nfin=1 m=1 degradation=no
    I4 (B0P1 B1P1 S_0 W0 W1) _sub3
    I5 (B0P2 B1P2 S_1 W0 W1) _sub3
    I6 (B0P3 B1P3 S_2 W0 W1) _sub3
    I7 (B0P4 B1P4 S_3 W0 W1) _sub3
    I11 (B1P1 B1P2 B1P3 B1P4 SM1) nand4_1x
    I10 (B0P1 B0P2 B0P3 B0P4 SM0) nand4_1x
    C7 (B1P4 0) capacitor c=1.2822f m=1
    C6 (B1P2 0) capacitor c=1.2822f m=1
    C5 (B1P3 0) capacitor c=1.2822f m=1
    C4 (B0P4 0) capacitor c=1.2822f m=1
    C3 (B0P3 0) capacitor c=1.2822f m=1
    C2 (B0P2 0) capacitor c=1.2822f m=1
    C1 (B1P1 0) capacitor c=1.2822f m=1
    C0 (B0P1 0) capacitor c=1.2822f m=1
    M5 (B1P1 S_0 vdd! vdd!) pfet w=100n l=20n nfin=1 m=1 degradation=no
    M4 (B0P1 S_0 vdd! vdd!) pfet w=100n l=20n nfin=1 m=1 degradation=no
    M6 (B1P2 S_1 vdd! vdd!) pfet w=100n l=20n nfin=1 m=1 degradation=no
    M7 (B0P2 S_1 vdd! vdd!) pfet w=100n l=20n nfin=1 m=1 degradation=no
    M21 (B1P3 S_2 vdd! vdd!) pfet w=100n l=20n nfin=1 m=1 degradation=no
    M20 (B0P3 S_2 vdd! vdd!) pfet w=100n l=20n nfin=1 m=1 degradation=no
    M23 (B0P4 S_3 vdd! vdd!) pfet w=100n l=20n nfin=1 m=1 degradation=no
    M22 (B1P4 S_3 vdd! vdd!) pfet w=100n l=20n nfin=1 m=1 degradation=no
ends _sub4

// 16nm/6T_SetRead/schematic
//system verilogNetlist schematic cmos.sch cmos_sch veriloga ahdl
subckt _sub5 \~R0 \~R1 Go SM0_0 SM0_1 SM1_0 SM1_1
    M5 (\~R0 SM0_0 net18 0) nfet w=60n l=20n nfin=1 m=1 degradation=no
    M3 (\~R0 SM0_1 net18 0) nfet w=60n l=20n nfin=1 m=1 degradation=no
    M2 (net18 Go 0 0) nfet w=120n l=20n nfin=2 m=1 degradation=no
    M1 (\~R1 SM1_1 net18 0) nfet w=60n l=20n nfin=1 m=1 degradation=no
    M0 (\~R1 SM1_0 net18 0) nfet w=60n l=20n nfin=1 m=1 degradation=no
ends _sub5

// 16nm/6T_CHUNK/schematic
//system verilogNetlist schematic cmos.sch cmos_sch veriloga ahdl
subckt _sub6 \~R0_3 \~R0_2 \~R0_1 \~R0_0 \~R1_3 \~R1_2 \~R1_1 \~R1_0 A_63 A_62 A_61 A_60 A_59 A_58 A_57 A_56 A_55 A_54 A_53 A_52 A_51 A_50 A_49 A_48 A_47 A_46 A_45 A_44 A_43 A_42 A_41 A_40 A_39 A_38 A_37 A_36 A_35 A_34 A_33 A_32 A_31 A_30 A_29 A_28 A_27 A_26 A_25 A_24 A_23 A_22 A_21 A_20 A_19 A_18 A_17 A_16 A_15 A_14 A_13 A_12 A_11 A_10 A_9 A_8 A_7 A_6 A_5 A_4 A_3 A_2 A_1 A_0 B0_3 B0_2 B0_1 B0_0 B1_3 B1_2 B1_1 B1_0 S_7 S_6 S_5 S_4 S_3 S_2 S_1 S_0 W0_3 W0_2 W0_1 W0_0 W1_3 W1_2 W1_1 W1_0 Go
    I11 (A_63 A_62 A_61 A_60 A_59 A_58 A_57 A_56 A_55 A_54 A_53 A_52 A_51 A_50 A_49 A_48 A_47 A_46 A_45 A_44 A_43 A_42 A_41 A_40 A_39 A_38 A_37 A_36 A_35 A_34 A_33 A_32 B0_3 B1_3 S_7 S_6 S_5 S_4 W0_3 W1_3 SM1_1_bit3 SM0_1_bit3) _sub4
    I10 (A_63 A_62 A_61 A_60 A_59 A_58 A_57 A_56 A_55 A_54 A_53 A_52 A_51 A_50 A_49 A_48 A_47 A_46 A_45 A_44 A_43 A_42 A_41 A_40 A_39 A_38 A_37 A_36 A_35 A_34 A_33 A_32 B0_2 B1_2 S_7 S_6 S_5 S_4 W0_2 W1_2 SM1_1_bit2 SM0_1_bit2) _sub4
    I9 (A_63 A_62 A_61 A_60 A_59 A_58 A_57 A_56 A_55 A_54 A_53 A_52 A_51 A_50 A_49 A_48 A_47 A_46 A_45 A_44 A_43 A_42 A_41 A_40 A_39 A_38 A_37 A_36 A_35 A_34 A_33 A_32 B0_1 B1_1 S_7 S_6 S_5 S_4 W0_1 W1_1 SM1_1_bit1 SM0_1_bit1) _sub4
    I8 (A_63 A_62 A_61 A_60 A_59 A_58 A_57 A_56 A_55 A_54 A_53 A_52 A_51 A_50 A_49 A_48 A_47 A_46 A_45 A_44 A_43 A_42 A_41 A_40 A_39 A_38 A_37 A_36 A_35 A_34 A_33 A_32 B0_0 B1_0 S_7 S_6 S_5 S_4 W0_0 W1_0 SM1_1_bit0 SM0_1_bit0) _sub4
    I3 (A_31 A_30 A_29 A_28 A_27 A_26 A_25 A_24 A_23 A_22 A_21 A_20 A_19 A_18 A_17 A_16 A_15 A_14 A_13 A_12 A_11 A_10 A_9 A_8 A_7 A_6 A_5 A_4 A_3 A_2 A_1 A_0 B0_3 B1_3 S_3 S_2 S_1 S_0 W0_3 W1_3 SM1_0_bit3 SM0_0_bit3) _sub4
    I2 (A_31 A_30 A_29 A_28 A_27 A_26 A_25 A_24 A_23 A_22 A_21 A_20 A_19 A_18 A_17 A_16 A_15 A_14 A_13 A_12 A_11 A_10 A_9 A_8 A_7 A_6 A_5 A_4 A_3 A_2 A_1 A_0 B0_2 B1_2 S_3 S_2 S_1 S_0 W0_2 W1_2 SM1_0_bit2 SM0_0_bit2) _sub4
    I1 (A_31 A_30 A_29 A_28 A_27 A_26 A_25 A_24 A_23 A_22 A_21 A_20 A_19 A_18 A_17 A_16 A_15 A_14 A_13 A_12 A_11 A_10 A_9 A_8 A_7 A_6 A_5 A_4 A_3 A_2 A_1 A_0 B0_1 B1_1 S_3 S_2 S_1 S_0 W0_1 W1_1 SM1_0_bit1 SM0_0_bit1) _sub4
    I0 (A_31 A_30 A_29 A_28 A_27 A_26 A_25 A_24 A_23 A_22 A_21 A_20 A_19 A_18 A_17 A_16 A_15 A_14 A_13 A_12 A_11 A_10 A_9 A_8 A_7 A_6 A_5 A_4 A_3 A_2 A_1 A_0 B0_0 B1_0 S_3 S_2 S_1 S_0 W0_0 W1_0 SM1_0_bit0 SM0_0_bit0) _sub4
    I7 (\~R0_3 \~R1_3 Go SM0_0_bit3 SM0_1_bit3 SM1_0_bit3 SM1_1_bit3) _sub5
    I6 (\~R0_2 \~R1_2 Go SM0_0_bit2 SM0_1_bit2 SM1_0_bit2 SM1_1_bit2) _sub5
    I5 (\~R0_1 \~R1_1 Go SM0_0_bit1 SM0_1_bit1 SM1_0_bit1 SM1_1_bit1) _sub5
    I4 (\~R0_0 \~R1_0 Go SM0_0_bit0 SM0_1_bit0 SM1_0_bit0 SM1_1_bit0) _sub5
ends _sub6

// 16nm/inv_1x/schematic
//system verilogNetlist schematic cmos.sch cmos_sch veriloga ahdl
subckt inv_1x A Y
    M0 (Y A 0 0) nfet w=60n l=20n nfin=1 m=1 degradation=no
    M1 (Y A vdd! vdd!) pfet w=100n l=20n nfin=1 m=1 degradation=no
ends inv_1x

// 16nm/and4_1x/schematic
//system verilogNetlist schematic cmos.sch cmos_sch veriloga ahdl
subckt and4_1x A B C D Y
    I15 (A B C D net1) nand4_1x
    I16 (net1 Y) inv_1x
ends and4_1x

// 16nm/Demux_2e1of4/schematic
//system verilogNetlist schematic cmos.sch cmos_sch veriloga ahdl
subckt Demux_2e1of4 A_15 A_14 A_13 A_12 A_11 A_10 A_9 A_8 A_7 A_6 A_5 A_4 A_3 A_2 A_1 A_0 _1of4_1_3 _1of4_1_2 _1of4_1_1 _1of4_1_0 _1of4_2_3 _1of4_2_2 _1of4_2_1 _1of4_2_0 En EnOut
    I15 (_1of4_1_3 _1of4_2_3 EnOut En A_15) and4_1x
    I14 (_1of4_1_2 _1of4_2_3 EnOut En A_14) and4_1x
    I13 (_1of4_1_1 _1of4_2_3 EnOut En A_13) and4_1x
    I12 (_1of4_1_0 _1of4_2_3 EnOut En A_12) and4_1x
    I11 (_1of4_1_3 _1of4_2_2 EnOut En A_11) and4_1x
    I10 (_1of4_1_2 _1of4_2_2 EnOut En A_10) and4_1x
    I9 (_1of4_1_1 _1of4_2_2 EnOut En A_9) and4_1x
    I8 (_1of4_1_0 _1of4_2_2 EnOut En A_8) and4_1x
    I7 (_1of4_1_3 _1of4_2_1 EnOut En A_7) and4_1x
    I6 (_1of4_1_2 _1of4_2_1 EnOut En A_6) and4_1x
    I5 (_1of4_1_1 _1of4_2_1 EnOut En A_5) and4_1x
    I4 (_1of4_1_0 _1of4_2_1 EnOut En A_4) and4_1x
    I3 (_1of4_1_3 _1of4_2_0 EnOut En A_3) and4_1x
    I2 (_1of4_1_2 _1of4_2_0 EnOut En A_2) and4_1x
    I1 (_1of4_1_1 _1of4_2_0 EnOut En A_1) and4_1x
    I0 (_1of4_1_0 _1of4_2_0 EnOut En A_0) and4_1x
ends Demux_2e1of4

// 16nm/nor4_1x/schematic
//system verilogNetlist schematic cmos.sch cmos_sch veriloga ahdl
subckt nor4_1x A B C D Y
    M5 (net017 C net21 vdd!) pfet w=400n l=20n nfin=1 m=1 degradation=no
    M4 (Y D net017 vdd!) pfet w=400n l=20n nfin=1 m=1 degradation=no
    M3 (net21 B net018 vdd!) pfet w=400n l=20n nfin=1 m=1 degradation=no
    M2 (net018 A vdd! vdd!) pfet w=400n l=20n nfin=1 m=1 degradation=no
    M7 (Y D 0 0) nfet w=60n l=20n nfin=1 m=1 degradation=no
    M6 (Y C 0 0) nfet w=60n l=20n nfin=1 m=1 degradation=no
    M1 (Y A 0 0) nfet w=60n l=20n nfin=1 m=1 degradation=no
    M0 (Y B 0 0) nfet w=60n l=20n nfin=1 m=1 degradation=no
ends nor4_1x

// 16nm/or16_1x/schematic
//system verilogNetlist schematic cmos.sch cmos_sch veriloga ahdl
subckt or16_1x Y X_15 X_14 X_13 X_12 X_11 X_10 X_9 X_8 X_7 X_6 X_5 X_4 X_3 X_2 X_1 X_0
    I2 (nX30 nX74 nX118 nX1512 Y) nand4_1x
    I0 (X_0 X_1 X_2 X_3 nX30) nor4_1x
    I1 (X_4 X_5 X_6 X_7 nX74) nor4_1x
    I3 (X_8 X_9 X_10 X_11 nX118) nor4_1x
    I4 (X_12 X_13 X_14 X_15 nX1512) nor4_1x
ends or16_1x

// 16nm/or4_1x/schematic
//system verilogNetlist schematic cmos.sch cmos_sch veriloga ahdl
subckt or4_1x A B C D Y
    I0 (A B C D net11) nor4_1x
    I1 (net11 Y) inv_1x
ends or4_1x

// 16nm/Demux_3e1of4/schematic
//system verilogNetlist schematic cmos.sch cmos_sch veriloga ahdl
subckt Demux_3e1of4 A_63 A_62 A_61 A_60 A_59 A_58 A_57 A_56 A_55 A_54 A_53 A_52 A_51 A_50 A_49 A_48 A_47 A_46 A_45 A_44 A_43 A_42 A_41 A_40 A_39 A_38 A_37 A_36 A_35 A_34 A_33 A_32 A_31 A_30 A_29 A_28 A_27 A_26 A_25 A_24 A_23 A_22 A_21 A_20 A_19 A_18 A_17 A_16 A_15 A_14 A_13 A_12 A_11 A_10 A_9 A_8 A_7 A_6 A_5 A_4 A_3 A_2 A_1 A_0 _1of4_1_3 _1of4_1_2 _1of4_1_1 _1of4_1_0 _1of4_2_3 _1of4_2_2 _1of4_2_1 _1of4_2_0 _1of4_3_3 _1of4_3_2 _1of4_3_1 _1of4_3_0 En AddrValid
    I3 (A_63 A_62 A_61 A_60 A_59 A_58 A_57 A_56 A_55 A_54 A_53 A_52 A_51 A_50 A_49 A_48 _1of4_1_3 _1of4_1_2 _1of4_1_1 _1of4_1_0 _1of4_2_3 _1of4_2_2 _1of4_2_1 _1of4_2_0 En _1of4_3_3) Demux_2e1of4
    I2 (A_47 A_46 A_45 A_44 A_43 A_42 A_41 A_40 A_39 A_38 A_37 A_36 A_35 A_34 A_33 A_32 _1of4_1_3 _1of4_1_2 _1of4_1_1 _1of4_1_0 _1of4_2_3 _1of4_2_2 _1of4_2_1 _1of4_2_0 En _1of4_3_2) Demux_2e1of4
    I1 (A_31 A_30 A_29 A_28 A_27 A_26 A_25 A_24 A_23 A_22 A_21 A_20 A_19 A_18 A_17 A_16 _1of4_1_3 _1of4_1_2 _1of4_1_1 _1of4_1_0 _1of4_2_3 _1of4_2_2 _1of4_2_1 _1of4_2_0 En _1of4_3_1) Demux_2e1of4
    I0 (A_15 A_14 A_13 A_12 A_11 A_10 A_9 A_8 A_7 A_6 A_5 A_4 A_3 A_2 A_1 A_0 _1of4_1_3 _1of4_1_2 _1of4_1_1 _1of4_1_0 _1of4_2_3 _1of4_2_2 _1of4_2_1 _1of4_2_0 En _1of4_3_0) Demux_2e1of4
    I8 (net22 A_63 A_62 A_61 A_60 A_59 A_58 A_57 A_56 A_55 A_54 A_53 A_52 A_51 A_50 A_49 A_48) or16_1x
    I7 (net23 A_47 A_46 A_45 A_44 A_43 A_42 A_41 A_40 A_39 A_38 A_37 A_36 A_35 A_34 A_33 A_32) or16_1x
    I6 (net24 A_31 A_30 A_29 A_28 A_27 A_26 A_25 A_24 A_23 A_22 A_21 A_20 A_19 A_18 A_17 A_16) or16_1x
    I17 (net25 A_15 A_14 A_13 A_12 A_11 A_10 A_9 A_8 A_7 A_6 A_5 A_4 A_3 A_2 A_1 A_0) or16_1x
    I11 (net25 net24 net23 net22 AddrValid) or4_1x
ends Demux_3e1of4

// 16nm/nor_1x/schematic
//system verilogNetlist schematic cmos.sch cmos_sch veriloga ahdl
subckt nor_1x A B Y
    M3 (Y B or_pd_ps vdd!) pfet w=200n l=20n nfin=1 m=1 degradation=no
    M2 (or_pd_ps A vdd! vdd!) pfet w=200n l=20n nfin=1 m=1 degradation=no
    M1 (Y B 0 0) nfet w=60n l=20n nfin=1 m=1 degradation=no
    M0 (Y A 0 0) nfet w=60n l=20n nfin=1 m=1 degradation=no
ends nor_1x

// 16nm/nor3_1x/schematic
//system verilogNetlist schematic cmos.sch cmos_sch veriloga ahdl
subckt nor3_1x A B C Y
    M5 (Y C net21 vdd!) pfet w=300n l=20n nfin=1 m=1 degradation=no
    M3 (net21 B net018 vdd!) pfet w=300n l=20n nfin=1 m=1 degradation=no
    M2 (net018 A vdd! vdd!) pfet w=300n l=20n nfin=1 m=1 degradation=no
    M6 (Y C 0 0) nfet w=60n l=20n nfin=1 m=1 degradation=no
    M1 (Y A 0 0) nfet w=60n l=20n nfin=1 m=1 degradation=no
    M0 (Y B 0 0) nfet w=60n l=20n nfin=1 m=1 degradation=no
ends nor3_1x

// 16nm/6T_DEMUX_/schematic
//system verilogNetlist schematic cmos.sch cmos_sch veriloga ahdl
subckt _sub7 A_63 A_62 A_61 A_60 A_59 A_58 A_57 A_56 A_55 A_54 A_53 A_52 A_51 A_50 A_49 A_48 A_47 A_46 A_45 A_44 A_43 A_42 A_41 A_40 A_39 A_38 A_37 A_36 A_35 A_34 A_33 A_32 A_31 A_30 A_29 A_28 A_27 A_26 A_25 A_24 A_23 A_22 A_21 A_20 A_19 A_18 A_17 A_16 A_15 A_14 A_13 A_12 A_11 A_10 A_9 A_8 A_7 A_6 A_5 A_4 A_3 A_2 A_1 A_0 S_7 S_6 S_5 S_4 S_3 S_2 S_1 S_0 _1of4_1_3 _1of4_1_2 _1of4_1_1 _1of4_1_0 _1of4_2_3 _1of4_2_2 _1of4_2_1 _1of4_2_0 _1of4_3_3 _1of4_3_2 _1of4_3_1 _1of4_3_0 _1of4_4_3 _1of4_4_2 _1of4_4_1 _1of4_4_0 En Ack
    I0 (A_63 A_62 A_61 A_60 A_59 A_58 A_57 A_56 A_55 A_54 A_53 A_52 A_51 A_50 A_49 A_48 A_47 A_46 A_45 A_44 A_43 A_42 A_41 A_40 A_39 A_38 A_37 A_36 A_35 A_34 A_33 A_32 A_31 A_30 A_29 A_28 A_27 A_26 A_25 A_24 A_23 A_22 A_21 A_20 A_19 A_18 A_17 A_16 A_15 A_14 A_13 A_12 A_11 A_10 A_9 A_8 A_7 A_6 A_5 A_4 A_3 A_2 A_1 A_0 _1of4_1_3 _1of4_1_2 _1of4_1_1 _1of4_1_0 _1of4_2_3 _1of4_2_2 _1of4_2_1 _1of4_2_0 _1of4_3_3 _1of4_3_2 _1of4_3_1 _1of4_3_0 En Ack) Demux_3e1of4
    I10_3 (_1of4_4_3 net020_0) inv_1x
    I10_2 (_1of4_4_2 net020_1) inv_1x
    I10_1 (_1of4_4_1 net020_2) inv_1x
    I10_0 (_1of4_4_0 net020_3) inv_1x
    I9 (En net015) inv_1x
    I6 (En net016) inv_1x
    I4 (_1of4_3_0 _1of4_3_1 net23) nor_1x
    I5 (_1of4_3_2 _1of4_3_3 net22) nor_1x
    I1_3 (net020_0 net23 net016 S_3) nor3_1x
    I1_2 (net020_1 net23 net016 S_2) nor3_1x
    I1_1 (net020_2 net23 net016 S_1) nor3_1x
    I1_0 (net020_3 net23 net016 S_0) nor3_1x
    I2_3 (net020_0 net22 net015 S_7) nor3_1x
    I2_2 (net020_1 net22 net015 S_6) nor3_1x
    I2_1 (net020_2 net22 net015 S_5) nor3_1x
    I2_0 (net020_3 net22 net015 S_4) nor3_1x
ends _sub7

// 16nm/nand_1x/schematic
//system verilogNetlist schematic cmos.sch cmos_sch veriloga ahdl
subckt nand_1x A B Y
    M1 (Y B vdd! vdd!) pfet w=100n l=20n nfin=1 m=1 degradation=no
    M0 (Y A vdd! vdd!) pfet w=100n l=20n nfin=1 m=1 degradation=no
    M3 (net22 B 0 0) nfet w=120n l=20n nfin=1 m=1 degradation=no
    M2 (Y A net22 0) nfet w=120n l=20n nfin=1 m=1 degradation=no
ends nand_1x

// 16nm/or_1x/schematic
//system verilogNetlist schematic cmos.sch cmos_sch veriloga ahdl
subckt or_1x A B Y
    I6 (A B AnorB) nor_1x
    I7 (AnorB Y) inv_1x
ends or_1x

// 16nm/inv_weak_1x/schematic
//system verilogNetlist schematic cmos.sch cmos_sch veriloga ahdl
subckt inv_weak_1x A Y
    M2 (net13 vdd! 0 0) nfet w=60n l=20n nfin=1 ls=105n m=1 degradation=no
    M0 (Y A net13 0) nfet w=60n l=20n nfin=1 ls=105n m=1 degradation=no
    M3 (net14 0 vdd! vdd!) pfet w=100n l=20n nfin=1 m=1 degradation=no
    M1 (Y A net14 vdd!) pfet w=100n l=20n nfin=1 m=1 degradation=no
ends inv_weak_1x

// 16nm/TH22/schematic
//system verilogNetlist schematic cmos.sch cmos_sch veriloga ahdl
subckt TH22 A B Y
    M5 (Y net5 0 0) nfet w=60n l=20n nfin=1 m=1 degradation=no
    M4 (net5 Y net9 0) nfet w=120n l=20n nfin=1 m=1 degradation=no
    M3 (net9 B 0 0) nfet w=120n l=20n nfin=1 m=1 degradation=no
    M2 (net9 A 0 0) nfet w=120n l=20n nfin=1 m=1 degradation=no
    M1 (net5 B net17 0) nfet w=120n l=20n nfin=1 m=1 degradation=no
    M0 (net17 A 0 0) nfet w=120n l=20n nfin=1 m=1 degradation=no
    M11 (Y net5 vdd! vdd!) pfet w=100n l=20n nfin=1 m=1 degradation=no
    M10 (net5 B net032 vdd!) pfet w=200n l=20n nfin=1 m=1 degradation=no
    M9 (net032 A vdd! vdd!) pfet w=200n l=20n nfin=1 m=1 degradation=no
    M8 (net037 B vdd! vdd!) pfet w=200n l=20n nfin=1 m=1 degradation=no
    M7 (net037 A vdd! vdd!) pfet w=200n l=20n nfin=1 m=1 degradation=no
    M6 (net5 Y net037 vdd!) pfet w=200n l=20n nfin=1 m=1 degradation=no
ends TH22

// 16nm/PCHBd/schematic
//system verilogNetlist schematic cmos.sch cmos_sch veriloga ahdl
subckt PCHBd R0i\+1 R1i\+1 Ai R0i R1i Ai\+1
    I32 (net019 R0i\+1) inv_1x
    I5 (net032 R1i\+1) inv_1x
    I35 (Ai net027) inv_1x
    M16 (net019 R0i net034 0) nfet w=60n l=20n nfin=1 m=1 degradation=no
    M3 (net032 R1i net033 0) nfet w=60n l=20n nfin=1 m=1 degradation=no
    M4 (net034 net022 0 0) nfet w=60n l=20n nfin=1 m=1 degradation=no
    M5 (net033 net022 0 0) nfet w=60n l=20n nfin=1 m=1 degradation=no
    M10 (net019 net022 vdd! vdd!) pfet w=200n l=20n nfin=1 m=1 degradation=no
    M1 (net032 net022 vdd! vdd!) pfet w=200n l=20n nfin=1 m=1 degradation=no
    I6 (net032 net019 net031) nand_1x
    I9 (R0i R1i net030) or_1x
    I2 (R0i\+1 net019) inv_weak_1x
    I33 (R1i\+1 net032) inv_weak_1x
    I12 (net031 net030 Ai) TH22
    I30 (net027 Ai\+1 net022) TH22
ends PCHBd

// 16nm/THaC/schematic
//system verilogNetlist schematic cmos.sch cmos_sch veriloga ahdl
subckt THaC A Y C\- B\+
    M8 (net11 A 0 A) nfet w=120n l=20n nfin=1 m=1 degradation=no
    M5 (net7 A net33 A) nfet w=120n l=20n nfin=1 m=1 degradation=no
    M6 (net7 Y net11 Y) nfet w=120n l=20n nfin=1 m=1 degradation=no
    M9 (net11 C\- 0 C\-) nfet w=120n l=20n nfin=1 m=1 degradation=no
    M7 (net33 \~B\+ 0 \~B\+) nfet w=120n l=20n nfin=1 m=1 degradation=no
    I2 (net7 Y) inv_1x
    I9 (B\+ \~B\+) inv_1x
    M4 (net7 Y net17 Y) pfet w=100n l=20n nfin=1 m=1 degradation=no
    M3 (net7 C\- net32 C\-) pfet w=100n l=20n nfin=1 m=1 degradation=no
    M0 (net32 A vdd! A) pfet w=100n l=20n nfin=1 m=1 degradation=no
    M2 (net17 \~B\+ vdd! \~B\+) pfet w=100n l=20n nfin=1 m=1 degradation=no
    M1 (net17 A vdd! A) pfet w=100n l=20n nfin=1 m=1 degradation=no
ends THaC

// 16nm/PCHB_Write/schematic
//system verilogNetlist schematic cmos.sch cmos_sch veriloga ahdl
subckt PCHB_Write B0 B1 outAck R0i R1i W0 W1
    I34 (outAck net027) inv_1x
    I5 (net029 B1) inv_1x
    I4 (net18 B0) inv_1x
    I12 (inValid outAck outValid inAck) THaC
    M5 (net026 oE 0 0) nfet w=60n l=20n nfin=1 m=1 degradation=no
    M4 (net22 oE 0 0) nfet w=60n l=20n nfin=1 m=1 degradation=no
    M3 (net029 R1i net026 0) nfet w=60n l=20n nfin=1 m=1 degradation=no
    M2 (net18 R0i net22 0) nfet w=60n l=20n nfin=1 m=1 degradation=no
    M1 (net029 oE vdd! vdd!) pfet w=200n l=20n nfin=1 m=1 degradation=no
    M0 (net18 oE vdd! vdd!) pfet w=200n l=20n nfin=1 m=1 degradation=no
    I6 (net029 net18 outValid) nand_1x
    I9 (R0i R1i inValid) or_1x
    I2 (B0 net18) inv_weak_1x
    I3 (B1 net029) inv_weak_1x
    I11 (net027 inAck oE) TH22
    I31 (W1 W0 inAck) nor_1x
ends PCHB_Write

// 16nm/and_1x/schematic
//system verilogNetlist schematic cmos.sch cmos_sch veriloga ahdl
subckt and_1x A B Y
    I7 (A B ntYbar) nand_1x
    I6 (ntYbar Y) inv_1x
ends and_1x

// 16nm/WCHB_Read/schematic
//system verilogNetlist schematic cmos.sch cmos_sch veriloga ahdl
subckt WCHB_Read Lack_1 Lack_0 L0_1 L0_0 L1_1 L1_0 Rack Out_3 Out_2 Out_1 Out_0
    I23 (n0_1 n1_1 Lack_1) nor_1x
    I12 (n0_0 n1_0 Lack_0) nor_1x
    I34 (net31 net27 net24 net20 outAck) and4_1x
    I29 (n0_0 n1_1 m_2) nand_1x
    I26 (n1_0 n1_1 m_3) nand_1x
    I25 (n1_0 n0_1 m_1) nand_1x
    I24 (n0_0 n0_1 m_0) nand_1x
    I28 (Rack m_2 net24) TH22
    I27 (Rack m_3 net20) TH22
    I0 (L0_0 outAck n0_0) TH22
    I7 (Rack m_0 net31) TH22
    I1 (L1_0 outAck n1_0) TH22
    I21 (L0_1 outAck n0_1) TH22
    I6 (Rack m_1 net27) TH22
    I22 (L1_1 outAck n1_1) TH22
    I42 (net20 Out_3) inv_1x
    I41 (net24 Out_2) inv_1x
    I39 (net31 Out_0) inv_1x
    I40 (net27 Out_1) inv_1x
ends WCHB_Read

// 16nm/TH44~/schematic
//system verilogNetlist schematic cmos.sch cmos_sch veriloga ahdl
subckt _sub8 A B C D Y
    M19 (net13 A 0 0) nfet w=80n l=16n nfin=1 m=1 degradation=no
    M18 (net13 B 0 0) nfet w=80n l=16n nfin=1 m=1 degradation=no
    M17 (net13 C 0 0) nfet w=80n l=16n nfin=1 m=1 degradation=no
    M16 (net13 D 0 0) nfet w=80n l=16n nfin=1 m=1 degradation=no
    M15 (net011 net19 0 0) nfet w=40n l=16n nfin=1 m=1 degradation=no
    M14 (net42 A 0 0) nfet w=160n l=16n nfin=1 m=1 degradation=no
    M13 (net43 B net42 0) nfet w=160n l=16n nfin=1 m=1 degradation=no
    M12 (net44 C net43 0) nfet w=160n l=16n nfin=1 m=1 degradation=no
    M11 (net19 D net44 0) nfet w=160n l=16n nfin=1 m=1 degradation=no
    M10 (net19 net011 net13 0) nfet w=80n l=16n nfin=1 m=1 degradation=no
    I6 (net011 Y) inv_1x
    M9 (net011 net19 vdd! vdd!) pfet w=80n l=16n nfin=1 m=1 degradation=no
    M8 (net19 net011 net15 vdd!) pfet w=160n l=16n nfin=1 m=1 degradation=no
    M7 (net15 D vdd! vdd!) pfet w=160n l=16n nfin=1 m=1 degradation=no
    M6 (net15 C vdd! vdd!) pfet w=160n l=16n nfin=1 m=1 degradation=no
    M5 (net15 B vdd! vdd!) pfet w=160n l=16n nfin=1 m=1 degradation=no
    M4 (net15 A vdd! vdd!) pfet w=160n l=16n nfin=1 m=1 degradation=no
    M3 (net19 D net45 vdd!) pfet w=320n l=16n nfin=1 m=1 degradation=no
    M2 (net45 C net46 vdd!) pfet w=320n l=16n nfin=1 m=1 degradation=no
    M1 (net46 B net47 vdd!) pfet w=320n l=16n nfin=1 m=1 degradation=no
    M0 (net47 A vdd! vdd!) pfet w=320n l=16n nfin=1 m=1 degradation=no
ends _sub8

// 16nm/WCHB_Write/schematic
//system verilogNetlist schematic cmos.sch cmos_sch veriloga ahdl
subckt WCHB_Write Lack In_3 In_2 In_1 In_0 Rack_1 Rack_0 Out1_1 Out1_0 Out0_1 Out0_0
    I26 (b1_1 Rack_1 net12) TH22
    I7 (b1_0 Rack_0 net14) TH22
    I24 (b0_1 Rack_1 net11) TH22
    I6 (b0_0 Rack_0 net13) TH22
    I3 (In_3 nxa n_3) TH22
    I2 (In_2 nxa n_2) TH22
    I1 (In_1 nxa n_1) TH22
    I0 (In_0 nxa n_0) TH22
    I30 (net12 Out1_1) inv_1x
    I29 (net13 Out0_0) inv_1x
    I31 (net11 Out0_1) inv_1x
    I28 (net14 Out1_0) inv_1x
    I12 (n_0 n_1 n_2 n_3 Lack) or4_1x
    I19 (n_3 n_1 b1_0) nor_1x
    I22 (n_2 n_3 b1_1) nor_1x
    I21 (n_0 n_1 b0_1) nor_1x
    I20 (n_0 n_2 b0_0) nor_1x
    I27 (net14 net13 net12 net11 nxa) and4_1x
ends WCHB_Write

// 16nm/6T_DATAb/schematic
//system verilogNetlist schematic cmos.sch cmos_sch veriloga ahdl
subckt _sub9 Ack B0_3 B0_2 B0_1 B0_0 B1_3 B1_2 B1_1 B1_0 Go W0_3 W0_2 W0_1 W0_0 W1_3 W1_2 W1_1 W1_0 RW_1 RW_0 Reset ValAddr Read_1of4_3 Read_1of4_2 Read_1of4_1 Read_1of4_0 Read_1of4_7 Read_1of4_6 Read_1of4_5 Read_1of4_4 W1_1of4_3 W1_1of4_2 W1_1of4_1 W1_1of4_0 W2_1of4_3 W2_1of4_2 W2_1of4_1 W2_1of4_0 \~R1_3 \~R1_2 \~R1_1 \~R1_0 \~R0_3 \~R0_2 \~R0_1 \~R0_0 AckThruTop AckThruBot WdataAck_1 WdataAck_0 RdataAck_1 RdataAck_0
    I5_3 (R0q_3 R1q_3 Lack_3 R0_3 R1_3 RpAck_3) PCHBd
    I5_2 (R0q_2 R1q_2 Lack_2 R0_2 R1_2 RpAck_2) PCHBd
    I5_1 (R0q_1 R1q_1 Lack_1 R0_1 R1_1 RpAck_1) PCHBd
    I5_0 (R0q_0 R1q_0 Lack_0 R0_0 R1_0 RpAck_0) PCHBd
    I8 (intRack intWack Ack) nand_1x
    I12_1 (B0_1 B1_1 wack_1 nB0_1 nB1_1 W0_1 W1_1) PCHB_Write
    I12_0 (B0_0 B1_0 wack_0 nB0_0 nB1_0 W0_0 W1_0) PCHB_Write
    I15_1 (B0_3 B1_3 wack_3 nB0_3 nB1_3 W0_3 W1_3) PCHB_Write
    I15_0 (B0_2 B1_2 wack_2 nB0_2 nB1_2 W0_2 W1_2) PCHB_Write
    I13_3 (Wen B0_3 W0_3) and_1x
    I13_2 (Wen B0_2 W0_2) and_1x
    I13_1 (Wen B0_1 W0_1) and_1x
    I13_0 (Wen B0_0 W0_0) and_1x
    I11_3 (Wen B1_3 W1_3) and_1x
    I11_2 (Wen B1_2 W1_2) and_1x
    I11_1 (Wen B1_1 W1_1) and_1x
    I11_0 (Wen B1_0 W1_0) and_1x
    M0_3 (\~R1_3 Go vdd! vdd!) pfet w=100n l=20n nfin=1 m=1 degradation=no
    M0_2 (\~R1_2 Go vdd! vdd!) pfet w=100n l=20n nfin=1 m=1 degradation=no
    M0_1 (\~R1_1 Go vdd! vdd!) pfet w=100n l=20n nfin=1 m=1 degradation=no
    M0_0 (\~R1_0 Go vdd! vdd!) pfet w=100n l=20n nfin=1 m=1 degradation=no
    M1_3 (\~R0_3 Go vdd! vdd!) pfet w=100n l=20n nfin=1 m=1 degradation=no
    M1_2 (\~R0_2 Go vdd! vdd!) pfet w=100n l=20n nfin=1 m=1 degradation=no
    M1_1 (\~R0_1 Go vdd! vdd!) pfet w=100n l=20n nfin=1 m=1 degradation=no
    M1_0 (\~R0_0 Go vdd! vdd!) pfet w=100n l=20n nfin=1 m=1 degradation=no
    I4_3 (\~R1_3 R1_3) inv_1x
    I4_2 (\~R1_2 R1_2) inv_1x
    I4_1 (\~R1_1 R1_1) inv_1x
    I4_0 (\~R1_0 R1_0) inv_1x
    I6_3 (\~R0_3 R0_3) inv_1x
    I6_2 (\~R0_2 R0_2) inv_1x
    I6_1 (\~R0_1 R0_1) inv_1x
    I6_0 (\~R0_0 R0_0) inv_1x
    I1 (AckThruBot AckThruTop) iprobe
    I9 (ValAddr RW_0 Wen) TH22
    I7 (ValAddr RW_1 Go) TH22
    I3_1 (RpAck_3 RpAck_2 R0q_3 R0q_2 R1q_3 R1q_2 RdataAck_1 Read_1of4_7 Read_1of4_6 Read_1of4_5 Read_1of4_4) WCHB_Read
    I3_0 (RpAck_1 RpAck_0 R0q_1 R0q_0 R1q_1 R1q_0 RdataAck_0 Read_1of4_3 Read_1of4_2 Read_1of4_1 Read_1of4_0) WCHB_Read
    I16 (wack_0 wack_2 wack_3 wack_1 intWack) _sub8
    I0 (Lack_3 Lack_2 Lack_1 Lack_0 intRack) _sub8
    I14 (WdataAck_1 W2_1of4_3 W2_1of4_2 W2_1of4_1 W2_1of4_0 wack_3 wack_2 nB1_3 nB1_2 nB0_3 nB0_2) WCHB_Write
    I10 (WdataAck_0 W1_1of4_3 W1_1of4_2 W1_1of4_1 W1_1of4_0 wack_1 wack_0 nB1_1 nB1_0 nB0_1 nB0_0) WCHB_Write
ends _sub9

// 16nm/inv_1xt/schematic
//system verilogNetlist schematic cmos.sch cmos_sch veriloga ahdl
subckt inv_1xt A Y
    M0 (Y A 0 0) nfet w=60n l=20n nfin=1 m=1 degradation=no
    M1 (Y A vcc! vcc!) pfet w=100n l=20n nfin=1 m=1 degradation=no
ends inv_1xt

// 16nm_Tests/6T_DataPathSimple_Test/schematic
// system verilogNetlist schematic cmos.sch cmos_sch veriloga ahdl
ICHUNK (\~R0_1_3 \~R0_1_2 \~R0_1_1 \~R0_1_0 \~R1_1_3 \~R1_1_2 \~R1_1_1 \~R1_1_0 Aline_63 Aline_62 Aline_61 Aline_60 Aline_59 Aline_58 Aline_57 Aline_56 Aline_55 Aline_54 Aline_53 Aline_52 Aline_51 Aline_50 Aline_49 Aline_48 Aline_47 Aline_46 Aline_45 Aline_44 Aline_43 Aline_42 Aline_41 Aline_40 Aline_39 Aline_38 Aline_37 Aline_36 Aline_35 Aline_34 Aline_33 Aline_32 Aline_31 Aline_30 Aline_29 Aline_28 Aline_27 Aline_26 Aline_25 Aline_24 Aline_23 Aline_22 Aline_21 Aline_20 Aline_19 Aline_18 Aline_17 Aline_16 Aline_15 Aline_14 Aline_13 Aline_12 Aline_11 Aline_10 Aline_9 Aline_8 Aline_7 Aline_6 Aline_5 Aline_4 Aline_3 Aline_2 Aline_1 Aline_0 B0_1_3 B0_1_2 B0_1_1 B0_1_0 B1_1_3 B1_1_2 B1_1_1 B1_1_0 S_7 S_6 S_5 S_4 S_3 S_2 S_1 S_0 W0_1_3 W0_1_2 W0_1_1 W0_1_0 W1_1_3 W1_1_2 W1_1_1 W1_1_0 G01) _sub6
IMUX (Aline_63 Aline_62 Aline_61 Aline_60 Aline_59 Aline_58 Aline_57 Aline_56 Aline_55 Aline_54 Aline_53 Aline_52 Aline_51 Aline_50 Aline_49 Aline_48 Aline_47 Aline_46 Aline_45 Aline_44 Aline_43 Aline_42 Aline_41 Aline_40 Aline_39 Aline_38 Aline_37 Aline_36 Aline_35 Aline_34 Aline_33 Aline_32 Aline_31 Aline_30 Aline_29 Aline_28 Aline_27 Aline_26 Aline_25 Aline_24 Aline_23 Aline_22 Aline_21 Aline_20 Aline_19 Aline_18 Aline_17 Aline_16 Aline_15 Aline_14 Aline_13 Aline_12 Aline_11 Aline_10 Aline_9 Aline_8 Aline_7 Aline_6 Aline_5 Aline_4 Aline_3 Aline_2 Aline_1 Aline_0 S_7 S_6 S_5 S_4 S_3 S_2 S_1 S_0 AT_3 AT_2 AT_1 AT_0 AT_7 AT_6 AT_5 AT_4 AT_11 AT_10 AT_9 AT_8 AT_15 AT_14 AT_13 AT_12 AT_16 ValAddr) _sub7
V0 (vcc! 0) vsource type=dc dc=vdd
V1 (vdd! 0) vsource type=dc dc=vdd
IDATA (DataAckT B0_1_3 B0_1_2 B0_1_1 B0_1_0 B1_1_3 B1_1_2 B1_1_1 B1_1_0 G01 W0_1_3 W0_1_2 W0_1_1 W0_1_0 W1_1_3 W1_1_2 W1_1_1 W1_1_0 RWT_1 RWT_0 net58 ValAddr RDataT_3 RDataT_2 RDataT_1 RDataT_0 RDataT_7 RDataT_6 RDataT_5 RDataT_4 WDataT_3 WDataT_2 WDataT_1 WDataT_0 WDataT_7 WDataT_6 WDataT_5 WDataT_4 \~R1_1_3 \~R1_1_2 \~R1_1_1 \~R1_1_0 \~R0_1_3 \~R0_1_2 \~R0_1_1 \~R0_1_0 net56 net57 WdataAckT_1 WdataAckT_0 RdataAckT_1 RdataAckT_0) _sub9
I5 (net011 net018) inv_1xt
I2_16 (net033_0 AT_16) inv_1xt
I2_15 (net033_1 AT_15) inv_1xt
I2_14 (net033_2 AT_14) inv_1xt
I2_13 (net033_3 AT_13) inv_1xt
I2_12 (net033_4 AT_12) inv_1xt
I2_11 (net033_5 AT_11) inv_1xt
I2_10 (net033_6 AT_10) inv_1xt
I2_9 (net033_7 AT_9) inv_1xt
I2_8 (net033_8 AT_8) inv_1xt
I2_7 (net033_9 AT_7) inv_1xt
I2_6 (net033_10 AT_6) inv_1xt
I2_5 (net033_11 AT_5) inv_1xt
I2_4 (net033_12 AT_4) inv_1xt
I2_3 (net033_13 AT_3) inv_1xt
I2_2 (net033_14 AT_2) inv_1xt
I2_1 (net033_15 AT_1) inv_1xt
I2_0 (net033_16 AT_0) inv_1xt
I0_1 (net032_0 RWT_1) inv_1xt
I0_0 (net032_1 RWT_0) inv_1xt
I9_7 (RDataT_7 net027_0) inv_1xt
I9_6 (RDataT_6 net027_1) inv_1xt
I9_5 (RDataT_5 net027_2) inv_1xt
I9_4 (RDataT_4 net027_3) inv_1xt
I9_3 (RDataT_3 net027_4) inv_1xt
I9_2 (RDataT_2 net027_5) inv_1xt
I9_1 (RDataT_1 net027_6) inv_1xt
I9_0 (RDataT_0 net027_7) inv_1xt
I11_1 (WdataAckT_1 net036_0) inv_1xt
I11_0 (WdataAckT_0 net036_1) inv_1xt
I7_1 (net41_0 RdataAckT_1) inv_1xt
I7_0 (net41_1 RdataAckT_0) inv_1xt
I13_7 (net44_0 WDataT_7) inv_1xt
I13_6 (net44_1 WDataT_6) inv_1xt
I13_5 (net44_2 WDataT_5) inv_1xt
I13_4 (net44_3 WDataT_4) inv_1xt
I13_3 (net44_4 WDataT_3) inv_1xt
I13_2 (net44_5 WDataT_2) inv_1xt
I13_1 (net44_6 WDataT_1) inv_1xt
I13_0 (net44_7 WDataT_0) inv_1xt
I62 (DataAckT net011) inv_1x
// BEGIN Hierarchical Interface Elements
_ie99960 (net033_16 0) d2a src="99960" val0=0.0 val1=vdd valx=vdd/2 rise=2p fall=2p
_ie99961 (net033_7 0) d2a src="99961" val0=0.0 val1=vdd valx=vdd/2 rise=2p fall=2p
_ie99962 (net033_1 0) d2a src="99962" val0=0.0 val1=vdd valx=vdd/2 rise=2p fall=2p
_ie99963 (net032_1 0) d2a src="99963" val0=0.0 val1=vdd valx=vdd/2 rise=2p fall=2p
_ie99964 (net018 0) a2d dest="99964" vl=0.3*vdd vh=0.7*vdd timex=20n
_ie99965 (net027_1 0) a2d dest="99965" vl=0.3*vdd vh=0.7*vdd timex=20n
_ie99966 (net027_0 0) a2d dest="99966" vl=0.3*vdd vh=0.7*vdd timex=20n
_ie99967 (net033_6 0) d2a src="99967" val0=0.0 val1=vdd valx=vdd/2 rise=2p fall=2p
_ie99968 (net033_5 0) d2a src="99968" val0=0.0 val1=vdd valx=vdd/2 rise=2p fall=2p
_ie99969 (net033_10 0) d2a src="99969" val0=0.0 val1=vdd valx=vdd/2 rise=2p fall=2p
_ie99970 (net032_0 0) d2a src="99970" val0=0.0 val1=vdd valx=vdd/2 rise=2p fall=2p
_ie99971 (net027_7 0) a2d dest="99971" vl=0.3*vdd vh=0.7*vdd timex=20n
_ie99972 (net033_9 0) d2a src="99972" val0=0.0 val1=vdd valx=vdd/2 rise=2p fall=2p
_ie99973 (net033_0 0) d2a src="99973" val0=0.0 val1=vdd valx=vdd/2 rise=2p fall=2p
_ie99974 (net44_0 0) d2a src="99974" val0=0.0 val1=vdd valx=vdd/2 rise=2p fall=2p
_ie99975 (net44_7 0) d2a src="99975" val0=0.0 val1=vdd valx=vdd/2 rise=2p fall=2p
_ie99976 (net033_4 0) d2a src="99976" val0=0.0 val1=vdd valx=vdd/2 rise=2p fall=2p
_ie99977 (net41_0 0) d2a src="99977" val0=0.0 val1=vdd valx=vdd/2 rise=2p fall=2p
_ie99978 (net027_3 0) a2d dest="99978" vl=0.3*vdd vh=0.7*vdd timex=20n
_ie99979 (net44_3 0) d2a src="99979" val0=0.0 val1=vdd valx=vdd/2 rise=2p fall=2p
_ie99980 (net033_12 0) d2a src="99980" val0=0.0 val1=vdd valx=vdd/2 rise=2p fall=2p
_ie99981 (net027_5 0) a2d dest="99981" vl=0.3*vdd vh=0.7*vdd timex=20n
_ie99982 (net033_15 0) d2a src="99982" val0=0.0 val1=vdd valx=vdd/2 rise=2p fall=2p
_ie99983 (net033_14 0) d2a src="99983" val0=0.0 val1=vdd valx=vdd/2 rise=2p fall=2p
_ie99984 (net033_8 0) d2a src="99984" val0=0.0 val1=vdd valx=vdd/2 rise=2p fall=2p
_ie99985 (net44_2 0) d2a src="99985" val0=0.0 val1=vdd valx=vdd/2 rise=2p fall=2p
_ie99986 (net033_11 0) d2a src="99986" val0=0.0 val1=vdd valx=vdd/2 rise=2p fall=2p
_ie99987 (net033_13 0) d2a src="99987" val0=0.0 val1=vdd valx=vdd/2 rise=2p fall=2p
_ie99988 (net033_2 0) d2a src="99988" val0=0.0 val1=vdd valx=vdd/2 rise=2p fall=2p
_ie99989 (net027_4 0) a2d dest="99989" vl=0.3*vdd vh=0.7*vdd timex=20n
_ie99990 (net027_2 0) a2d dest="99990" vl=0.3*vdd vh=0.7*vdd timex=20n
_ie99991 (net44_5 0) d2a src="99991" val0=0.0 val1=vdd valx=vdd/2 rise=2p fall=2p
_ie99992 (net44_4 0) d2a src="99992" val0=0.0 val1=vdd valx=vdd/2 rise=2p fall=2p
_ie99993 (net036_1 0) a2d dest="99993" vl=0.3*vdd vh=0.7*vdd timex=20n
_ie99994 (net036_0 0) a2d dest="99994" vl=0.3*vdd vh=0.7*vdd timex=20n
_ie99995 (net027_6 0) a2d dest="99995" vl=0.3*vdd vh=0.7*vdd timex=20n
_ie99996 (net44_6 0) d2a src="99996" val0=0.0 val1=vdd valx=vdd/2 rise=2p fall=2p
_ie99997 (net44_1 0) d2a src="99997" val0=0.0 val1=vdd valx=vdd/2 rise=2p fall=2p
_ie99998 (net033_3 0) d2a src="99998" val0=0.0 val1=vdd valx=vdd/2 rise=2p fall=2p
_ie99999 (net41_1 0) d2a src="99999" val0=0.0 val1=vdd valx=vdd/2 rise=2p fall=2p
// END Hierarchical Interface Elements
ic WdataAckT_1=0 WdataAckT_0=0 IDATA.I5_3.net022=vdd IDATA.I5_3.net027=vdd IDATA.I5_3.net031=0 IDATA.I5_3.net030=0 IDATA.I15_1.inValid=0 IDATA.I15_1.outValid=0 IDATA.I15_1.oE=vdd IDATA.I15_1.inAck=vdd IDATA.I15_1.net027=vdd IDATA.I14.nxa=vdd IDATA.I14.net14=vdd IDATA.I14.net13=vdd IDATA.I14.net12=vdd IDATA.I14.net11=vdd IDATA.I14.b0_1=vdd IDATA.I14.b1_1=vdd IDATA.I14.b1_0=vdd IDATA.I14.b0_0=vdd IDATA.I14.n_0=0 IDATA.I14.n_1=0 IDATA.I14.n_2=0 IDATA.I14.n_3=0 IDATA.I3_1.n0_0=0 IDATA.I3_1.n1_0=0 IDATA.I3_1.n0_1=0 IDATA.I3_1.n1_1=0 IDATA.I3_1.outAck=vdd IDATA.I3_1.net31=vdd IDATA.I3_1.net27=vdd IDATA.I3_1.net24=vdd IDATA.I3_1.net20=vdd IDATA.I3_1.m_0=vdd IDATA.I3_1.m_1=vdd IDATA.I3_1.m_2=vdd IDATA.I3_1.m_3=vdd IDATA.I12_1.oE=vdd IDATA.I12_1.inAck=vdd IDATA.I12_1.net027=vdd IDATA.I12_1.outValid=0 IDATA.I12_1.inValid=0 IDATA.I10.nxa=vdd IDATA.I10.net14=vdd IDATA.I10.net13=vdd IDATA.I10.net12=vdd IDATA.I10.net11=vdd IDATA.I10.b0_1=vdd IDATA.I10.b1_1=vdd IDATA.I10.b0_0=vdd IDATA.I10.b1_0=vdd IDATA.I10.n_0=0 IDATA.I10.n_1=0 IDATA.I10.n_2=0 IDATA.I10.n_3=0 DataAckT=0 IDATA.intWack=vdd IDATA.intRack=vdd IDATA.RdataAck_1=0 IDATA.RdataAck_0=0 IDATA.Lack_3=0 IDATA.Lack_2=0 IDATA.Lack_1=0 IDATA.Lack_0=0 IDATA.wack_3=0 IDATA.wack_2=0 IDATA.wack_1=0 IDATA.wack_0=0 IDATA.R0_3=0 IDATA.R0_2=0 IDATA.R0_1=0 IDATA.R0_0=0 IDATA.R1_3=0 IDATA.R1_2=0 IDATA.R1_1=0 IDATA.R1_0=0 IDATA.nB0_3=0 IDATA.nB0_2=0 IDATA.nB1_3=0 IDATA.nB1_2=0 IDATA.Wen=0 IDATA.nB0_1=0 IDATA.nB1_1=0 IDATA.nB0_0=0 IDATA.nB1_0=0 IDATA.R1q_3=0 IDATA.R0q_3=0 IDATA.R1q_2=0 IDATA.R0q_2=0 IDATA.RpAck_3=vdd IDATA.RpAck_2=vdd ICHUNK.I0.B0P1=vdd ICHUNK.I0.B1P1=vdd ICHUNK.I0.I0.I7.I3.Q0=vdd ICHUNK.I0.I0.I7.I3.Q1=0 RWT_1=0 RWT_0=0 AT_11=0 AT_10=0 AT_9=0 AT_8=0 AT_3=0 AT_2=0 AT_1=0 AT_0=0 AT_7=0 AT_6=0 AT_5=0 AT_4=0 AT_15=0 AT_14=0 AT_13=0 AT_12=0 AT_16=0 ValAddr=0 \~R1_1_3=vdd \~R1_1_2=vdd \~R1_1_1=vdd \~R1_1_0=vdd \~R0_1_3=vdd \~R0_1_2=vdd \~R0_1_1=vdd \~R0_1_0=vdd G01=0 W0_1_3=0 W0_1_2=0 W0_1_1=0 W0_1_0=0 W1_1_3=0 W1_1_2=0 W1_1_1=0 W1_1_0=0 B0_1_3=0 B0_1_2=0 B0_1_1=0 B0_1_0=0 B1_1_3=0 B1_1_2=0 B1_1_1=0 B1_1_0=0 S_7=0 S_6=0 S_5=0 S_4=0 S_3=0 S_2=0 S_1=0 S_0=0 Aline_63=0 Aline_62=0 Aline_61=0 Aline_60=0 Aline_59=0 Aline_58=0 Aline_57=0 Aline_56=0 Aline_55=0 Aline_54=0 Aline_53=0 Aline_52=0 Aline_51=0 Aline_50=0 Aline_49=0 Aline_48=0 Aline_47=0 Aline_46=0 Aline_45=0 Aline_44=0 Aline_43=0 Aline_42=0 Aline_41=0 Aline_40=0 Aline_39=0 Aline_38=0 Aline_37=0 Aline_36=0 Aline_35=0 Aline_34=0 Aline_33=0 Aline_32=0 Aline_31=0 Aline_30=0 Aline_29=0 Aline_28=0 Aline_27=0 Aline_26=0 Aline_25=0 Aline_24=0 Aline_23=0 Aline_22=0 Aline_21=0 Aline_20=0 Aline_19=0 Aline_18=0 Aline_17=0 Aline_16=0 Aline_15=0 Aline_14=0 Aline_13=0 Aline_12=0 Aline_11=0 Aline_10=0 Aline_9=0 Aline_8=0 Aline_7=0 Aline_6=0 Aline_5=0 Aline_4=0 Aline_3=0 Aline_2=0 Aline_1=0 Aline_0=0 RDataT_7=0 RDataT_6=0 RDataT_5=0 RDataT_4=0 RDataT_3=0 RDataT_2=0 RDataT_1=0 RDataT_0=0 WDataT_3=0 WDataT_2=0 WDataT_1=0 WDataT_0=0 WDataT_7=0 WDataT_6=0 WDataT_5=0 WDataT_4=0
simulatorOptions options temp=30.0
tran tran stop=50n errpreset=conservative
save vdd! V1:p V0:p
