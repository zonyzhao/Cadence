simulator( 'spectreVerilog )
design(	 "/net/kafka/nfs/rstdenis/Cadence/simulation/6T_DataPathSimple_Test/spectreVerilog/config/netlist/analog/netlist")
resultsDir( "/net/kafka/nfs/rstdenis/Cadence/simulation/6T_DataPathSimple_Test/spectreVerilog/config" )
modelFile(
    '("/software/cadence/ncsu-FreePDK15/hspice_16nm_hp.include" "")
)
analysis('tran ?stop "50n"  ?errpreset "conservative"  )
desVar(	  "vdd" .750	)
envOption(
	'mspSetupNetlistSimPrecisionUnit  "ps"
	'mspSetupNetlistSimTimeUnit  "ps"
	'mspSetupNetlistSwitchRC  t
	'analysisOrder  list("tran")
)
option(	'multithread  "on"
)
saveOption( ?simOutputFormat "psfxl" )
converge( 'ic "/WDataT<4>" "0" )
converge( 'ic "/WDataT<5>" "0" )
converge( 'ic "/WDataT<6>" "0" )
converge( 'ic "/WDataT<7>" "0" )
converge( 'ic "/WDataT<0>" "0" )
converge( 'ic "/WDataT<1>" "0" )
converge( 'ic "/WDataT<2>" "0" )
converge( 'ic "/WDataT<3>" "0" )
converge( 'ic "/RDataT<0>" "0" )
converge( 'ic "/RDataT<1>" "0" )
converge( 'ic "/RDataT<2>" "0" )
converge( 'ic "/RDataT<3>" "0" )
converge( 'ic "/RDataT<4>" "0" )
converge( 'ic "/RDataT<5>" "0" )
converge( 'ic "/RDataT<6>" "0" )
converge( 'ic "/RDataT<7>" "0" )
converge( 'ic "/DataAckT" "0" )
converge( 'ic "/Aline<0>" "0" )
converge( 'ic "/Aline<1>" "0" )
converge( 'ic "/Aline<2>" "0" )
converge( 'ic "/Aline<3>" "0" )
converge( 'ic "/Aline<4>" "0" )
converge( 'ic "/Aline<5>" "0" )
converge( 'ic "/Aline<6>" "0" )
converge( 'ic "/Aline<7>" "0" )
converge( 'ic "/Aline<8>" "0" )
converge( 'ic "/Aline<9>" "0" )
converge( 'ic "/Aline<10>" "0" )
converge( 'ic "/Aline<11>" "0" )
converge( 'ic "/Aline<12>" "0" )
converge( 'ic "/Aline<13>" "0" )
converge( 'ic "/Aline<14>" "0" )
converge( 'ic "/Aline<15>" "0" )
converge( 'ic "/Aline<16>" "0" )
converge( 'ic "/Aline<17>" "0" )
converge( 'ic "/Aline<18>" "0" )
converge( 'ic "/Aline<19>" "0" )
converge( 'ic "/Aline<20>" "0" )
converge( 'ic "/Aline<21>" "0" )
converge( 'ic "/Aline<22>" "0" )
converge( 'ic "/Aline<23>" "0" )
converge( 'ic "/Aline<24>" "0" )
converge( 'ic "/Aline<25>" "0" )
converge( 'ic "/Aline<26>" "0" )
converge( 'ic "/Aline<27>" "0" )
converge( 'ic "/Aline<28>" "0" )
converge( 'ic "/Aline<29>" "0" )
converge( 'ic "/Aline<30>" "0" )
converge( 'ic "/Aline<31>" "0" )
converge( 'ic "/Aline<32>" "0" )
converge( 'ic "/Aline<33>" "0" )
converge( 'ic "/Aline<34>" "0" )
converge( 'ic "/Aline<35>" "0" )
converge( 'ic "/Aline<36>" "0" )
converge( 'ic "/Aline<37>" "0" )
converge( 'ic "/Aline<38>" "0" )
converge( 'ic "/Aline<39>" "0" )
converge( 'ic "/Aline<40>" "0" )
converge( 'ic "/Aline<41>" "0" )
converge( 'ic "/Aline<42>" "0" )
converge( 'ic "/Aline<43>" "0" )
converge( 'ic "/Aline<44>" "0" )
converge( 'ic "/Aline<45>" "0" )
converge( 'ic "/Aline<46>" "0" )
converge( 'ic "/Aline<47>" "0" )
converge( 'ic "/Aline<48>" "0" )
converge( 'ic "/Aline<49>" "0" )
converge( 'ic "/Aline<50>" "0" )
converge( 'ic "/Aline<51>" "0" )
converge( 'ic "/Aline<52>" "0" )
converge( 'ic "/Aline<53>" "0" )
converge( 'ic "/Aline<54>" "0" )
converge( 'ic "/Aline<55>" "0" )
converge( 'ic "/Aline<56>" "0" )
converge( 'ic "/Aline<57>" "0" )
converge( 'ic "/Aline<58>" "0" )
converge( 'ic "/Aline<59>" "0" )
converge( 'ic "/Aline<60>" "0" )
converge( 'ic "/Aline<61>" "0" )
converge( 'ic "/Aline<62>" "0" )
converge( 'ic "/Aline<63>" "0" )
converge( 'ic "/S<0>" "0" )
converge( 'ic "/S<1>" "0" )
converge( 'ic "/S<2>" "0" )
converge( 'ic "/S<3>" "0" )
converge( 'ic "/S<4>" "0" )
converge( 'ic "/S<5>" "0" )
converge( 'ic "/S<6>" "0" )
converge( 'ic "/S<7>" "0" )
converge( 'ic "/B1_1<0>" "0" )
converge( 'ic "/B1_1<1>" "0" )
converge( 'ic "/B1_1<2>" "0" )
converge( 'ic "/B1_1<3>" "0" )
converge( 'ic "/B0_1<0>" "0" )
converge( 'ic "/B0_1<1>" "0" )
converge( 'ic "/B0_1<2>" "0" )
converge( 'ic "/B0_1<3>" "0" )
converge( 'ic "/W1_1<0>" "0" )
converge( 'ic "/W1_1<1>" "0" )
converge( 'ic "/W1_1<2>" "0" )
converge( 'ic "/W1_1<3>" "0" )
converge( 'ic "/W0_1<0>" "0" )
converge( 'ic "/W0_1<1>" "0" )
converge( 'ic "/W0_1<2>" "0" )
converge( 'ic "/W0_1<3>" "0" )
converge( 'ic "/G01" "0" )
converge( 'ic "/~R0_1<0>" "vdd" )
converge( 'ic "/~R0_1<1>" "vdd" )
converge( 'ic "/~R0_1<2>" "vdd" )
converge( 'ic "/~R0_1<3>" "vdd" )
converge( 'ic "/~R1_1<0>" "vdd" )
converge( 'ic "/~R1_1<1>" "vdd" )
converge( 'ic "/~R1_1<2>" "vdd" )
converge( 'ic "/~R1_1<3>" "vdd" )
converge( 'ic "/ValAddr" "0" )
converge( 'ic "/AT<16>" "0" )
converge( 'ic "/AT<12>" "0" )
converge( 'ic "/AT<13>" "0" )
converge( 'ic "/AT<14>" "0" )
converge( 'ic "/AT<15>" "0" )
converge( 'ic "/AT<4>" "0" )
converge( 'ic "/AT<5>" "0" )
converge( 'ic "/AT<6>" "0" )
converge( 'ic "/AT<7>" "0" )
converge( 'ic "/AT<0>" "0" )
converge( 'ic "/AT<1>" "0" )
converge( 'ic "/AT<2>" "0" )
converge( 'ic "/AT<3>" "0" )
converge( 'ic "/AT<8>" "0" )
converge( 'ic "/AT<9>" "0" )
converge( 'ic "/AT<10>" "0" )
converge( 'ic "/AT<11>" "0" )
converge( 'ic "/RWT<0>" "0" )
converge( 'ic "/RWT<1>" "0" )
converge( 'ic "/ICHUNK/I0/I0/I7/I3/Q1" "0" )
converge( 'ic "/ICHUNK/I0/I0/I7/I3/Q0" "vdd" )
converge( 'ic "/ICHUNK/I0/B1P1" "vdd" )
converge( 'ic "/ICHUNK/I0/B0P1" "vdd" )
converge( 'ic "/RdataAckT<1>" "vdd" )
converge( 'ic "/IDATA/I67<1>/outAck" "vdd" )
converge( 'ic "/IDATA/RpAck<2>" "vdd" )
converge( 'ic "/IDATA/RpAck<3>" "vdd" )
converge( 'ic "/IDATA/I67<1>/n1<1>" "0" )
converge( 'ic "/IDATA/I67<1>/n0<1>" "0" )
converge( 'ic "/IDATA/I67<1>/n1<0>" "0" )
converge( 'ic "/IDATA/I67<1>/n0<0>" "0" )
converge( 'ic "/IDATA/I67<1>/m<0>" "0" )
converge( 'ic "/IDATA/I67<1>/m<1>" "0" )
converge( 'ic "/IDATA/I67<1>/m<2>" "0" )
converge( 'ic "/IDATA/I67<1>/m<3>" "0" )
converge( 'ic "/IDATA/R0q<2>" "0" )
converge( 'ic "/IDATA/R1q<2>" "0" )
converge( 'ic "/IDATA/R0q<3>" "0" )
converge( 'ic "/IDATA/R1q<3>" "0" )
converge( 'ic "/IDATA/wack<0>" "vdd" )
converge( 'ic "/IDATA/wack<1>" "vdd" )
converge( 'ic "/IDATA/I84/nxa" "vdd" )
converge( 'ic "/IDATA/I84/n<3>" "vdd" )
converge( 'ic "/IDATA/I84/n<2>" "vdd" )
converge( 'ic "/IDATA/I84/n<1>" "vdd" )
converge( 'ic "/IDATA/I84/n<0>" "vdd" )
converge( 'ic "/IDATA/nB1<0>" "0" )
converge( 'ic "/IDATA/nB0<0>" "0" )
converge( 'ic "/IDATA/nB1<1>" "0" )
converge( 'ic "/IDATA/nB0<1>" "0" )
converge( 'ic "/WdataAckT<0>" "vdd" )
converge( 'ic "/IDATA/Wen" "0" )
converge( 'ic "/IDATA/intWack" "vdd" )
converge( 'ic "/IDATA/intRack" "vdd" )
run()
selectResult( 'tran )
plot(getData("/IDATA/Wen") getData("/WDataT<3>") getData("/WDataT<2>") getData("/WDataT<1>") getData("/WDataT<0>") getData("/WdataAckT<0>") getData("/RDataT<3>") getData("/RDataT<2>") getData("/RDataT<1>") getData("/RDataT<0>") getData("/RdataAckT<0>") getData("/IDATA/R0q<0>") getData("/IDATA/R1q<0>") getData("/IDATA/R0<0>") getData("/IDATA/R1<0>") getData("/IDATA/intRack") getData("/IDATA/intWack") getData("/IDATA/wack<0>") getData("/IDATA/nB0<0>") getData("/IDATA/nB1<0>") getData("/ICHUNK/I0/B0P1") getData("/ICHUNK/I0/B1P1") getData("/ICHUNK/I0/I0/I7/I3/Q0") getData("/ICHUNK/I0/I0/I7/I3/Q1") getData("/RWT<1>") getData("/RWT<0>") getData("/S<0>") getData("/Aline<0>") getData("/ValAddr") getData("/~R0_1<0>") getData("/~R1_1<0>") getData("/G01") getData("/W1_1<0>") getData("/W0_1<0>") getData("/B0_1<0>") getData("/B1_1<0>") getData("/WData<7:0>") getData("/WdataAck<1:0>") getData("/RData<7:0>") getData("/RdataAck<1:0>") getData("/A<16:0>") getData("/RW<1:0>") )
modelFile(
    '("/software/cadence/ncsu-FreePDK15/hspice_16nm_hp.include" "")
)
save( 'i "/IDATA/I86/Lack" )
converge( 'ic "/IDATA/I84/b1<0>" "0" )
converge( 'ic "/IDATA/I84/b0<0>" "0" )
converge( 'ic "/IDATA/I84/b1<1>" "0" )
converge( 'ic "/IDATA/I84/b0<1>" "0" )
converge( 'ic "/IDATA/nB1<2>" "0" )
converge( 'ic "/IDATA/nB1<3>" "0" )
converge( 'ic "/IDATA/nB0<2>" "0" )
converge( 'ic "/IDATA/nB0<3>" "0" )
converge( 'ic "/WdataAckT<1>" "vdd" )
converge( 'ic "/IDATA/wack<2>" "vdd" )
converge( 'ic "/IDATA/wack<3>" "vdd" )
converge( 'ic "/IDATA/Lack<0>" "vdd" )
converge( 'ic "/IDATA/Lack<1>" "vdd" )
converge( 'ic "/IDATA/Lack<2>" "vdd" )
converge( 'ic "/IDATA/Lack<3>" "vdd" )
converge( 'ic "/IDATA/R1<0>" "0" )
converge( 'ic "/IDATA/R1<1>" "0" )
converge( 'ic "/IDATA/R1<2>" "0" )
converge( 'ic "/IDATA/R1<3>" "0" )
converge( 'ic "/IDATA/R0<0>" "0" )
converge( 'ic "/IDATA/R0<1>" "0" )
converge( 'ic "/IDATA/R0<2>" "0" )
converge( 'ic "/IDATA/R0<3>" "0" )
converge( 'ic "/IDATA/I83<1>/inAck" "vdd" )
converge( 'ic "/IDATA/I83<1>/oE" "vdd" )
run()
selectResult( 'tran )
plot(getData("/WData<7:0>") getData("/WdataAck<1:0>") getData("/RData<7:0>") getData("/RdataAck<1:0>") getData("/A<16:0>") getData("/RW<1:0>") getData("/B1_1<0>") getData("/B0_1<0>") getData("/W0_1<0>") getData("/W1_1<0>") getData("/G01") getData("/~R1_1<0>") getData("/~R0_1<0>") getData("/ValAddr") getData("/Aline<0>") getData("/S<0>") getData("/RWT<1>") getData("/RWT<0>") getData("/ICHUNK/I0/I0/I7/I3/Q1") getData("/ICHUNK/I0/I0/I7/I3/Q0") getData("/ICHUNK/I0/B1P1") getData("/ICHUNK/I0/B0P1") getData("/IDATA/nB1<0>") getData("/IDATA/nB0<0>") getData("/IDATA/wack<0>") getData("/IDATA/intWack") getData("/IDATA/intRack") getData("/IDATA/R1<0>") getData("/IDATA/R0<0>") getData("/IDATA/R1q<0>") getData("/IDATA/R0q<0>") getData("/RdataAckT<0>") getData("/RDataT<3>") getData("/RDataT<2>") getData("/RDataT<1>") getData("/RDataT<0>") getData("/WdataAckT<0>") getData("/WDataT<3>") getData("/WDataT<2>") getData("/WDataT<1>") getData("/WDataT<0>") getData("/IDATA/Wen") getData("/IDATA/I84/n<0>") getData("/IDATA/I84/b1<0>") getData("/IDATA/I84/b0<0>") getData("/IDATA/I84/nxa") getData("/IDATA/I86/Lack") )
modelFile(
    '("/software/cadence/ncsu-FreePDK15/hspice_16nm_hp.include" "")
)
save( 'i "/V1/MINUS" "/V0/MINUS" )
run()
selectResult( 'tran )
plot(getData("/WData<7:0>") getData("/WdataAck<1:0>") getData("/RData<7:0>") getData("/RdataAck<1:0>") getData("/A<16:0>") getData("/RW<1:0>") getData("/B1_1<0>") getData("/B0_1<0>") getData("/W0_1<0>") getData("/W1_1<0>") getData("/G01") getData("/~R1_1<0>") getData("/~R0_1<0>") getData("/ValAddr") getData("/Aline<0>") getData("/S<0>") getData("/RWT<1>") getData("/RWT<0>") getData("/ICHUNK/I0/I0/I7/I3/Q1") getData("/ICHUNK/I0/I0/I7/I3/Q0") getData("/ICHUNK/I0/B1P1") getData("/ICHUNK/I0/B0P1") getData("/IDATA/nB1<0>") getData("/IDATA/nB0<0>") getData("/IDATA/wack<0>") getData("/IDATA/intWack") getData("/IDATA/intRack") getData("/IDATA/R1<0>") getData("/IDATA/R0<0>") getData("/IDATA/R1q<0>") getData("/IDATA/R0q<0>") getData("/RdataAckT<0>") getData("/RDataT<3>") getData("/RDataT<2>") getData("/RDataT<1>") getData("/RDataT<0>") getData("/WdataAckT<0>") getData("/WDataT<3>") getData("/WDataT<2>") getData("/WDataT<1>") getData("/WDataT<0>") getData("/IDATA/Wen") getData("/IDATA/I84/n<0>") getData("/IDATA/I84/b1<0>") getData("/IDATA/I84/b0<0>") getData("/IDATA/I84/nxa") getData("/IDATA/I86/Lack") getData("/V1/MINUS") getData("/vdd!") getData("/V0/MINUS") )
modelFile(
    '("/software/cadence/ncsu-FreePDK15/hspice_16nm_hp.include" "")
)
run()
selectResult( 'tran )
plot(getData("/WData<7:0>") getData("/WdataAck<1:0>") getData("/RData<7:0>") getData("/RdataAck<1:0>") getData("/A<16:0>") getData("/RW<1:0>") getData("/B1_1<0>") getData("/B0_1<0>") getData("/W0_1<0>") getData("/W1_1<0>") getData("/G01") getData("/~R1_1<0>") getData("/~R0_1<0>") getData("/ValAddr") getData("/Aline<0>") getData("/S<0>") getData("/RWT<1>") getData("/RWT<0>") getData("/ICHUNK/I0/I0/I7/I3/Q1") getData("/ICHUNK/I0/I0/I7/I3/Q0") getData("/ICHUNK/I0/B1P1") getData("/ICHUNK/I0/B0P1") getData("/IDATA/nB1<0>") getData("/IDATA/nB0<0>") getData("/IDATA/wack<0>") getData("/IDATA/intWack") getData("/IDATA/intRack") getData("/IDATA/R1<0>") getData("/IDATA/R0<0>") getData("/IDATA/R1q<0>") getData("/IDATA/R0q<0>") getData("/RdataAckT<0>") getData("/RDataT<3>") getData("/RDataT<2>") getData("/RDataT<1>") getData("/RDataT<0>") getData("/WdataAckT<0>") getData("/WDataT<3>") getData("/WDataT<2>") getData("/WDataT<1>") getData("/WDataT<0>") getData("/IDATA/Wen") getData("/IDATA/I84/n<0>") getData("/IDATA/I84/b1<0>") getData("/IDATA/I84/b0<0>") getData("/IDATA/I84/nxa") getData("/IDATA/I86/Lack") getData("/V1/MINUS") getData("/vdd!") getData("/V0/MINUS") getData("/Ack") getData("/DataAckT") )
modelFile(
    '("/software/cadence/ncsu-FreePDK15/hspice_16nm_hp.include" "")
)
run()
selectResult( 'tran )
plot(getData("/WData<7:0>") getData("/WdataAck<1:0>") getData("/RData<7:0>") getData("/RdataAck<1:0>") getData("/A<16:0>") getData("/RW<1:0>") getData("/B1_1<0>") getData("/B0_1<0>") getData("/W0_1<0>") getData("/W1_1<0>") getData("/G01") getData("/~R1_1<0>") getData("/~R0_1<0>") getData("/ValAddr") getData("/Aline<0>") getData("/S<0>") getData("/RWT<1>") getData("/RWT<0>") getData("/ICHUNK/I0/I0/I7/I3/Q1") getData("/ICHUNK/I0/I0/I7/I3/Q0") getData("/ICHUNK/I0/B1P1") getData("/ICHUNK/I0/B0P1") getData("/IDATA/nB1<0>") getData("/IDATA/nB0<0>") getData("/IDATA/wack<0>") getData("/IDATA/intWack") getData("/IDATA/intRack") getData("/IDATA/R1<0>") getData("/IDATA/R0<0>") getData("/IDATA/R1q<0>") getData("/IDATA/R0q<0>") getData("/RdataAckT<0>") getData("/RDataT<3>") getData("/RDataT<2>") getData("/RDataT<1>") getData("/RDataT<0>") getData("/WdataAckT<0>") getData("/WDataT<3>") getData("/WDataT<2>") getData("/WDataT<1>") getData("/WDataT<0>") getData("/IDATA/Wen") getData("/IDATA/I84/n<0>") getData("/IDATA/I84/b1<0>") getData("/IDATA/I84/b0<0>") getData("/IDATA/I84/nxa") getData("/IDATA/I86/Lack") getData("/V1/MINUS") getData("/vdd!") getData("/V0/MINUS") getData("/Ack") getData("/DataAckT") )
modelFile(
    '("/software/cadence/ncsu-FreePDK15/hspice_16nm_hp.include" "")
)
run()
selectResult( 'tran )
plot(getData("/WData<7:0>") getData("/WdataAck<1:0>") getData("/RData<7:0>") getData("/RdataAck<1:0>") getData("/A<16:0>") getData("/RW<1:0>") getData("/B1_1<0>") getData("/B0_1<0>") getData("/W0_1<0>") getData("/W1_1<0>") getData("/G01") getData("/~R1_1<0>") getData("/~R0_1<0>") getData("/ValAddr") getData("/Aline<0>") getData("/S<0>") getData("/RWT<1>") getData("/RWT<0>") getData("/ICHUNK/I0/I0/I7/I3/Q1") getData("/ICHUNK/I0/I0/I7/I3/Q0") getData("/ICHUNK/I0/B1P1") getData("/ICHUNK/I0/B0P1") getData("/IDATA/nB1<0>") getData("/IDATA/nB0<0>") getData("/IDATA/wack<0>") getData("/IDATA/intWack") getData("/IDATA/intRack") getData("/IDATA/R1<0>") getData("/IDATA/R0<0>") getData("/IDATA/R1q<0>") getData("/IDATA/R0q<0>") getData("/RdataAckT<0>") getData("/RDataT<3>") getData("/RDataT<2>") getData("/RDataT<1>") getData("/RDataT<0>") getData("/WdataAckT<0>") getData("/WDataT<3>") getData("/WDataT<2>") getData("/WDataT<1>") getData("/WDataT<0>") getData("/IDATA/Wen") getData("/IDATA/I84/n<0>") getData("/IDATA/I84/b1<0>") getData("/IDATA/I84/b0<0>") getData("/IDATA/I84/nxa") getData("/IDATA/I86/Lack") getData("/V1/MINUS") getData("/vdd!") getData("/V0/MINUS") getData("/Ack") getData("/DataAckT") )
modelFile(
    '("/software/cadence/ncsu-FreePDK15/hspice_16nm_hp.include" "")
)
run()
selectResult( 'tran )
plot(getData("/WData<7:0>") getData("/WdataAck<1:0>") getData("/RData<7:0>") getData("/RdataAck<1:0>") getData("/A<16:0>") getData("/RW<1:0>") getData("/B1_1<0>") getData("/B0_1<0>") getData("/W0_1<0>") getData("/W1_1<0>") getData("/G01") getData("/~R1_1<0>") getData("/~R0_1<0>") getData("/ValAddr") getData("/Aline<0>") getData("/S<0>") getData("/RWT<1>") getData("/RWT<0>") getData("/ICHUNK/I0/I0/I7/I3/Q1") getData("/ICHUNK/I0/I0/I7/I3/Q0") getData("/ICHUNK/I0/B1P1") getData("/ICHUNK/I0/B0P1") getData("/IDATA/nB1<0>") getData("/IDATA/nB0<0>") getData("/IDATA/wack<0>") getData("/IDATA/intWack") getData("/IDATA/intRack") getData("/IDATA/R1<0>") getData("/IDATA/R0<0>") getData("/IDATA/R1q<0>") getData("/IDATA/R0q<0>") getData("/RdataAckT<0>") getData("/RDataT<3>") getData("/RDataT<2>") getData("/RDataT<1>") getData("/RDataT<0>") getData("/WdataAckT<0>") getData("/WDataT<3>") getData("/WDataT<2>") getData("/WDataT<1>") getData("/WDataT<0>") getData("/IDATA/Wen") getData("/IDATA/I84/n<0>") getData("/IDATA/I84/b1<0>") getData("/IDATA/I84/b0<0>") getData("/IDATA/I84/nxa") getData("/IDATA/I86/Lack") getData("/V1/MINUS") getData("/vdd!") getData("/V0/MINUS") getData("/Ack") getData("/DataAckT") )
modelFile(
    '("/software/cadence/ncsu-FreePDK15/hspice_16nm_hp.include" "")
)
run()
selectResult( 'tran )
plot(getData("/WData<7:0>") getData("/WdataAck<1:0>") getData("/RData<7:0>") getData("/RdataAck<1:0>") getData("/A<16:0>") getData("/RW<1:0>") getData("/B1_1<0>") getData("/B0_1<0>") getData("/W0_1<0>") getData("/W1_1<0>") getData("/G01") getData("/~R1_1<0>") getData("/~R0_1<0>") getData("/ValAddr") getData("/Aline<0>") getData("/S<0>") getData("/RWT<1>") getData("/RWT<0>") getData("/ICHUNK/I0/I0/I7/I3/Q1") getData("/ICHUNK/I0/I0/I7/I3/Q0") getData("/ICHUNK/I0/B1P1") getData("/ICHUNK/I0/B0P1") getData("/IDATA/nB1<0>") getData("/IDATA/nB0<0>") getData("/IDATA/wack<0>") getData("/IDATA/intWack") getData("/IDATA/intRack") getData("/IDATA/R1<0>") getData("/IDATA/R0<0>") getData("/IDATA/R1q<0>") getData("/IDATA/R0q<0>") getData("/RdataAckT<0>") getData("/RDataT<3>") getData("/RDataT<2>") getData("/RDataT<1>") getData("/RDataT<0>") getData("/WdataAckT<0>") getData("/WDataT<3>") getData("/WDataT<2>") getData("/WDataT<1>") getData("/WDataT<0>") getData("/IDATA/Wen") getData("/IDATA/I84/n<0>") getData("/IDATA/I84/b1<0>") getData("/IDATA/I84/b0<0>") getData("/IDATA/I84/nxa") getData("/IDATA/I86/Lack") getData("/V1/MINUS") getData("/vdd!") getData("/V0/MINUS") getData("/Ack") getData("/DataAckT") )
modelFile(
    '("/software/cadence/ncsu-FreePDK15/hspice_16nm_hp.include" "")
)
run()
selectResult( 'tran )
plot(getData("/WData<7:0>") getData("/WdataAck<1:0>") getData("/RData<7:0>") getData("/RdataAck<1:0>") getData("/A<16:0>") getData("/RW<1:0>") getData("/B1_1<0>") getData("/B0_1<0>") getData("/W0_1<0>") getData("/W1_1<0>") getData("/G01") getData("/~R1_1<0>") getData("/~R0_1<0>") getData("/ValAddr") getData("/Aline<0>") getData("/S<0>") getData("/RWT<1>") getData("/RWT<0>") getData("/ICHUNK/I0/I0/I7/I3/Q1") getData("/ICHUNK/I0/I0/I7/I3/Q0") getData("/ICHUNK/I0/B1P1") getData("/ICHUNK/I0/B0P1") getData("/IDATA/nB1<0>") getData("/IDATA/nB0<0>") getData("/IDATA/wack<0>") getData("/IDATA/intWack") getData("/IDATA/intRack") getData("/IDATA/R1<0>") getData("/IDATA/R0<0>") getData("/IDATA/R1q<0>") getData("/IDATA/R0q<0>") getData("/RdataAckT<0>") getData("/RDataT<3>") getData("/RDataT<2>") getData("/RDataT<1>") getData("/RDataT<0>") getData("/WdataAckT<0>") getData("/WDataT<3>") getData("/WDataT<2>") getData("/WDataT<1>") getData("/WDataT<0>") getData("/IDATA/Wen") getData("/IDATA/I84/n<0>") getData("/IDATA/I84/b1<0>") getData("/IDATA/I84/b0<0>") getData("/IDATA/I84/nxa") getData("/IDATA/I86/Lack") getData("/V1/MINUS") getData("/vdd!") getData("/V0/MINUS") getData("/Ack") getData("/DataAckT") )
modelFile(
    '("/software/cadence/ncsu-FreePDK15/hspice_16nm_hp.include" "")
)
run()
selectResult( 'tran )
plot(getData("/WData<7:0>") getData("/WdataAck<1:0>") getData("/RData<7:0>") getData("/RdataAck<1:0>") getData("/A<16:0>") getData("/RW<1:0>") getData("/B1_1<0>") getData("/B0_1<0>") getData("/W0_1<0>") getData("/W1_1<0>") getData("/G01") getData("/~R1_1<0>") getData("/~R0_1<0>") getData("/ValAddr") getData("/Aline<0>") getData("/S<0>") getData("/RWT<1>") getData("/RWT<0>") getData("/ICHUNK/I0/I0/I7/I3/Q1") getData("/ICHUNK/I0/I0/I7/I3/Q0") getData("/ICHUNK/I0/B1P1") getData("/ICHUNK/I0/B0P1") getData("/IDATA/nB1<0>") getData("/IDATA/nB0<0>") getData("/IDATA/wack<0>") getData("/IDATA/intWack") getData("/IDATA/intRack") getData("/IDATA/R1<0>") getData("/IDATA/R0<0>") getData("/IDATA/R1q<0>") getData("/IDATA/R0q<0>") getData("/RdataAckT<0>") getData("/RDataT<3>") getData("/RDataT<2>") getData("/RDataT<1>") getData("/RDataT<0>") getData("/WdataAckT<0>") getData("/WDataT<3>") getData("/WDataT<2>") getData("/WDataT<1>") getData("/WDataT<0>") getData("/IDATA/Wen") getData("/IDATA/I84/n<0>") getData("/IDATA/I84/b1<0>") getData("/IDATA/I84/b0<0>") getData("/IDATA/I84/nxa") getData("/IDATA/I86/Lack") getData("/V1/MINUS") getData("/vdd!") getData("/V0/MINUS") getData("/Ack") getData("/DataAckT") )
modelFile(
    '("/software/cadence/ncsu-FreePDK15/hspice_16nm_hp.include" "")
)
desVar(	  "vdd" .500	)
run()
selectResult( 'tran )
plot(getData("/WData<7:0>") getData("/WdataAck<1:0>") getData("/RData<7:0>") getData("/RdataAck<1:0>") getData("/A<16:0>") getData("/RW<1:0>") getData("/B1_1<0>") getData("/B0_1<0>") getData("/W0_1<0>") getData("/W1_1<0>") getData("/G01") getData("/~R1_1<0>") getData("/~R0_1<0>") getData("/ValAddr") getData("/Aline<0>") getData("/S<0>") getData("/RWT<1>") getData("/RWT<0>") getData("/ICHUNK/I0/I0/I7/I3/Q1") getData("/ICHUNK/I0/I0/I7/I3/Q0") getData("/ICHUNK/I0/B1P1") getData("/ICHUNK/I0/B0P1") getData("/IDATA/nB1<0>") getData("/IDATA/nB0<0>") getData("/IDATA/wack<0>") getData("/IDATA/intWack") getData("/IDATA/intRack") getData("/IDATA/R1<0>") getData("/IDATA/R0<0>") getData("/IDATA/R1q<0>") getData("/IDATA/R0q<0>") getData("/RdataAckT<0>") getData("/RDataT<3>") getData("/RDataT<2>") getData("/RDataT<1>") getData("/RDataT<0>") getData("/WdataAckT<0>") getData("/WDataT<3>") getData("/WDataT<2>") getData("/WDataT<1>") getData("/WDataT<0>") getData("/IDATA/Wen") getData("/IDATA/I84/n<0>") getData("/IDATA/I84/b1<0>") getData("/IDATA/I84/b0<0>") getData("/IDATA/I84/nxa") getData("/IDATA/I86/Lack") getData("/V1/MINUS") getData("/vdd!") getData("/V0/MINUS") getData("/Ack") getData("/DataAckT") )
modelFile(
    '("/software/cadence/ncsu-FreePDK15/hspice_16nm_hp.include" "")
)
option(	'temp  "30.0"
)
temp( 30.0 )
run()
selectResult( 'tran )
plot(getData("/WData<7:0>") getData("/WdataAck<1:0>") getData("/RData<7:0>") getData("/RdataAck<1:0>") getData("/A<16:0>") getData("/RW<1:0>") getData("/B1_1<0>") getData("/B0_1<0>") getData("/W0_1<0>") getData("/W1_1<0>") getData("/G01") getData("/~R1_1<0>") getData("/~R0_1<0>") getData("/ValAddr") getData("/Aline<0>") getData("/S<0>") getData("/RWT<1>") getData("/RWT<0>") getData("/ICHUNK/I0/I0/I7/I3/Q1") getData("/ICHUNK/I0/I0/I7/I3/Q0") getData("/ICHUNK/I0/B1P1") getData("/ICHUNK/I0/B0P1") getData("/IDATA/nB1<0>") getData("/IDATA/nB0<0>") getData("/IDATA/wack<0>") getData("/IDATA/intWack") getData("/IDATA/intRack") getData("/IDATA/R1<0>") getData("/IDATA/R0<0>") getData("/IDATA/R1q<0>") getData("/IDATA/R0q<0>") getData("/RdataAckT<0>") getData("/RDataT<3>") getData("/RDataT<2>") getData("/RDataT<1>") getData("/RDataT<0>") getData("/WdataAckT<0>") getData("/WDataT<3>") getData("/WDataT<2>") getData("/WDataT<1>") getData("/WDataT<0>") getData("/IDATA/Wen") getData("/IDATA/I84/n<0>") getData("/IDATA/I84/b1<0>") getData("/IDATA/I84/b0<0>") getData("/IDATA/I84/nxa") getData("/IDATA/I86/Lack") getData("/V1/MINUS") getData("/vdd!") getData("/V0/MINUS") getData("/Ack") getData("/DataAckT") )
