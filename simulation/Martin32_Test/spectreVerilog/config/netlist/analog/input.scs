// Design: 16nm_Tests/Martin32_Test
simulator lang=spectre
global 0 vdd! vcc!
parameters vcc=0.5 vdd=0.5
include "/project/ncsu-FreePDK15/hspice_16nm_hp.include"

// 16nm/inv_1xt/schematic
//system verilogNetlist schematic cmos.sch cmos_sch veriloga ahdl
subckt inv_1xt A Y
    M0 (Y A 0 0) nfet w=60n l=20n nfin=1 m=1 degradation=no
    M1 (Y A vcc! vcc!) pfet w=100n l=20n nfin=1 m=1 degradation=no
ends inv_1xt

// 16nm/TH44/schematic
//system verilogNetlist schematic cmos.sch cmos_sch veriloga ahdl
subckt TH44 A B C D Y
    M19 (net13 A 0 0) nfet w=120n l=20n nfin=1 m=1 degradation=no
    M18 (net13 B 0 0) nfet w=120n l=20n nfin=1 m=1 degradation=no
    M17 (net13 C 0 0) nfet w=120n l=20n nfin=1 m=1 degradation=no
    M16 (net13 D 0 0) nfet w=120n l=20n nfin=1 m=1 degradation=no
    M15 (Y net19 0 0) nfet w=60n l=20n nfin=1 m=1 degradation=no
    M14 (net42 A 0 0) nfet w=240n l=20n nfin=1 m=1 degradation=no
    M13 (net43 B net42 0) nfet w=240n l=20n nfin=1 m=1 degradation=no
    M12 (net44 C net43 0) nfet w=240n l=20n nfin=1 m=1 degradation=no
    M11 (net19 D net44 0) nfet w=240n l=20n nfin=1 m=1 degradation=no
    M10 (net19 Y net13 0) nfet w=120n l=20n nfin=1 m=1 degradation=no
    M9 (Y net19 vdd! vdd!) pfet w=100n l=20n nfin=1 m=1 degradation=yes
    M8 (net19 Y net15 vdd!) pfet w=200n l=20n nfin=1 m=1 degradation=yes
    M7 (net15 D vdd! vdd!) pfet w=200n l=20n nfin=1 m=1 degradation=yes
    M6 (net15 C vdd! vdd!) pfet w=200n l=20n nfin=1 m=1 degradation=yes
    M5 (net15 B vdd! vdd!) pfet w=200n l=20n nfin=1 m=1 degradation=yes
    M4 (net15 A vdd! vdd!) pfet w=200n l=20n nfin=1 m=1 degradation=yes
    M3 (net19 D net45 vdd!) pfet w=320n l=20n nfin=1 m=1 degradation=yes
    M2 (net45 C net46 vdd!) pfet w=320n l=20n nfin=1 m=1 degradation=yes
    M1 (net46 B net47 vdd!) pfet w=320n l=20n nfin=1 m=1 degradation=yes
    M0 (net47 A vdd! vdd!) pfet w=320n l=20n nfin=1 m=1 degradation=yes
ends TH44

// 16nm/inv_1x/schematic
//system verilogNetlist schematic cmos.sch cmos_sch veriloga ahdl
subckt inv_1x A Y
    M0 (Y A 0 0) nfet w=60n l=20n nfin=1 m=1 degradation=no
    M1 (Y A vdd! vdd!) pfet w=100n l=20n nfin=1 m=1 degradation=no
ends inv_1x

// 16nm/Martin_Sum/schematic
//system verilogNetlist schematic cmos.sch cmos_sch veriloga ahdl
subckt Martin_Sum af at bf bt cf ct sf st
    M11 (net33 af 0 0) nfet w=112n l=16n nfin=1 m=1 degradation=no
    M10 (net20 bt net33 0) nfet w=112n l=16n nfin=1 m=1 degradation=no
    M9 (net16 cf net20 0) nfet w=112n l=16n nfin=1 m=1 degradation=no
    M8 (net34 at 0 0) nfet w=112n l=16n nfin=1 m=1 degradation=no
    M7 (net20 bf net34 0) nfet w=112n l=16n nfin=1 m=1 degradation=no
    M6 (net28 ct net20 0) nfet w=112n l=16n nfin=1 m=1 degradation=no
    M5 (net35 af 0 0) nfet w=112n l=16n nfin=1 m=1 degradation=no
    M4 (net13 bf net35 0) nfet w=112n l=16n nfin=1 m=1 degradation=no
    M3 (net28 cf net13 0) nfet w=112n l=16n nfin=1 m=1 degradation=no
    M2 (net36 at 0 0) nfet w=112n l=16n nfin=1 m=1 degradation=no
    M1 (net13 bt net36 0) nfet w=112n l=16n nfin=1 m=1 degradation=no
    M0 (net16 ct net13 0) nfet w=112n l=16n nfin=1 m=1 degradation=no
    M15 (net28 cf net32 vdd!) pfet w=112n l=16n nfin=1 m=1 degradation=yes
    M14 (net32 ct vdd! vdd!) pfet w=112n l=16n nfin=1 m=1 degradation=yes
    M13 (net31 ct vdd! vdd!) pfet w=112n l=16n nfin=1 m=1 degradation=yes
    M12 (net16 cf net31 vdd!) pfet w=112n l=16n nfin=1 m=1 degradation=yes
    I6 (net28 sf) inv_1x
    I5 (net16 st) inv_1x
ends Martin_Sum

// 16nm/Martin_Carry/schematic
//system verilogNetlist schematic cmos.sch cmos_sch veriloga ahdl
subckt Martin_Carry af at bf bt cf ct df dt
    I7 (dfBar df) inv_1x
    I0 (dtBar dt) inv_1x
    M13 (dfBar cf net5 0) nfet w=80n l=16n nfin=1 m=1 degradation=no
    M12 (net5 bf 0 0) nfet w=80n l=16n nfin=1 m=1 degradation=no
    M11 (net5 af 0 0) nfet w=80n l=16n nfin=1 m=1 degradation=no
    M10 (net21 bf 0 0) nfet w=80n l=16n nfin=1 m=1 degradation=no
    M4 (dtBar ct net11 0) nfet w=80n l=16n nfin=1 m=1 degradation=no
    M3 (net11 bt 0 0) nfet w=80n l=16n nfin=1 m=1 degradation=no
    M2 (net11 at 0 0) nfet w=80n l=16n nfin=1 m=1 degradation=no
    M1 (net43 bt 0 0) nfet w=80n l=20n nfin=1 m=1 degradation=no
    M0 (dtBar at net43 0) nfet w=80n l=16n nfin=1 m=1 degradation=no
    M9 (dfBar af net21 0) nfet w=80n l=16n nfin=1 m=1 degradation=no
    M17 (net19 at vdd! net3) pfet w=320n l=16n nfin=1 m=1 degradation=yes
    M16 (net18 af net19 net3) pfet w=320n l=16n nfin=1 m=1 degradation=yes
    M15 (net17 bt net18 net3) pfet w=320n l=16n nfin=1 m=1 degradation=yes
    M14 (dfBar bf net17 net3) pfet w=320n l=16n nfin=1 m=1 degradation=yes
    M8 (net41 at vdd! net9) pfet w=320n l=16n nfin=1 m=1 degradation=yes
    M7 (net40 af net41 net9) pfet w=320n l=16n nfin=1 m=1 degradation=yes
    M6 (net39 bt net40 net9) pfet w=320n l=16n nfin=1 m=1 degradation=yes
    M5 (dtBar bf net39 net9) pfet w=320n l=16n nfin=1 m=1 degradation=yes
ends Martin_Carry

// 16nm/nor_1x/schematic
//system verilogNetlist schematic cmos.sch cmos_sch veriloga ahdl
subckt nor_1x A B Y
    M3 (Y B or_pd_ps vdd!) pfet w=200n l=20n nfin=1 m=1 degradation=yes
    M2 (or_pd_ps A vdd! vdd!) pfet w=200n l=20n nfin=1 m=1 degradation=yes
    M1 (Y B 0 0) nfet w=60n l=20n nfin=1 m=1 degradation=no
    M0 (Y A 0 0) nfet w=60n l=20n nfin=1 m=1 degradation=no
ends nor_1x

// 16nm/or_1x/schematic
//system verilogNetlist schematic cmos.sch cmos_sch veriloga ahdl
subckt or_1x A B Y
    I6 (A B AnorB) nor_1x
    I7 (AnorB Y) inv_1x
ends or_1x

// 16nm/Martin_Add/schematic
//system verilogNetlist schematic cmos.sch cmos_sch veriloga ahdl
subckt Martin_Add af at bf bt cf ct df dt sf st Req
    I0 (af at bf bt cf ct sf st) Martin_Sum
    I1 (af at bf bt cf ct df dt) Martin_Carry
    I2 (dt df Req) or_1x
ends Martin_Add

// 16nm/Martin_Add4/schematic
//system verilogNetlist schematic cmos.sch cmos_sch veriloga ahdl
subckt Martin_Add4 Req af_3 af_2 af_1 af_0 at_3 at_2 at_1 at_0 bf_3 bf_2 bf_1 bf_0 bt_3 bt_2 bt_1 bt_0 cf ct df dt sf_3 sf_2 sf_1 sf_0 st_3 st_2 st_1 st_0
    I10 (Req0 Req1 Req2 Req3 Req) TH44
    I3 (af_3 at_3 bf_3 bt_3 df2 dt2 df dt sf_3 st_3 Req3) Martin_Add
    I2 (af_2 at_2 bf_2 bt_2 df1 dt1 df2 dt2 sf_2 st_2 Req2) Martin_Add
    I1 (af_1 at_1 bf_1 bt_1 df0 dt0 df1 dt1 sf_1 st_1 Req1) Martin_Add
    I0 (af_0 at_0 bf_0 bt_0 cf ct df0 dt0 sf_0 st_0 Req0) Martin_Add
ends Martin_Add4

// 16nm/TH22/schematic
//system verilogNetlist schematic cmos.sch cmos_sch veriloga ahdl
subckt TH22 A B Y
    M5 (Y net5 0 0) nfet w=60n l=20n nfin=1 m=1 degradation=no
    M4 (net5 Y net9 0) nfet w=120n l=20n nfin=1 m=1 degradation=no
    M3 (net9 B 0 0) nfet w=120n l=20n nfin=1 m=1 degradation=no
    M2 (net9 A 0 0) nfet w=120n l=20n nfin=1 m=1 degradation=no
    M1 (net5 B net17 0) nfet w=120n l=20n nfin=1 m=1 degradation=no
    M0 (net17 A 0 0) nfet w=120n l=20n nfin=1 m=1 degradation=no
    M11 (Y net5 vdd! vdd!) pfet w=100n l=20n nfin=1 m=1 degradation=yes
    M10 (net5 B net032 vdd!) pfet w=200n l=20n nfin=1 m=1 degradation=yes
    M9 (net032 A vdd! vdd!) pfet w=200n l=20n nfin=1 m=1 degradation=yes
    M8 (net037 B vdd! vdd!) pfet w=200n l=20n nfin=1 m=1 degradation=yes
    M7 (net037 A vdd! vdd!) pfet w=200n l=20n nfin=1 m=1 degradation=yes
    M6 (net5 Y net037 vdd!) pfet w=200n l=20n nfin=1 m=1 degradation=yes
ends TH22

// 16nm/nand_1x/schematic
//system verilogNetlist schematic cmos.sch cmos_sch veriloga ahdl
subckt nand_1x A B Y
    M1 (Y B vdd! vdd!) pfet w=100n l=20n nfin=1 m=1 degradation=no
    M0 (Y A vdd! vdd!) pfet w=100n l=20n nfin=1 m=1 degradation=no
    M3 (net22 B 0 0) nfet w=120n l=20n nfin=1 m=1 degradation=no
    M2 (Y A net22 0) nfet w=120n l=20n nfin=1 m=1 degradation=no
ends nand_1x

// 16nm/Martin_Add32/schematic
//system verilogNetlist schematic cmos.sch cmos_sch veriloga ahdl
subckt Martin_Add32 at_31 at_30 at_29 at_28 at_27 at_26 at_25 at_24 at_23 at_22 at_21 at_20 at_19 at_18 at_17 at_16 at_15 at_14 at_13 at_12 at_11 at_10 at_9 at_8 at_7 at_6 at_5 at_4 at_3 at_2 at_1 at_0 af_31 af_30 af_29 af_28 af_27 af_26 af_25 af_24 af_23 af_22 af_21 af_20 af_19 af_18 af_17 af_16 af_15 af_14 af_13 af_12 af_11 af_10 af_9 af_8 af_7 af_6 af_5 af_4 af_3 af_2 af_1 af_0 bt_31 bt_30 bt_29 bt_28 bt_27 bt_26 bt_25 bt_24 bt_23 bt_22 bt_21 bt_20 bt_19 bt_18 bt_17 bt_16 bt_15 bt_14 bt_13 bt_12 bt_11 bt_10 bt_9 bt_8 bt_7 bt_6 bt_5 bt_4 bt_3 bt_2 bt_1 bt_0 bf_31 bf_30 bf_29 bf_28 bf_27 bf_26 bf_25 bf_24 bf_23 bf_22 bf_21 bf_20 bf_19 bf_18 bf_17 bf_16 bf_15 bf_14 bf_13 bf_12 bf_11 bf_10 bf_9 bf_8 bf_7 bf_6 bf_5 bf_4 bf_3 bf_2 bf_1 bf_0 ct cf st_31 st_30 st_29 st_28 st_27 st_26 st_25 st_24 st_23 st_22 st_21 st_20 st_19 st_18 st_17 st_16 st_15 st_14 st_13 st_12 st_11 st_10 st_9 st_8 st_7 st_6 st_5 st_4 st_3 st_2 st_1 st_0 sf_31 sf_30 sf_29 sf_28 sf_27 sf_26 sf_25 sf_24 sf_23 sf_22 sf_21 sf_20 sf_19 sf_18 sf_17 sf_16 sf_15 sf_14 sf_13 sf_12 sf_11 sf_10 sf_9 sf_8 sf_7 sf_6 sf_5 sf_4 sf_3 sf_2 sf_1 sf_0 df dt Ack
    I5 (Req5 af_23 af_22 af_21 af_20 at_23 at_22 at_21 at_20 bf_23 bf_22 bf_21 bf_20 bt_23 bt_22 bt_21 bt_20 df19 dt19 df21 dt21 sf_23 sf_22 sf_21 sf_20 st_23 st_22 st_21 st_20) Martin_Add4
    I4 (Req4 af_19 af_18 af_17 af_16 at_19 at_18 at_17 at_16 bf_19 bf_18 bf_17 bf_16 bt_19 bt_18 bt_17 bt_16 df15 dt15 df19 dt19 sf_19 sf_18 sf_17 sf_16 st_19 st_18 st_17 st_16) Martin_Add4
    I3 (Req3 af_15 af_14 af_13 af_12 at_15 at_14 at_13 at_12 bf_15 bf_14 bf_13 bf_12 bt_15 bt_14 bt_13 bt_12 df11 dt11 df15 dt15 sf_15 sf_14 sf_13 sf_12 st_15 st_14 st_13 st_12) Martin_Add4
    I2 (Req2 af_11 af_10 af_9 af_8 at_11 at_10 at_9 at_8 bf_11 bf_10 bf_9 bf_8 bt_11 bt_10 bt_9 bt_8 df7 dt7 df11 dt11 sf_11 sf_10 sf_9 sf_8 st_11 st_10 st_9 st_8) Martin_Add4
    I1 (Req1 af_7 af_6 af_5 af_4 at_7 at_6 at_5 at_4 bf_7 bf_6 bf_5 bf_4 bt_7 bt_6 bt_5 bt_4 df3 dt3 df7 dt7 sf_7 sf_6 sf_5 sf_4 st_7 st_6 st_5 st_4) Martin_Add4
    I0 (Req0 af_3 af_2 af_1 af_0 at_3 at_2 at_1 at_0 bf_3 bf_2 bf_1 bf_0 bt_3 bt_2 bt_1 bt_0 cf ct df3 dt3 sf_3 sf_2 sf_1 sf_0 st_3 st_2 st_1 st_0) Martin_Add4
    I6 (Req6 af_27 af_26 af_25 af_24 at_27 at_26 at_25 at_24 bf_27 bf_26 bf_25 bf_24 bt_27 bt_26 bt_25 bt_24 df21 dt21 df23 dt23 sf_27 sf_26 sf_25 sf_24 st_27 st_26 st_25 st_24) Martin_Add4
    I7 (Req7 af_31 af_30 af_29 af_28 at_31 at_30 at_29 at_28 bf_31 bf_30 bf_29 bf_28 bt_31 bt_30 bt_29 bt_28 df23 dt23 df dt sf_31 sf_30 sf_29 sf_28 st_31 st_30 st_29 st_28) Martin_Add4
    I16 (ReqFin2 ReqFin1 Ack) TH22
    I17_3 (sf_3 st_3 net23_0) nand_1x
    I17_2 (sf_2 st_2 net23_1) nand_1x
    I17_1 (sf_1 st_1 net23_2) nand_1x
    I17_0 (sf_0 st_0 net23_3) nand_1x
    I15 (Req3 Req2 Req1 Req0 ReqFin2) TH44
    I14 (Req4 Req5 Req6 Req7 ReqFin1) TH44
ends Martin_Add32

// 16nm_Tests/Martin32_Test/schematic
// system verilogNetlist schematic cmos.sch cmos_sch veriloga ahdl
I17 (ReqT ReqBar) inv_1xt
I14 (dfT dfBar) inv_1xt
I13 (dtT dtBar) inv_1xt
I10 (cfBar cfT) inv_1xt
I9 (ctBar ctT) inv_1xt
I72_31 (stT_31 stBar_31) inv_1xt
I72_30 (stT_30 stBar_30) inv_1xt
I72_29 (stT_29 stBar_29) inv_1xt
I72_28 (stT_28 stBar_28) inv_1xt
I72_27 (stT_27 stBar_27) inv_1xt
I72_26 (stT_26 stBar_26) inv_1xt
I72_25 (stT_25 stBar_25) inv_1xt
I72_24 (stT_24 stBar_24) inv_1xt
I72_23 (stT_23 stBar_23) inv_1xt
I72_22 (stT_22 stBar_22) inv_1xt
I72_21 (stT_21 stBar_21) inv_1xt
I72_20 (stT_20 stBar_20) inv_1xt
I72_19 (stT_19 stBar_19) inv_1xt
I72_18 (stT_18 stBar_18) inv_1xt
I72_17 (stT_17 stBar_17) inv_1xt
I72_16 (stT_16 stBar_16) inv_1xt
I72_15 (stT_15 stBar_15) inv_1xt
I72_14 (stT_14 stBar_14) inv_1xt
I72_13 (stT_13 stBar_13) inv_1xt
I72_12 (stT_12 stBar_12) inv_1xt
I72_11 (stT_11 stBar_11) inv_1xt
I72_10 (stT_10 stBar_10) inv_1xt
I72_9 (stT_9 stBar_9) inv_1xt
I72_8 (stT_8 stBar_8) inv_1xt
I72_7 (stT_7 stBar_7) inv_1xt
I72_6 (stT_6 stBar_6) inv_1xt
I72_5 (stT_5 stBar_5) inv_1xt
I72_4 (stT_4 stBar_4) inv_1xt
I72_3 (stT_3 stBar_3) inv_1xt
I72_2 (stT_2 stBar_2) inv_1xt
I72_1 (stT_1 stBar_1) inv_1xt
I72_0 (stT_0 stBar_0) inv_1xt
I71_31 (sfT_31 sfBar_31) inv_1xt
I71_30 (sfT_30 sfBar_30) inv_1xt
I71_29 (sfT_29 sfBar_29) inv_1xt
I71_28 (sfT_28 sfBar_28) inv_1xt
I71_27 (sfT_27 sfBar_27) inv_1xt
I71_26 (sfT_26 sfBar_26) inv_1xt
I71_25 (sfT_25 sfBar_25) inv_1xt
I71_24 (sfT_24 sfBar_24) inv_1xt
I71_23 (sfT_23 sfBar_23) inv_1xt
I71_22 (sfT_22 sfBar_22) inv_1xt
I71_21 (sfT_21 sfBar_21) inv_1xt
I71_20 (sfT_20 sfBar_20) inv_1xt
I71_19 (sfT_19 sfBar_19) inv_1xt
I71_18 (sfT_18 sfBar_18) inv_1xt
I71_17 (sfT_17 sfBar_17) inv_1xt
I71_16 (sfT_16 sfBar_16) inv_1xt
I71_15 (sfT_15 sfBar_15) inv_1xt
I71_14 (sfT_14 sfBar_14) inv_1xt
I71_13 (sfT_13 sfBar_13) inv_1xt
I71_12 (sfT_12 sfBar_12) inv_1xt
I71_11 (sfT_11 sfBar_11) inv_1xt
I71_10 (sfT_10 sfBar_10) inv_1xt
I71_9 (sfT_9 sfBar_9) inv_1xt
I71_8 (sfT_8 sfBar_8) inv_1xt
I71_7 (sfT_7 sfBar_7) inv_1xt
I71_6 (sfT_6 sfBar_6) inv_1xt
I71_5 (sfT_5 sfBar_5) inv_1xt
I71_4 (sfT_4 sfBar_4) inv_1xt
I71_3 (sfT_3 sfBar_3) inv_1xt
I71_2 (sfT_2 sfBar_2) inv_1xt
I71_1 (sfT_1 sfBar_1) inv_1xt
I71_0 (sfT_0 sfBar_0) inv_1xt
I5_31 (afBar_31 afT_31) inv_1xt
I5_30 (afBar_30 afT_30) inv_1xt
I5_29 (afBar_29 afT_29) inv_1xt
I5_28 (afBar_28 afT_28) inv_1xt
I5_27 (afBar_27 afT_27) inv_1xt
I5_26 (afBar_26 afT_26) inv_1xt
I5_25 (afBar_25 afT_25) inv_1xt
I5_24 (afBar_24 afT_24) inv_1xt
I5_23 (afBar_23 afT_23) inv_1xt
I5_22 (afBar_22 afT_22) inv_1xt
I5_21 (afBar_21 afT_21) inv_1xt
I5_20 (afBar_20 afT_20) inv_1xt
I5_19 (afBar_19 afT_19) inv_1xt
I5_18 (afBar_18 afT_18) inv_1xt
I5_17 (afBar_17 afT_17) inv_1xt
I5_16 (afBar_16 afT_16) inv_1xt
I5_15 (afBar_15 afT_15) inv_1xt
I5_14 (afBar_14 afT_14) inv_1xt
I5_13 (afBar_13 afT_13) inv_1xt
I5_12 (afBar_12 afT_12) inv_1xt
I5_11 (afBar_11 afT_11) inv_1xt
I5_10 (afBar_10 afT_10) inv_1xt
I5_9 (afBar_9 afT_9) inv_1xt
I5_8 (afBar_8 afT_8) inv_1xt
I5_7 (afBar_7 afT_7) inv_1xt
I5_6 (afBar_6 afT_6) inv_1xt
I5_5 (afBar_5 afT_5) inv_1xt
I5_4 (afBar_4 afT_4) inv_1xt
I5_3 (afBar_3 afT_3) inv_1xt
I5_2 (afBar_2 afT_2) inv_1xt
I5_1 (afBar_1 afT_1) inv_1xt
I5_0 (afBar_0 afT_0) inv_1xt
I8_31 (btBar_31 btT_31) inv_1xt
I8_30 (btBar_30 btT_30) inv_1xt
I8_29 (btBar_29 btT_29) inv_1xt
I8_28 (btBar_28 btT_28) inv_1xt
I8_27 (btBar_27 btT_27) inv_1xt
I8_26 (btBar_26 btT_26) inv_1xt
I8_25 (btBar_25 btT_25) inv_1xt
I8_24 (btBar_24 btT_24) inv_1xt
I8_23 (btBar_23 btT_23) inv_1xt
I8_22 (btBar_22 btT_22) inv_1xt
I8_21 (btBar_21 btT_21) inv_1xt
I8_20 (btBar_20 btT_20) inv_1xt
I8_19 (btBar_19 btT_19) inv_1xt
I8_18 (btBar_18 btT_18) inv_1xt
I8_17 (btBar_17 btT_17) inv_1xt
I8_16 (btBar_16 btT_16) inv_1xt
I8_15 (btBar_15 btT_15) inv_1xt
I8_14 (btBar_14 btT_14) inv_1xt
I8_13 (btBar_13 btT_13) inv_1xt
I8_12 (btBar_12 btT_12) inv_1xt
I8_11 (btBar_11 btT_11) inv_1xt
I8_10 (btBar_10 btT_10) inv_1xt
I8_9 (btBar_9 btT_9) inv_1xt
I8_8 (btBar_8 btT_8) inv_1xt
I8_7 (btBar_7 btT_7) inv_1xt
I8_6 (btBar_6 btT_6) inv_1xt
I8_5 (btBar_5 btT_5) inv_1xt
I8_4 (btBar_4 btT_4) inv_1xt
I8_3 (btBar_3 btT_3) inv_1xt
I8_2 (btBar_2 btT_2) inv_1xt
I8_1 (btBar_1 btT_1) inv_1xt
I8_0 (btBar_0 btT_0) inv_1xt
I7_31 (bfBar_31 bfT_31) inv_1xt
I7_30 (bfBar_30 bfT_30) inv_1xt
I7_29 (bfBar_29 bfT_29) inv_1xt
I7_28 (bfBar_28 bfT_28) inv_1xt
I7_27 (bfBar_27 bfT_27) inv_1xt
I7_26 (bfBar_26 bfT_26) inv_1xt
I7_25 (bfBar_25 bfT_25) inv_1xt
I7_24 (bfBar_24 bfT_24) inv_1xt
I7_23 (bfBar_23 bfT_23) inv_1xt
I7_22 (bfBar_22 bfT_22) inv_1xt
I7_21 (bfBar_21 bfT_21) inv_1xt
I7_20 (bfBar_20 bfT_20) inv_1xt
I7_19 (bfBar_19 bfT_19) inv_1xt
I7_18 (bfBar_18 bfT_18) inv_1xt
I7_17 (bfBar_17 bfT_17) inv_1xt
I7_16 (bfBar_16 bfT_16) inv_1xt
I7_15 (bfBar_15 bfT_15) inv_1xt
I7_14 (bfBar_14 bfT_14) inv_1xt
I7_13 (bfBar_13 bfT_13) inv_1xt
I7_12 (bfBar_12 bfT_12) inv_1xt
I7_11 (bfBar_11 bfT_11) inv_1xt
I7_10 (bfBar_10 bfT_10) inv_1xt
I7_9 (bfBar_9 bfT_9) inv_1xt
I7_8 (bfBar_8 bfT_8) inv_1xt
I7_7 (bfBar_7 bfT_7) inv_1xt
I7_6 (bfBar_6 bfT_6) inv_1xt
I7_5 (bfBar_5 bfT_5) inv_1xt
I7_4 (bfBar_4 bfT_4) inv_1xt
I7_3 (bfBar_3 bfT_3) inv_1xt
I7_2 (bfBar_2 bfT_2) inv_1xt
I7_1 (bfBar_1 bfT_1) inv_1xt
I7_0 (bfBar_0 bfT_0) inv_1xt
I6_31 (atBar_31 atT_31) inv_1xt
I6_30 (atBar_30 atT_30) inv_1xt
I6_29 (atBar_29 atT_29) inv_1xt
I6_28 (atBar_28 atT_28) inv_1xt
I6_27 (atBar_27 atT_27) inv_1xt
I6_26 (atBar_26 atT_26) inv_1xt
I6_25 (atBar_25 atT_25) inv_1xt
I6_24 (atBar_24 atT_24) inv_1xt
I6_23 (atBar_23 atT_23) inv_1xt
I6_22 (atBar_22 atT_22) inv_1xt
I6_21 (atBar_21 atT_21) inv_1xt
I6_20 (atBar_20 atT_20) inv_1xt
I6_19 (atBar_19 atT_19) inv_1xt
I6_18 (atBar_18 atT_18) inv_1xt
I6_17 (atBar_17 atT_17) inv_1xt
I6_16 (atBar_16 atT_16) inv_1xt
I6_15 (atBar_15 atT_15) inv_1xt
I6_14 (atBar_14 atT_14) inv_1xt
I6_13 (atBar_13 atT_13) inv_1xt
I6_12 (atBar_12 atT_12) inv_1xt
I6_11 (atBar_11 atT_11) inv_1xt
I6_10 (atBar_10 atT_10) inv_1xt
I6_9 (atBar_9 atT_9) inv_1xt
I6_8 (atBar_8 atT_8) inv_1xt
I6_7 (atBar_7 atT_7) inv_1xt
I6_6 (atBar_6 atT_6) inv_1xt
I6_5 (atBar_5 atT_5) inv_1xt
I6_4 (atBar_4 atT_4) inv_1xt
I6_3 (atBar_3 atT_3) inv_1xt
I6_2 (atBar_2 atT_2) inv_1xt
I6_1 (atBar_1 atT_1) inv_1xt
I6_0 (atBar_0 atT_0) inv_1xt
V1 (vdd! 0) vsource type=dc dc=vdd
V0 (vcc! 0) vsource type=dc dc=vcc
I0 (atT_31 atT_30 atT_29 atT_28 atT_27 atT_26 atT_25 atT_24 atT_23 atT_22 atT_21 atT_20 atT_19 atT_18 atT_17 atT_16 atT_15 atT_14 atT_13 atT_12 atT_11 atT_10 atT_9 atT_8 atT_7 atT_6 atT_5 atT_4 atT_3 atT_2 atT_1 atT_0 afT_31 afT_30 afT_29 afT_28 afT_27 afT_26 afT_25 afT_24 afT_23 afT_22 afT_21 afT_20 afT_19 afT_18 afT_17 afT_16 afT_15 afT_14 afT_13 afT_12 afT_11 afT_10 afT_9 afT_8 afT_7 afT_6 afT_5 afT_4 afT_3 afT_2 afT_1 afT_0 btT_31 btT_30 btT_29 btT_28 btT_27 btT_26 btT_25 btT_24 btT_23 btT_22 btT_21 btT_20 btT_19 btT_18 btT_17 btT_16 btT_15 btT_14 btT_13 btT_12 btT_11 btT_10 btT_9 btT_8 btT_7 btT_6 btT_5 btT_4 btT_3 btT_2 btT_1 btT_0 bfT_31 bfT_30 bfT_29 bfT_28 bfT_27 bfT_26 bfT_25 bfT_24 bfT_23 bfT_22 bfT_21 bfT_20 bfT_19 bfT_18 bfT_17 bfT_16 bfT_15 bfT_14 bfT_13 bfT_12 bfT_11 bfT_10 bfT_9 bfT_8 bfT_7 bfT_6 bfT_5 bfT_4 bfT_3 bfT_2 bfT_1 bfT_0 ctT cfT stT_31 stT_30 stT_29 stT_28 stT_27 stT_26 stT_25 stT_24 stT_23 stT_22 stT_21 stT_20 stT_19 stT_18 stT_17 stT_16 stT_15 stT_14 stT_13 stT_12 stT_11 stT_10 stT_9 stT_8 stT_7 stT_6 stT_5 stT_4 stT_3 stT_2 stT_1 stT_0 sfT_31 sfT_30 sfT_29 sfT_28 sfT_27 sfT_26 sfT_25 sfT_24 sfT_23 sfT_22 sfT_21 sfT_20 sfT_19 sfT_18 sfT_17 sfT_16 sfT_15 sfT_14 sfT_13 sfT_12 sfT_11 sfT_10 sfT_9 sfT_8 sfT_7 sfT_6 sfT_5 sfT_4 sfT_3 sfT_2 sfT_1 sfT_0 dfT dtT ReqT) Martin_Add32
// BEGIN Hierarchical Interface Elements
_ie99803 (stBar_17 0) a2d dest="99803" vl=0.3*vdd vh=0.7*vdd timex=20n
_ie99804 (afBar_0 0) d2a src="99804" val0=0.0 val1=vdd valx=vdd/2 rise=2p fall=2p
_ie99805 (bfBar_0 0) d2a src="99805" val0=0.0 val1=vdd valx=vdd/2 rise=2p fall=2p
_ie99806 (btBar_0 0) d2a src="99806" val0=0.0 val1=vdd valx=vdd/2 rise=2p fall=2p
_ie99807 (afBar_1 0) d2a src="99807" val0=0.0 val1=vdd valx=vdd/2 rise=2p fall=2p
_ie99808 (atBar_23 0) d2a src="99808" val0=0.0 val1=vdd valx=vdd/2 rise=2p fall=2p
_ie99809 (btBar_1 0) d2a src="99809" val0=0.0 val1=vdd valx=vdd/2 rise=2p fall=2p
_ie99810 (atBar_0 0) d2a src="99810" val0=0.0 val1=vdd valx=vdd/2 rise=2p fall=2p
_ie99811 (afBar_2 0) d2a src="99811" val0=0.0 val1=vdd valx=vdd/2 rise=2p fall=2p
_ie99812 (btBar_12 0) d2a src="99812" val0=0.0 val1=vdd valx=vdd/2 rise=2p fall=2p
_ie99813 (btBar_17 0) d2a src="99813" val0=0.0 val1=vdd valx=vdd/2 rise=2p fall=2p
_ie99814 (atBar_2 0) d2a src="99814" val0=0.0 val1=vdd valx=vdd/2 rise=2p fall=2p
_ie99815 (atBar_3 0) d2a src="99815" val0=0.0 val1=vdd valx=vdd/2 rise=2p fall=2p
_ie99816 (afBar_25 0) d2a src="99816" val0=0.0 val1=vdd valx=vdd/2 rise=2p fall=2p
_ie99817 (afBar_3 0) d2a src="99817" val0=0.0 val1=vdd valx=vdd/2 rise=2p fall=2p
_ie99818 (afBar_4 0) d2a src="99818" val0=0.0 val1=vdd valx=vdd/2 rise=2p fall=2p
_ie99819 (btBar_18 0) d2a src="99819" val0=0.0 val1=vdd valx=vdd/2 rise=2p fall=2p
_ie99820 (stBar_25 0) a2d dest="99820" vl=0.3*vdd vh=0.7*vdd timex=20n
_ie99821 (bfBar_12 0) d2a src="99821" val0=0.0 val1=vdd valx=vdd/2 rise=2p fall=2p
_ie99822 (btBar_22 0) d2a src="99822" val0=0.0 val1=vdd valx=vdd/2 rise=2p fall=2p
_ie99823 (afBar_19 0) d2a src="99823" val0=0.0 val1=vdd valx=vdd/2 rise=2p fall=2p
_ie99824 (btBar_19 0) d2a src="99824" val0=0.0 val1=vdd valx=vdd/2 rise=2p fall=2p
_ie99825 (afBar_5 0) d2a src="99825" val0=0.0 val1=vdd valx=vdd/2 rise=2p fall=2p
_ie99826 (bfBar_13 0) d2a src="99826" val0=0.0 val1=vdd valx=vdd/2 rise=2p fall=2p
_ie99827 (btBar_2 0) d2a src="99827" val0=0.0 val1=vdd valx=vdd/2 rise=2p fall=2p
_ie99828 (btBar_20 0) d2a src="99828" val0=0.0 val1=vdd valx=vdd/2 rise=2p fall=2p
_ie99829 (ctBar 0) d2a src="99829" val0=0.0 val1=vdd valx=vdd/2 rise=2p fall=2p
_ie99830 (afBar_9 0) d2a src="99830" val0=0.0 val1=vdd valx=vdd/2 rise=2p fall=2p
_ie99831 (bfBar_1 0) d2a src="99831" val0=0.0 val1=vdd valx=vdd/2 rise=2p fall=2p
_ie99832 (atBar_8 0) d2a src="99832" val0=0.0 val1=vdd valx=vdd/2 rise=2p fall=2p
_ie99833 (atBar_9 0) d2a src="99833" val0=0.0 val1=vdd valx=vdd/2 rise=2p fall=2p
_ie99834 (bfBar_2 0) d2a src="99834" val0=0.0 val1=vdd valx=vdd/2 rise=2p fall=2p
_ie99835 (bfBar_3 0) d2a src="99835" val0=0.0 val1=vdd valx=vdd/2 rise=2p fall=2p
_ie99836 (btBar_21 0) d2a src="99836" val0=0.0 val1=vdd valx=vdd/2 rise=2p fall=2p
_ie99837 (btBar_13 0) d2a src="99837" val0=0.0 val1=vdd valx=vdd/2 rise=2p fall=2p
_ie99838 (afBar_21 0) d2a src="99838" val0=0.0 val1=vdd valx=vdd/2 rise=2p fall=2p
_ie99839 (sfBar_13 0) a2d dest="99839" vl=0.3*vdd vh=0.7*vdd timex=20n
_ie99840 (sfBar_18 0) a2d dest="99840" vl=0.3*vdd vh=0.7*vdd timex=20n
_ie99841 (atBar_24 0) d2a src="99841" val0=0.0 val1=vdd valx=vdd/2 rise=2p fall=2p
_ie99842 (atBar_5 0) d2a src="99842" val0=0.0 val1=vdd valx=vdd/2 rise=2p fall=2p
_ie99843 (btBar_3 0) d2a src="99843" val0=0.0 val1=vdd valx=vdd/2 rise=2p fall=2p
_ie99844 (sfBar_19 0) a2d dest="99844" vl=0.3*vdd vh=0.7*vdd timex=20n
_ie99845 (btBar_11 0) d2a src="99845" val0=0.0 val1=vdd valx=vdd/2 rise=2p fall=2p
_ie99846 (afBar_26 0) d2a src="99846" val0=0.0 val1=vdd valx=vdd/2 rise=2p fall=2p
_ie99847 (afBar_18 0) d2a src="99847" val0=0.0 val1=vdd valx=vdd/2 rise=2p fall=2p
_ie99848 (atBar_6 0) d2a src="99848" val0=0.0 val1=vdd valx=vdd/2 rise=2p fall=2p
_ie99849 (stBar_31 0) a2d dest="99849" vl=0.3*vdd vh=0.7*vdd timex=20n
_ie99850 (bfBar_14 0) d2a src="99850" val0=0.0 val1=vdd valx=vdd/2 rise=2p fall=2p
_ie99851 (atBar_15 0) d2a src="99851" val0=0.0 val1=vdd valx=vdd/2 rise=2p fall=2p
_ie99852 (afBar_17 0) d2a src="99852" val0=0.0 val1=vdd valx=vdd/2 rise=2p fall=2p
_ie99853 (atBar_4 0) d2a src="99853" val0=0.0 val1=vdd valx=vdd/2 rise=2p fall=2p
_ie99854 (sfBar_20 0) a2d dest="99854" vl=0.3*vdd vh=0.7*vdd timex=20n
_ie99855 (atBar_16 0) d2a src="99855" val0=0.0 val1=vdd valx=vdd/2 rise=2p fall=2p
_ie99856 (sfBar_21 0) a2d dest="99856" vl=0.3*vdd vh=0.7*vdd timex=20n
_ie99857 (afBar_14 0) d2a src="99857" val0=0.0 val1=vdd valx=vdd/2 rise=2p fall=2p
_ie99858 (afBar_27 0) d2a src="99858" val0=0.0 val1=vdd valx=vdd/2 rise=2p fall=2p
_ie99859 (afBar_28 0) d2a src="99859" val0=0.0 val1=vdd valx=vdd/2 rise=2p fall=2p
_ie99860 (sfBar_5 0) a2d dest="99860" vl=0.3*vdd vh=0.7*vdd timex=20n
_ie99861 (atBar_17 0) d2a src="99861" val0=0.0 val1=vdd valx=vdd/2 rise=2p fall=2p
_ie99862 (atBar_7 0) d2a src="99862" val0=0.0 val1=vdd valx=vdd/2 rise=2p fall=2p
_ie99863 (atBar_1 0) d2a src="99863" val0=0.0 val1=vdd valx=vdd/2 rise=2p fall=2p
_ie99864 (atBar_18 0) d2a src="99864" val0=0.0 val1=vdd valx=vdd/2 rise=2p fall=2p
_ie99865 (btBar_14 0) d2a src="99865" val0=0.0 val1=vdd valx=vdd/2 rise=2p fall=2p
_ie99866 (btBar_15 0) d2a src="99866" val0=0.0 val1=vdd valx=vdd/2 rise=2p fall=2p
_ie99867 (sfBar_14 0) a2d dest="99867" vl=0.3*vdd vh=0.7*vdd timex=20n
_ie99868 (sfBar_15 0) a2d dest="99868" vl=0.3*vdd vh=0.7*vdd timex=20n
_ie99869 (atBar_25 0) d2a src="99869" val0=0.0 val1=vdd valx=vdd/2 rise=2p fall=2p
_ie99870 (sfBar_16 0) a2d dest="99870" vl=0.3*vdd vh=0.7*vdd timex=20n
_ie99871 (btBar_4 0) d2a src="99871" val0=0.0 val1=vdd valx=vdd/2 rise=2p fall=2p
_ie99872 (atBar_19 0) d2a src="99872" val0=0.0 val1=vdd valx=vdd/2 rise=2p fall=2p
_ie99873 (sfBar_6 0) a2d dest="99873" vl=0.3*vdd vh=0.7*vdd timex=20n
_ie99874 (sfBar_17 0) a2d dest="99874" vl=0.3*vdd vh=0.7*vdd timex=20n
_ie99875 (cfBar 0) d2a src="99875" val0=0.0 val1=vdd valx=vdd/2 rise=2p fall=2p
_ie99876 (bfBar_26 0) d2a src="99876" val0=0.0 val1=vdd valx=vdd/2 rise=2p fall=2p
_ie99877 (stBar_24 0) a2d dest="99877" vl=0.3*vdd vh=0.7*vdd timex=20n
_ie99878 (stBar_23 0) a2d dest="99878" vl=0.3*vdd vh=0.7*vdd timex=20n
_ie99879 (bfBar_19 0) d2a src="99879" val0=0.0 val1=vdd valx=vdd/2 rise=2p fall=2p
_ie99880 (bfBar_18 0) d2a src="99880" val0=0.0 val1=vdd valx=vdd/2 rise=2p fall=2p
_ie99881 (sfBar_7 0) a2d dest="99881" vl=0.3*vdd vh=0.7*vdd timex=20n
_ie99882 (bfBar_4 0) d2a src="99882" val0=0.0 val1=vdd valx=vdd/2 rise=2p fall=2p
_ie99883 (btBar_16 0) d2a src="99883" val0=0.0 val1=vdd valx=vdd/2 rise=2p fall=2p
_ie99884 (afBar_30 0) d2a src="99884" val0=0.0 val1=vdd valx=vdd/2 rise=2p fall=2p
_ie99885 (afBar_7 0) d2a src="99885" val0=0.0 val1=vdd valx=vdd/2 rise=2p fall=2p
_ie99886 (sfBar_8 0) a2d dest="99886" vl=0.3*vdd vh=0.7*vdd timex=20n
_ie99887 (stBar_30 0) a2d dest="99887" vl=0.3*vdd vh=0.7*vdd timex=20n
_ie99888 (stBar_29 0) a2d dest="99888" vl=0.3*vdd vh=0.7*vdd timex=20n
_ie99889 (stBar_28 0) a2d dest="99889" vl=0.3*vdd vh=0.7*vdd timex=20n
_ie99890 (stBar_27 0) a2d dest="99890" vl=0.3*vdd vh=0.7*vdd timex=20n
_ie99891 (stBar_26 0) a2d dest="99891" vl=0.3*vdd vh=0.7*vdd timex=20n
_ie99892 (sfBar_31 0) a2d dest="99892" vl=0.3*vdd vh=0.7*vdd timex=20n
_ie99893 (sfBar_9 0) a2d dest="99893" vl=0.3*vdd vh=0.7*vdd timex=20n
_ie99894 (afBar_10 0) d2a src="99894" val0=0.0 val1=vdd valx=vdd/2 rise=2p fall=2p
_ie99895 (afBar_11 0) d2a src="99895" val0=0.0 val1=vdd valx=vdd/2 rise=2p fall=2p
_ie99896 (bfBar_5 0) d2a src="99896" val0=0.0 val1=vdd valx=vdd/2 rise=2p fall=2p
_ie99897 (sfBar_22 0) a2d dest="99897" vl=0.3*vdd vh=0.7*vdd timex=20n
_ie99898 (bfBar_6 0) d2a src="99898" val0=0.0 val1=vdd valx=vdd/2 rise=2p fall=2p
_ie99899 (stBar_18 0) a2d dest="99899" vl=0.3*vdd vh=0.7*vdd timex=20n
_ie99900 (sfBar_24 0) a2d dest="99900" vl=0.3*vdd vh=0.7*vdd timex=20n
_ie99901 (atBar_20 0) d2a src="99901" val0=0.0 val1=vdd valx=vdd/2 rise=2p fall=2p
_ie99902 (bfBar_24 0) d2a src="99902" val0=0.0 val1=vdd valx=vdd/2 rise=2p fall=2p
_ie99903 (afBar_24 0) d2a src="99903" val0=0.0 val1=vdd valx=vdd/2 rise=2p fall=2p
_ie99904 (afBar_23 0) d2a src="99904" val0=0.0 val1=vdd valx=vdd/2 rise=2p fall=2p
_ie99905 (stBar_12 0) a2d dest="99905" vl=0.3*vdd vh=0.7*vdd timex=20n
_ie99906 (stBar_13 0) a2d dest="99906" vl=0.3*vdd vh=0.7*vdd timex=20n
_ie99907 (afBar_29 0) d2a src="99907" val0=0.0 val1=vdd valx=vdd/2 rise=2p fall=2p
_ie99908 (bfBar_25 0) d2a src="99908" val0=0.0 val1=vdd valx=vdd/2 rise=2p fall=2p
_ie99909 (atBar_30 0) d2a src="99909" val0=0.0 val1=vdd valx=vdd/2 rise=2p fall=2p
_ie99910 (atBar_29 0) d2a src="99910" val0=0.0 val1=vdd valx=vdd/2 rise=2p fall=2p
_ie99911 (stBar_19 0) a2d dest="99911" vl=0.3*vdd vh=0.7*vdd timex=20n
_ie99912 (atBar_13 0) d2a src="99912" val0=0.0 val1=vdd valx=vdd/2 rise=2p fall=2p
_ie99913 (bfBar_29 0) d2a src="99913" val0=0.0 val1=vdd valx=vdd/2 rise=2p fall=2p
_ie99914 (bfBar_27 0) d2a src="99914" val0=0.0 val1=vdd valx=vdd/2 rise=2p fall=2p
_ie99915 (atBar_14 0) d2a src="99915" val0=0.0 val1=vdd valx=vdd/2 rise=2p fall=2p
_ie99916 (bfBar_17 0) d2a src="99916" val0=0.0 val1=vdd valx=vdd/2 rise=2p fall=2p
_ie99917 (bfBar_28 0) d2a src="99917" val0=0.0 val1=vdd valx=vdd/2 rise=2p fall=2p
_ie99918 (afBar_31 0) d2a src="99918" val0=0.0 val1=vdd valx=vdd/2 rise=2p fall=2p
_ie99919 (bfBar_7 0) d2a src="99919" val0=0.0 val1=vdd valx=vdd/2 rise=2p fall=2p
_ie99920 (bfBar_8 0) d2a src="99920" val0=0.0 val1=vdd valx=vdd/2 rise=2p fall=2p
_ie99921 (bfBar_9 0) d2a src="99921" val0=0.0 val1=vdd valx=vdd/2 rise=2p fall=2p
_ie99922 (bfBar_10 0) d2a src="99922" val0=0.0 val1=vdd valx=vdd/2 rise=2p fall=2p
_ie99923 (atBar_12 0) d2a src="99923" val0=0.0 val1=vdd valx=vdd/2 rise=2p fall=2p
_ie99924 (btBar_5 0) d2a src="99924" val0=0.0 val1=vdd valx=vdd/2 rise=2p fall=2p
_ie99925 (bfBar_31 0) d2a src="99925" val0=0.0 val1=vdd valx=vdd/2 rise=2p fall=2p
_ie99926 (sfBar_10 0) a2d dest="99926" vl=0.3*vdd vh=0.7*vdd timex=20n
_ie99927 (sfBar_25 0) a2d dest="99927" vl=0.3*vdd vh=0.7*vdd timex=20n
_ie99928 (stBar_20 0) a2d dest="99928" vl=0.3*vdd vh=0.7*vdd timex=20n
_ie99929 (sfBar_26 0) a2d dest="99929" vl=0.3*vdd vh=0.7*vdd timex=20n
_ie99930 (sfBar_11 0) a2d dest="99930" vl=0.3*vdd vh=0.7*vdd timex=20n
_ie99931 (sfBar_12 0) a2d dest="99931" vl=0.3*vdd vh=0.7*vdd timex=20n
_ie99932 (sfBar_27 0) a2d dest="99932" vl=0.3*vdd vh=0.7*vdd timex=20n
_ie99933 (atBar_11 0) d2a src="99933" val0=0.0 val1=vdd valx=vdd/2 rise=2p fall=2p
_ie99934 (atBar_10 0) d2a src="99934" val0=0.0 val1=vdd valx=vdd/2 rise=2p fall=2p
_ie99935 (bfBar_30 0) d2a src="99935" val0=0.0 val1=vdd valx=vdd/2 rise=2p fall=2p
_ie99936 (sfBar_3 0) a2d dest="99936" vl=0.3*vdd vh=0.7*vdd timex=20n
_ie99937 (afBar_15 0) d2a src="99937" val0=0.0 val1=vdd valx=vdd/2 rise=2p fall=2p
_ie99938 (stBar_21 0) a2d dest="99938" vl=0.3*vdd vh=0.7*vdd timex=20n
_ie99939 (bfBar_15 0) d2a src="99939" val0=0.0 val1=vdd valx=vdd/2 rise=2p fall=2p
_ie99940 (btBar_6 0) d2a src="99940" val0=0.0 val1=vdd valx=vdd/2 rise=2p fall=2p
_ie99941 (afBar_22 0) d2a src="99941" val0=0.0 val1=vdd valx=vdd/2 rise=2p fall=2p
_ie99942 (bfBar_16 0) d2a src="99942" val0=0.0 val1=vdd valx=vdd/2 rise=2p fall=2p
_ie99943 (afBar_20 0) d2a src="99943" val0=0.0 val1=vdd valx=vdd/2 rise=2p fall=2p
_ie99944 (stBar_0 0) a2d dest="99944" vl=0.3*vdd vh=0.7*vdd timex=20n
_ie99945 (btBar_7 0) d2a src="99945" val0=0.0 val1=vdd valx=vdd/2 rise=2p fall=2p
_ie99946 (btBar_8 0) d2a src="99946" val0=0.0 val1=vdd valx=vdd/2 rise=2p fall=2p
_ie99947 (sfBar_28 0) a2d dest="99947" vl=0.3*vdd vh=0.7*vdd timex=20n
_ie99948 (bfBar_11 0) d2a src="99948" val0=0.0 val1=vdd valx=vdd/2 rise=2p fall=2p
_ie99949 (stBar_22 0) a2d dest="99949" vl=0.3*vdd vh=0.7*vdd timex=20n
_ie99950 (sfBar_29 0) a2d dest="99950" vl=0.3*vdd vh=0.7*vdd timex=20n
_ie99951 (ReqBar 0) a2d dest="99951" vl=0.3*vdd vh=0.7*vdd timex=20n
_ie99952 (btBar_9 0) d2a src="99952" val0=0.0 val1=vdd valx=vdd/2 rise=2p fall=2p
_ie99953 (stBar_16 0) a2d dest="99953" vl=0.3*vdd vh=0.7*vdd timex=20n
_ie99954 (stBar_15 0) a2d dest="99954" vl=0.3*vdd vh=0.7*vdd timex=20n
_ie99955 (dtBar 0) a2d dest="99955" vl=0.3*vdd vh=0.7*vdd timex=20n
_ie99956 (stBar_14 0) a2d dest="99956" vl=0.3*vdd vh=0.7*vdd timex=20n
_ie99957 (dfBar 0) a2d dest="99957" vl=0.3*vdd vh=0.7*vdd timex=20n
_ie99958 (atBar_21 0) d2a src="99958" val0=0.0 val1=vdd valx=vdd/2 rise=2p fall=2p
_ie99959 (sfBar_0 0) a2d dest="99959" vl=0.3*vdd vh=0.7*vdd timex=20n
_ie99960 (atBar_27 0) d2a src="99960" val0=0.0 val1=vdd valx=vdd/2 rise=2p fall=2p
_ie99961 (bfBar_22 0) d2a src="99961" val0=0.0 val1=vdd valx=vdd/2 rise=2p fall=2p
_ie99962 (sfBar_1 0) a2d dest="99962" vl=0.3*vdd vh=0.7*vdd timex=20n
_ie99963 (sfBar_23 0) a2d dest="99963" vl=0.3*vdd vh=0.7*vdd timex=20n
_ie99964 (atBar_22 0) d2a src="99964" val0=0.0 val1=vdd valx=vdd/2 rise=2p fall=2p
_ie99965 (atBar_28 0) d2a src="99965" val0=0.0 val1=vdd valx=vdd/2 rise=2p fall=2p
_ie99966 (sfBar_2 0) a2d dest="99966" vl=0.3*vdd vh=0.7*vdd timex=20n
_ie99967 (stBar_1 0) a2d dest="99967" vl=0.3*vdd vh=0.7*vdd timex=20n
_ie99968 (stBar_2 0) a2d dest="99968" vl=0.3*vdd vh=0.7*vdd timex=20n
_ie99969 (stBar_3 0) a2d dest="99969" vl=0.3*vdd vh=0.7*vdd timex=20n
_ie99970 (stBar_5 0) a2d dest="99970" vl=0.3*vdd vh=0.7*vdd timex=20n
_ie99971 (bfBar_23 0) d2a src="99971" val0=0.0 val1=vdd valx=vdd/2 rise=2p fall=2p
_ie99972 (stBar_6 0) a2d dest="99972" vl=0.3*vdd vh=0.7*vdd timex=20n
_ie99973 (sfBar_30 0) a2d dest="99973" vl=0.3*vdd vh=0.7*vdd timex=20n
_ie99974 (afBar_8 0) d2a src="99974" val0=0.0 val1=vdd valx=vdd/2 rise=2p fall=2p
_ie99975 (btBar_10 0) d2a src="99975" val0=0.0 val1=vdd valx=vdd/2 rise=2p fall=2p
_ie99976 (atBar_26 0) d2a src="99976" val0=0.0 val1=vdd valx=vdd/2 rise=2p fall=2p
_ie99977 (stBar_4 0) a2d dest="99977" vl=0.3*vdd vh=0.7*vdd timex=20n
_ie99978 (stBar_7 0) a2d dest="99978" vl=0.3*vdd vh=0.7*vdd timex=20n
_ie99979 (stBar_8 0) a2d dest="99979" vl=0.3*vdd vh=0.7*vdd timex=20n
_ie99980 (stBar_9 0) a2d dest="99980" vl=0.3*vdd vh=0.7*vdd timex=20n
_ie99981 (stBar_10 0) a2d dest="99981" vl=0.3*vdd vh=0.7*vdd timex=20n
_ie99982 (btBar_23 0) d2a src="99982" val0=0.0 val1=vdd valx=vdd/2 rise=2p fall=2p
_ie99983 (btBar_24 0) d2a src="99983" val0=0.0 val1=vdd valx=vdd/2 rise=2p fall=2p
_ie99984 (afBar_6 0) d2a src="99984" val0=0.0 val1=vdd valx=vdd/2 rise=2p fall=2p
_ie99985 (btBar_25 0) d2a src="99985" val0=0.0 val1=vdd valx=vdd/2 rise=2p fall=2p
_ie99986 (btBar_26 0) d2a src="99986" val0=0.0 val1=vdd valx=vdd/2 rise=2p fall=2p
_ie99987 (btBar_27 0) d2a src="99987" val0=0.0 val1=vdd valx=vdd/2 rise=2p fall=2p
_ie99988 (btBar_28 0) d2a src="99988" val0=0.0 val1=vdd valx=vdd/2 rise=2p fall=2p
_ie99989 (btBar_29 0) d2a src="99989" val0=0.0 val1=vdd valx=vdd/2 rise=2p fall=2p
_ie99990 (btBar_30 0) d2a src="99990" val0=0.0 val1=vdd valx=vdd/2 rise=2p fall=2p
_ie99991 (atBar_31 0) d2a src="99991" val0=0.0 val1=vdd valx=vdd/2 rise=2p fall=2p
_ie99992 (stBar_11 0) a2d dest="99992" vl=0.3*vdd vh=0.7*vdd timex=20n
_ie99993 (btBar_31 0) d2a src="99993" val0=0.0 val1=vdd valx=vdd/2 rise=2p fall=2p
_ie99994 (afBar_12 0) d2a src="99994" val0=0.0 val1=vdd valx=vdd/2 rise=2p fall=2p
_ie99995 (bfBar_20 0) d2a src="99995" val0=0.0 val1=vdd valx=vdd/2 rise=2p fall=2p
_ie99996 (afBar_13 0) d2a src="99996" val0=0.0 val1=vdd valx=vdd/2 rise=2p fall=2p
_ie99997 (sfBar_4 0) a2d dest="99997" vl=0.3*vdd vh=0.7*vdd timex=20n
_ie99998 (bfBar_21 0) d2a src="99998" val0=0.0 val1=vdd valx=vdd/2 rise=2p fall=2p
_ie99999 (afBar_16 0) d2a src="99999" val0=0.0 val1=vdd valx=vdd/2 rise=2p fall=2p
// END Hierarchical Interface Elements
ic cfT=0 ctT=0 btT_31=0 btT_30=0 btT_29=0 btT_28=0 btT_27=0 btT_26=0 btT_25=0 btT_24=0 btT_23=0 btT_22=0 btT_21=0 btT_20=0 btT_19=0 btT_18=0 btT_17=0 btT_16=0 btT_15=0 btT_14=0 btT_13=0 btT_12=0 btT_11=0 btT_10=0 btT_9=0 btT_8=0 btT_7=0 btT_6=0 btT_5=0 btT_4=0 btT_3=0 btT_2=0 btT_1=0 btT_0=0 bfT_31=0 bfT_30=0 bfT_29=0 bfT_28=0 bfT_27=0 bfT_26=0 bfT_25=0 bfT_24=0 bfT_23=0 bfT_22=0 bfT_21=0 bfT_20=0 bfT_19=0 bfT_18=0 bfT_17=0 bfT_16=0 bfT_15=0 bfT_14=0 bfT_13=0 bfT_12=0 bfT_11=0 bfT_10=0 bfT_9=0 bfT_8=0 bfT_7=0 bfT_6=0 bfT_5=0 bfT_4=0 bfT_3=0 bfT_2=0 bfT_1=0 bfT_0=0 atT_31=0 atT_30=0 atT_29=0 atT_28=0 atT_27=0 atT_26=0 atT_25=0 atT_24=0 atT_23=0 atT_22=0 atT_21=0 atT_20=0 atT_19=0 atT_18=0 atT_17=0 atT_16=0 atT_15=0 atT_14=0 atT_13=0 atT_12=0 atT_11=0 atT_10=0 atT_9=0 atT_8=0 atT_7=0 atT_6=0 atT_5=0 atT_4=0 atT_3=0 atT_2=0 atT_1=0 atT_0=0 afT_31=0 afT_30=0 afT_29=0 afT_28=0 afT_27=0 afT_26=0 afT_25=0 afT_24=0 afT_23=0 afT_22=0 afT_21=0 afT_20=0 afT_19=0 afT_18=0 afT_17=0 afT_16=0 afT_15=0 afT_14=0 afT_13=0 afT_12=0 afT_11=0 afT_10=0 afT_9=0 afT_8=0 afT_7=0 afT_6=0 afT_5=0 afT_4=0 afT_3=0 afT_2=0 afT_1=0 afT_0=0
simulatorOptions options temp=27
tran tran stop=50n errpreset=conservative
save V1:p V1:p
