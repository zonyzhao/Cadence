simulator( 'spectreVerilog )
design(	 "/net/kafka/nfs/rstdenis/Cadence/simulation/Martin32_Test/spectreVerilog/config/netlist/analog/netlist")
resultsDir( "/net/kafka/nfs/rstdenis/Cadence/simulation/Martin32_Test/spectreVerilog/config" )
modelFile(
    '("/project/ncsu-FreePDK15/hspice_16nm_hp.include" "")
)
analysis('tran ?stop "15n"  ?errpreset "conservative"  )
desVar(	  "vdd" 0.5	)
desVar(	  "vcc" 0.5	)
envOption(
	'analysisOrder  list("tran")
)
option(	'multithread  "on"
)
saveOption( ?simOutputFormat "psfxl" )
save( 'i "/V1/PLUS" "/V1/MINUS" )
converge( 'ic "/afT<0>" "0" )
converge( 'ic "/afT<1>" "0" )
converge( 'ic "/afT<2>" "0" )
converge( 'ic "/afT<3>" "0" )
converge( 'ic "/afT<4>" "0" )
converge( 'ic "/afT<5>" "0" )
converge( 'ic "/afT<6>" "0" )
converge( 'ic "/afT<7>" "0" )
converge( 'ic "/afT<8>" "0" )
converge( 'ic "/afT<9>" "0" )
converge( 'ic "/afT<10>" "0" )
converge( 'ic "/afT<11>" "0" )
converge( 'ic "/afT<12>" "0" )
converge( 'ic "/afT<13>" "0" )
converge( 'ic "/afT<14>" "0" )
converge( 'ic "/afT<15>" "0" )
converge( 'ic "/afT<16>" "0" )
converge( 'ic "/afT<17>" "0" )
converge( 'ic "/afT<18>" "0" )
converge( 'ic "/afT<19>" "0" )
converge( 'ic "/afT<20>" "0" )
converge( 'ic "/afT<21>" "0" )
converge( 'ic "/afT<22>" "0" )
converge( 'ic "/afT<23>" "0" )
converge( 'ic "/afT<24>" "0" )
converge( 'ic "/afT<25>" "0" )
converge( 'ic "/afT<26>" "0" )
converge( 'ic "/afT<27>" "0" )
converge( 'ic "/afT<28>" "0" )
converge( 'ic "/afT<29>" "0" )
converge( 'ic "/afT<30>" "0" )
converge( 'ic "/afT<31>" "0" )
converge( 'ic "/atT<0>" "0" )
converge( 'ic "/atT<1>" "0" )
converge( 'ic "/atT<2>" "0" )
converge( 'ic "/atT<3>" "0" )
converge( 'ic "/atT<4>" "0" )
converge( 'ic "/atT<5>" "0" )
converge( 'ic "/atT<6>" "0" )
converge( 'ic "/atT<7>" "0" )
converge( 'ic "/atT<8>" "0" )
converge( 'ic "/atT<9>" "0" )
converge( 'ic "/atT<10>" "0" )
converge( 'ic "/atT<11>" "0" )
converge( 'ic "/atT<12>" "0" )
converge( 'ic "/atT<13>" "0" )
converge( 'ic "/atT<14>" "0" )
converge( 'ic "/atT<15>" "0" )
converge( 'ic "/atT<16>" "0" )
converge( 'ic "/atT<17>" "0" )
converge( 'ic "/atT<18>" "0" )
converge( 'ic "/atT<19>" "0" )
converge( 'ic "/atT<20>" "0" )
converge( 'ic "/atT<21>" "0" )
converge( 'ic "/atT<22>" "0" )
converge( 'ic "/atT<23>" "0" )
converge( 'ic "/atT<24>" "0" )
converge( 'ic "/atT<25>" "0" )
converge( 'ic "/atT<26>" "0" )
converge( 'ic "/atT<27>" "0" )
converge( 'ic "/atT<28>" "0" )
converge( 'ic "/atT<29>" "0" )
converge( 'ic "/atT<30>" "0" )
converge( 'ic "/atT<31>" "0" )
converge( 'ic "/bfT<0>" "0" )
converge( 'ic "/bfT<1>" "0" )
converge( 'ic "/bfT<2>" "0" )
converge( 'ic "/bfT<3>" "0" )
converge( 'ic "/bfT<4>" "0" )
converge( 'ic "/bfT<5>" "0" )
converge( 'ic "/bfT<6>" "0" )
converge( 'ic "/bfT<7>" "0" )
converge( 'ic "/bfT<8>" "0" )
converge( 'ic "/bfT<9>" "0" )
converge( 'ic "/bfT<10>" "0" )
converge( 'ic "/bfT<11>" "0" )
converge( 'ic "/bfT<12>" "0" )
converge( 'ic "/bfT<13>" "0" )
converge( 'ic "/bfT<14>" "0" )
converge( 'ic "/bfT<15>" "0" )
converge( 'ic "/bfT<16>" "0" )
converge( 'ic "/bfT<17>" "0" )
converge( 'ic "/bfT<18>" "0" )
converge( 'ic "/bfT<19>" "0" )
converge( 'ic "/bfT<20>" "0" )
converge( 'ic "/bfT<21>" "0" )
converge( 'ic "/bfT<22>" "0" )
converge( 'ic "/bfT<23>" "0" )
converge( 'ic "/bfT<24>" "0" )
converge( 'ic "/bfT<25>" "0" )
converge( 'ic "/bfT<26>" "0" )
converge( 'ic "/bfT<27>" "0" )
converge( 'ic "/bfT<28>" "0" )
converge( 'ic "/bfT<29>" "0" )
converge( 'ic "/bfT<30>" "0" )
converge( 'ic "/bfT<31>" "0" )
converge( 'ic "/btT<0>" "0" )
converge( 'ic "/btT<1>" "0" )
converge( 'ic "/btT<2>" "0" )
converge( 'ic "/btT<3>" "0" )
converge( 'ic "/btT<4>" "0" )
converge( 'ic "/btT<5>" "0" )
converge( 'ic "/btT<6>" "0" )
converge( 'ic "/btT<7>" "0" )
converge( 'ic "/btT<8>" "0" )
converge( 'ic "/btT<9>" "0" )
converge( 'ic "/btT<10>" "0" )
converge( 'ic "/btT<11>" "0" )
converge( 'ic "/btT<12>" "0" )
converge( 'ic "/btT<13>" "0" )
converge( 'ic "/btT<14>" "0" )
converge( 'ic "/btT<15>" "0" )
converge( 'ic "/btT<16>" "0" )
converge( 'ic "/btT<17>" "0" )
converge( 'ic "/btT<18>" "0" )
converge( 'ic "/btT<19>" "0" )
converge( 'ic "/btT<20>" "0" )
converge( 'ic "/btT<21>" "0" )
converge( 'ic "/btT<22>" "0" )
converge( 'ic "/btT<23>" "0" )
converge( 'ic "/btT<24>" "0" )
converge( 'ic "/btT<25>" "0" )
converge( 'ic "/btT<26>" "0" )
converge( 'ic "/btT<27>" "0" )
converge( 'ic "/btT<28>" "0" )
converge( 'ic "/btT<29>" "0" )
converge( 'ic "/btT<30>" "0" )
converge( 'ic "/btT<31>" "0" )
converge( 'ic "/ctT" "0" )
converge( 'ic "/cfT" "0" )
temp( 27 )
run()
selectResult( 'tran )
plot(getData("/af<31:0>") getData("/at<31:0>") getData("/bf<31:0>") getData("/bt<31:0>") getData("/df") getData("/dt") getData("/ct") getData("/cf") getData("/Req") getData("/st<31:0>") getData("/sf<31:0>") getData("/V1/PLUS") getData("/V1/MINUS") )
modelFile(
    '("/project/ncsu-FreePDK15/hspice_16nm_hp.include" "")
)
run()
selectResult( 'tran )
plot(getData("/af<31:0>") getData("/at<31:0>") getData("/bf<31:0>") getData("/bt<31:0>") getData("/df") getData("/dt") getData("/ct") getData("/cf") getData("/Req") getData("/st<31:0>") getData("/sf<31:0>") getData("/V1/PLUS") getData("/V1/MINUS") )
modelFile(
    '("/project/ncsu-FreePDK15/hspice_16nm_hp.include" "")
)
run()
selectResult( 'tran )
plot(getData("/af<31:0>") getData("/at<31:0>") getData("/bf<31:0>") getData("/bt<31:0>") getData("/df") getData("/dt") getData("/ct") getData("/cf") getData("/Req") getData("/st<31:0>") getData("/sf<31:0>") getData("/V1/PLUS") getData("/V1/MINUS") )
modelFile(
    '("/project/ncsu-FreePDK15/hspice_16nm_hp.include" "")
)
analysis('tran ?stop "50n"  )
run()
selectResult( 'tran )
plot(getData("/af<31:0>") getData("/at<31:0>") getData("/bf<31:0>") getData("/bt<31:0>") getData("/df") getData("/dt") getData("/ct") getData("/cf") getData("/Req") getData("/st<31:0>") getData("/sf<31:0>") getData("/V1/PLUS") getData("/V1/MINUS") )
modelFile(
    '("/project/ncsu-FreePDK15/hspice_16nm_hp.include" "")
)
run()
selectResult( 'tran )
plot(getData("/Ack") getData("/af<31:0>") getData("/at<31:0>") getData("/bf<31:0>") getData("/bt<31:0>") getData("/df") getData("/dt") getData("/ct") getData("/cf") getData("/st<31:0>") getData("/sf<31:0>") getData("/V1/PLUS") getData("/V1/MINUS") )
modelFile(
    '("/project/ncsu-FreePDK15/hspice_16nm_hp.include" "")
)
run()
selectResult( 'tran )
plot(getData("/Ack") getData("/af<31:0>") getData("/at<31:0>") getData("/bf<31:0>") getData("/bt<31:0>") getData("/df") getData("/dt") getData("/ct") getData("/cf") getData("/st<31:0>") getData("/sf<31:0>") getData("/V1/PLUS") getData("/V1/MINUS") )
modelFile(
    '("/project/ncsu-FreePDK15/hspice_16nm_hp.include" "")
)
run()
selectResult( 'tran )
plot(getData("/af<31:0>") getData("/at<31:0>") getData("/bf<31:0>") getData("/bt<31:0>") getData("/df") getData("/dt") getData("/ct") getData("/cf") getData("/st<31:0>") getData("/sf<31:0>") getData("/V1/PLUS") getData("/V1/MINUS") getData("/Ack") )
