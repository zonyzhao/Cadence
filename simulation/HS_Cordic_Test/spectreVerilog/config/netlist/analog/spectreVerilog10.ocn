simulator( 'spectreVerilog )
design(	 "/net/kafka/nfs/rstdenis/Cadence/simulation/HS_Cordic_Test/spectreVerilog/config/netlist/analog/netlist")
resultsDir( "/net/kafka/nfs/rstdenis/Cadence/simulation/HS_Cordic_Test/spectreVerilog/config" )
modelFile(
    '("/software/cadence/ncsu-FreePDK15/hspice_16nm_hp.include" "")
)
analysis('tran ?stop "5n"  ?errpreset "conservative"  )
desVar(	  "vcc" "vdd"	)
desVar(	  "vdd" .500	)
envOption(
	'mspSetupNetlistSimPrecisionUnit  "ps"
	'mspSetupNetlistSimTimeUnit  "ps"
	'mspSetupNetlistSwitchRC  t
	'analysisOrder  list("tran")
)
saveOption( ?simOutputFormat "psfxl" )
converge( 'ic "/LreqT" "0" )
converge( 'ic "/DataInT<0>" "0" )
converge( 'ic "/DataInT<1>" "0" )
converge( 'ic "/DataInT<2>" "0" )
converge( 'ic "/DataInT<3>" "0" )
converge( 'ic "/DataInT<4>" "0" )
converge( 'ic "/DataInT<5>" "0" )
converge( 'ic "/DataInT<6>" "0" )
converge( 'ic "/DataInT<7>" "0" )
converge( 'ic "/DataInT<8>" "0" )
converge( 'ic "/DataInT<9>" "0" )
converge( 'ic "/DataInT<10>" "0" )
converge( 'ic "/DataInT<11>" "0" )
converge( 'ic "/DataInT<12>" "0" )
converge( 'ic "/DataInT<13>" "0" )
converge( 'ic "/DataInT<14>" "0" )
converge( 'ic "/DataInT<15>" "0" )
converge( 'ic "/DataInT<16>" "0" )
converge( 'ic "/DataInT<17>" "0" )
converge( 'ic "/DataInT<18>" "0" )
converge( 'ic "/DataInT<19>" "0" )
converge( 'ic "/DataInT<20>" "0" )
converge( 'ic "/DataInT<21>" "0" )
converge( 'ic "/DataInT<22>" "0" )
converge( 'ic "/DataInT<23>" "0" )
converge( 'ic "/DataInT<24>" "0" )
converge( 'ic "/DataInT<25>" "0" )
converge( 'ic "/DataInT<26>" "0" )
converge( 'ic "/DataInT<27>" "0" )
converge( 'ic "/DataInT<28>" "0" )
converge( 'ic "/DataInT<29>" "0" )
converge( 'ic "/DataInT<30>" "0" )
converge( 'ic "/DataInT<31>" "0" )
converge( 'ic "/ackOutT" "0" )
converge( 'ic "/RreqT" "0" )
converge( 'ic "/RdataT<0>" "0" )
converge( 'ic "/RdataT<1>" "0" )
converge( 'ic "/RdataT<2>" "0" )
converge( 'ic "/RdataT<3>" "0" )
converge( 'ic "/RdataT<4>" "0" )
converge( 'ic "/RdataT<5>" "0" )
converge( 'ic "/RdataT<6>" "0" )
converge( 'ic "/RdataT<7>" "0" )
converge( 'ic "/RdataT<8>" "0" )
converge( 'ic "/RdataT<9>" "0" )
converge( 'ic "/RdataT<10>" "0" )
converge( 'ic "/RdataT<11>" "0" )
converge( 'ic "/RdataT<12>" "0" )
converge( 'ic "/RdataT<13>" "0" )
converge( 'ic "/RdataT<14>" "0" )
converge( 'ic "/RdataT<15>" "0" )
converge( 'ic "/RdataT<16>" "0" )
converge( 'ic "/RdataT<17>" "0" )
converge( 'ic "/RdataT<18>" "0" )
converge( 'ic "/RdataT<19>" "0" )
converge( 'ic "/RdataT<20>" "0" )
converge( 'ic "/RdataT<21>" "0" )
converge( 'ic "/RdataT<22>" "0" )
converge( 'ic "/RdataT<23>" "0" )
converge( 'ic "/RdataT<24>" "0" )
converge( 'ic "/RdataT<25>" "0" )
converge( 'ic "/RdataT<26>" "0" )
converge( 'ic "/RdataT<27>" "0" )
converge( 'ic "/RdataT<28>" "0" )
converge( 'ic "/RdataT<29>" "0" )
converge( 'ic "/RdataT<30>" "0" )
converge( 'ic "/RdataT<31>" "0" )
converge( 'ic "/RackT" "0" )
temp( 27 )
run()
selectResult( 'tran )
plot(getData("/RreqT") getData("/RackT") getData("/ackOutT") getData("/LreqT") getData("/reqOut") getData("/DataOut<31:0>") getData("/ackIn") getData("/ackOut") getData("/dataIn<31:0>") getData("/reqIn") )
modelFile(
    '("/software/cadence/ncsu-FreePDK15/hspice_16nm_hp.include" "")
)
run()
selectResult( 'tran )
plot(getData("/RreqT") getData("/RackT") getData("/ackOutT") getData("/LreqT") getData("/reqOut") getData("/DataOut<31:0>") getData("/ackIn") getData("/ackOut") getData("/dataIn<31:0>") getData("/reqIn") )
modelFile(
    '("/software/cadence/ncsu-FreePDK15/hspice_16nm_hp.include" "")
)
run()
selectResult( 'tran )
plot(getData("/RreqT") getData("/RackT") getData("/ackOutT") getData("/LreqT") getData("/reqOut") getData("/DataOut<31:0>") getData("/ackIn") getData("/ackOut") getData("/dataIn<31:0>") getData("/reqIn") )
modelFile(
    '("/software/cadence/ncsu-FreePDK15/hspice_16nm_hp.include" "")
)
run()
selectResult( 'tran )
plot(getData("/reqIn") getData("/dataIn<31:0>") getData("/ackOut") getData("/ackIn") getData("/DataOut<31:0>") getData("/reqOut") getData("/LreqT") getData("/ackOutT") getData("/RackT") getData("/RreqT") )
modelFile(
    '("/software/cadence/ncsu-FreePDK15/hspice_16nm_hp.include" "")
)
envOption(
	'userCmdLineOption  "+multithread"
)
run()
selectResult( 'tran )
plot(getData("/reqIn") getData("/dataIn<31:0>") getData("/ackOut") getData("/ackIn") getData("/DataOut<31:0>") getData("/reqOut") getData("/LreqT") getData("/ackOutT") getData("/RackT") getData("/RreqT") )
modelFile(
    '("/software/cadence/ncsu-FreePDK15/hspice_16nm_hp.include" "")
)
run()
selectResult( 'tran )
plot(getData("/reqIn") getData("/dataIn<31:0>") getData("/ackOut") getData("/ackIn") getData("/DataOut<31:0>") getData("/reqOut") getData("/LreqT") getData("/ackOutT") getData("/RackT") getData("/RreqT") )
modelFile(
    '("/software/cadence/ncsu-FreePDK15/hspice_16nm_hp.include" "")
)
run()
selectResult( 'tran )
plot(getData("/reqIn") getData("/dataIn<31:0>") getData("/ackOut") getData("/ackIn") getData("/DataOut<31:0>") getData("/reqOut") getData("/LreqT") getData("/ackOutT") getData("/RackT") getData("/RreqT") )
modelFile(
    '("/software/cadence/ncsu-FreePDK15/hspice_16nm_hp.include" "")
)
analysis('tran ?stop "3n"  )
run()
selectResult( 'tran )
plot(getData("/reqIn") getData("/dataIn<31:0>") getData("/ackOut") getData("/ackIn") getData("/DataOut<31:0>") getData("/reqOut") getData("/LreqT") getData("/ackOutT") getData("/RackT") getData("/RreqT") )
modelFile(
    '("/software/cadence/ncsu-FreePDK15/hspice_16nm_hp.include" "")
)
save( 'i "/I20/ackIn" "/I20/Req" "/I20/ackOut" "/I20/ReqOut" )
run()
selectResult( 'tran )
plot(getData("/reqIn") getData("/dataIn<31:0>") getData("/ackOut") getData("/ackIn") getData("/DataOut<31:0>") getData("/reqOut") getData("/LreqT") getData("/ackOutT") getData("/RackT") getData("/RreqT") getData("/I20/ackIn") getData("/I20/Req") getData("/I20/ackOut") getData("/I20/ReqOut") )
