simulator( 'spectre )
design(	 "/net/kafka/nfs/rstdenis/Cadence/simulation/ringOsc_Test/spectre/schematic/netlist/netlist")
resultsDir( "/net/kafka/nfs/rstdenis/Cadence/simulation/ringOsc_Test/spectre/schematic" )
modelFile(
    '("/software/cadence/ncsu-FreePDK15/hspice_16nm_hp.include" "")
)
analysis('tran ?stop "500p"  ?errpreset "conservative"  )
desVar(	  "vdd" .850	)
envOption(
	'analysisOrder  list("tran")
)
save( 'v "/inv0" "/nand0" "/nor0" "/nC0" )
converge( 'ic "/inv0" "0" )
converge( 'ic "/inv2" "0" )
converge( 'ic "/inv4" "0" )
converge( 'ic "/inv6" "0" )
converge( 'ic "/inv8" "0" )
converge( 'ic "/nor0" "0" )
converge( 'ic "/no2" "0" )
converge( 'ic "/nor4" "0" )
converge( 'ic "/not6" "0" )
converge( 'ic "/nor8" "0" )
converge( 'ic "/nand0" "0" )
converge( 'ic "/nand2" "0" )
converge( 'ic "/nand4" "0" )
converge( 'ic "/nand6" "0" )
converge( 'ic "/nand8" "0" )
converge( 'ic "/nC0" "0" )
converge( 'ic "/nC10" "vdd" )
temp( 27 )
run()
selectResult( 'tran )
plot(getData("/inv0") getData("/nand0") getData("/nor0") getData("/nC0") )
modelFile(
    '("/software/cadence/ncsu-FreePDK15/hspice_16nm_hp.include" "")
)
run()
selectResult( 'tran )
plot(getData("/inv0") getData("/nand0") getData("/nor0") getData("/nC0") )
modelFile(
    '("/software/cadence/ncsu-FreePDK15/hspice_16nm_hp.include" "")
)
run()
selectResult( 'tran )
plot(getData("/inv0") getData("/nand0") getData("/nor0") getData("/nC0") )
modelFile(
    '("/software/cadence/ncsu-FreePDK15/hspice_16nm_hp.include" "")
)
run()
selectResult( 'tran )
plot(getData("/inv0") getData("/nand0") getData("/nor0") getData("/nC0") )
