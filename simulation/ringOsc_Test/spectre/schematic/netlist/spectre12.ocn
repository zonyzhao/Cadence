simulator( 'spectre )
design(	 "/net/kafka/nfs/rstdenis/Cadence/simulation/ringOsc_Test/spectre/schematic/netlist/netlist")
resultsDir( "/net/kafka/nfs/rstdenis/Cadence/simulation/ringOsc_Test/spectre/schematic" )
modelFile(
    '("/software/cadence/ncsu-FreePDK15/hspice_16nm_hp.include" "")
)
analysis('tran ?stop ".5n"  ?errpreset "conservative"  )
desVar(	  "vdd" 0.850	)
envOption(
	'analysisOrder  list("tran")
)
save( 'v "/inv0" "/nand0" "/nor0" "/nC0" )
converge( 'ic "/inv0" "0" )
converge( 'ic "/inv2" "0" )
converge( 'ic "/inv4" "0" )
converge( 'ic "/inv6" "0" )
converge( 'ic "/inv8" "0" )
converge( 'ic "/nor0" "0" )
converge( 'ic "/no2" "0" )
converge( 'ic "/nor4" "0" )
converge( 'ic "/not6" "0" )
converge( 'ic "/nor8" "0" )
converge( 'ic "/nand0" "0" )
converge( 'ic "/nand2" "0" )
converge( 'ic "/nand4" "0" )
converge( 'ic "/nand6" "0" )
converge( 'ic "/nand8" "0" )
converge( 'ic "/nC0" "0" )
converge( 'ic "/nC10" "vdd" )
temp( 27 )
run()
selectResult( 'tran )
plot(getData("/inv0") getData("/nand0") getData("/nor0") getData("/nC0") getData("/nC1") getData("/nC2") getData("/nC3") getData("/nC10") getData("/nC9") getData("/nC8") )
modelFile(
    '("/software/cadence/ncsu-FreePDK15/hspice_16nm_hp.include" "")
)
save( 'v "/SG_0" )
converge( 'ic "/SG_0" "0" )
converge( 'ic "/net010" "0" )
converge( 'ic "/net076" "0" )
converge( 'ic "/net029" "0" )
converge( 'ic "/net014" "0" )
run()
selectResult( 'tran )
plot(getData("/nand0") getData("/SG_0") )
modelFile(
    '("/software/cadence/ncsu-FreePDK15/hspice_16nm_hp.include" "")
)
run()
selectResult( 'tran )
plot(getData("/nand0") getData("/SG_0") )
modelFile(
    '("/software/cadence/ncsu-FreePDK15/hspice_16nm_hp.include" "")
)
desVar(	  "vdd" 500m	)
run()
selectResult( 'tran )
plot(getData("/nand0") getData("/SG_0") )
modelFile(
    '("/software/cadence/ncsu-FreePDK15/hspice_16nm_hp.include" "")
)
run()
selectResult( 'tran )
plot(getData("/nand0") getData("/SG_0") )
modelFile(
    '("/software/cadence/ncsu-FreePDK15/hspice_16nm_hp.include" "")
)
run()
selectResult( 'tran )
plot(getData("/nand0") getData("/SG_0") )
modelFile(
    '("/software/cadence/ncsu-FreePDK15/hspice_16nm_hp.include" "")
)
desVar(	  "vdd" 300m	)
run()
selectResult( 'tran )
plot(getData("/nand0") getData("/SG_0") )
modelFile(
    '("/software/cadence/ncsu-FreePDK15/hspice_16nm_hp.include" "")
)
desVar(	  "vdd" 200m	)
run()
selectResult( 'tran )
plot(getData("/nand0") getData("/SG_0") )
modelFile(
    '("/software/cadence/ncsu-FreePDK15/hspice_16nm_hp.include" "")
)
analysis('tran ?stop "10n"  )
run()
selectResult( 'tran )
plot(getData("/nand0") getData("/SG_0") )
modelFile(
    '("/software/cadence/ncsu-FreePDK15/hspice_16nm_hp.include" "")
)
analysis('tran ?stop "500p"  )
desVar(	  "vdd" 2	)
run()
selectResult( 'tran )
plot(getData("/nand0") getData("/SG_0") )
modelFile(
    '("/software/cadence/ncsu-FreePDK15/hspice_16nm_hp.include" "")
)
desVar(	  "vdd" 1.3	)
run()
selectResult( 'tran )
plot(getData("/nand0") getData("/SG_0") )
modelFile(
    '("/software/cadence/ncsu-FreePDK15/hspice_16nm_hp.include" "")
)
desVar(	  "vdd" 1.5	)
run()
selectResult( 'tran )
plot(getData("/nand0") getData("/SG_0") )
modelFile(
    '("/software/cadence/ncsu-FreePDK15/hspice_16nm_hp.include" "")
)
run()
selectResult( 'tran )
plot(getData("/nand0") getData("/SG_0") )
modelFile(
    '("/software/cadence/ncsu-FreePDK15/hspice_16nm_hp.include" "")
)
run()
selectResult( 'tran )
plot(getData("/nand0") getData("/SG_0") )
modelFile(
    '("/software/cadence/ncsu-FreePDK15/hspice_16nm_hp.include" "")
)
run()
selectResult( 'tran )
plot(getData("/nand0") getData("/SG_0") )
modelFile(
    '("/software/cadence/ncsu-FreePDK15/hspice_16nm_hp.include" "")
)
run()
selectResult( 'tran )
plot(getData("/nand0") getData("/SG_0") )
modelFile(
    '("/software/cadence/ncsu-FreePDK15/hspice_16nm_hp.include" "")
)
desVar(	  "vdd" 1	)
run()
selectResult( 'tran )
plot(getData("/nand0") getData("/SG_0") )
modelFile(
    '("/software/cadence/ncsu-FreePDK15/hspice_16nm_hp.include" "")
)
desVar(	  "vdd" 2	)
run()
selectResult( 'tran )
plot(getData("/SG_0") )
