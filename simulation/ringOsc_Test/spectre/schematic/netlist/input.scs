// Design: 16nm_Tests/ringOsc_Test
simulator lang=spectre
global 0 vdd!
parameters vdd=2
include "/software/cadence/ncsu-FreePDK15/hspice_16nm_hp.include"

// 16nm/inv_1x/schematic
subckt inv_1x A Y
    M0 (Y A 0 0) nfet w=60n l=20n nfin=1 m=1 degradation=no
    M1 (Y A vdd! vdd!) pfet w=100n l=20n nfin=1 m=1 degradation=no
ends inv_1x

// 16nm/nor_1x/schematic
subckt nor_1x A B Y
    M3 (Y B or_pd_ps vdd!) pfet w=200n l=20n nfin=1 m=1 degradation=yes
    M2 (or_pd_ps A vdd! vdd!) pfet w=200n l=20n nfin=1 m=1 degradation=yes
    M1 (Y B 0 0) nfet w=60n l=20n nfin=1 m=1 degradation=no
    M0 (Y A 0 0) nfet w=60n l=20n nfin=1 m=1 degradation=no
ends nor_1x

// 16nm/nand_1x/schematic
subckt nand_1x A B Y
    M1 (Y B vdd! vdd!) pfet w=100n l=20n nfin=1 m=1 degradation=no
    M0 (Y A vdd! vdd!) pfet w=100n l=20n nfin=1 m=1 degradation=no
    M3 (net22 B 0 0) nfet w=120n l=20n nfin=1 m=1 degradation=no
    M2 (Y A net22 0) nfet w=120n l=20n nfin=1 m=1 degradation=no
ends nand_1x

// 16nm/TH22/schematic
subckt TH22 A B Y
    M5 (Y net5 0 0) nfet w=60n l=20n nfin=1 m=1 degradation=no
    M4 (net5 Y net9 0) nfet w=120n l=20n nfin=1 m=1 degradation=no
    M3 (net9 B 0 0) nfet w=120n l=20n nfin=1 m=1 degradation=no
    M2 (net9 A 0 0) nfet w=120n l=20n nfin=1 m=1 degradation=no
    M1 (net5 B net17 0) nfet w=120n l=20n nfin=1 m=1 degradation=no
    M0 (net17 A 0 0) nfet w=120n l=20n nfin=1 m=1 degradation=no
    M11 (Y net5 vdd! vdd!) pfet w=100n l=20n nfin=1 m=1 degradation=yes
    M10 (net5 B net032 vdd!) pfet w=200n l=20n nfin=1 m=1 degradation=yes
    M9 (net032 A vdd! vdd!) pfet w=200n l=20n nfin=1 m=1 degradation=yes
    M8 (net037 B vdd! vdd!) pfet w=200n l=20n nfin=1 m=1 degradation=yes
    M7 (net037 A vdd! vdd!) pfet w=200n l=20n nfin=1 m=1 degradation=yes
    M6 (net5 Y net037 vdd!) pfet w=200n l=20n nfin=1 m=1 degradation=yes
ends TH22

// 16nm/SG_nand_1x/schematic
subckt SG_nand_1x A B Y
    M1 (Y B vdd! B) pfet w=100n l=20n nfin=1 m=1 degradation=no
    M0 (Y A vdd! A) pfet w=100n l=20n nfin=1 m=1 degradation=no
    M3 (net22 B 0 B) nfet w=120n l=20n nfin=1 m=1 degradation=no
    M2 (Y A net22 A) nfet w=120n l=20n nfin=1 m=1 degradation=no
ends SG_nand_1x

// 16nm_Tests/ringOsc_Test/schematic
V1 (vdd! 0) vsource type=dc dc=vdd
I95\<2\> (net05 net090\<0\>) inv_1x
I95\<1\> (net05 net090\<1\>) inv_1x
I95\<0\> (net05 net090\<2\>) inv_1x
I94\<2\> (net010 net091\<0\>) inv_1x
I94\<1\> (net010 net091\<1\>) inv_1x
I94\<0\> (net010 net091\<2\>) inv_1x
I93\<2\> (net078 net092\<0\>) inv_1x
I93\<1\> (net078 net092\<1\>) inv_1x
I93\<0\> (net078 net092\<2\>) inv_1x
I92\<2\> (net076 net093\<0\>) inv_1x
I92\<1\> (net076 net093\<1\>) inv_1x
I92\<0\> (net076 net093\<2\>) inv_1x
I91\<2\> (net032 net094\<0\>) inv_1x
I91\<1\> (net032 net094\<1\>) inv_1x
I91\<0\> (net032 net094\<2\>) inv_1x
I90\<2\> (net029 net095\<0\>) inv_1x
I90\<1\> (net029 net095\<1\>) inv_1x
I90\<0\> (net029 net095\<2\>) inv_1x
I89\<2\> (net077 net096\<0\>) inv_1x
I89\<1\> (net077 net096\<1\>) inv_1x
I89\<0\> (net077 net096\<2\>) inv_1x
I88\<2\> (net014 net097\<0\>) inv_1x
I88\<1\> (net014 net097\<1\>) inv_1x
I88\<0\> (net014 net097\<2\>) inv_1x
I87\<2\> (net08 net098\<0\>) inv_1x
I87\<1\> (net08 net098\<1\>) inv_1x
I87\<0\> (net08 net098\<2\>) inv_1x
I86\<2\> (net03 net099\<0\>) inv_1x
I86\<1\> (net03 net099\<1\>) inv_1x
I86\<0\> (net03 net099\<2\>) inv_1x
I85\<2\> (SG_0 net0100\<0\>) inv_1x
I85\<1\> (SG_0 net0100\<1\>) inv_1x
I85\<0\> (SG_0 net0100\<2\>) inv_1x
I84\<2\> (nand0 net0101\<0\>) inv_1x
I84\<1\> (nand0 net0101\<1\>) inv_1x
I84\<0\> (nand0 net0101\<2\>) inv_1x
I83\<2\> (nand10 net0102\<0\>) inv_1x
I83\<1\> (nand10 net0102\<1\>) inv_1x
I83\<0\> (nand10 net0102\<2\>) inv_1x
I82\<2\> (nand9 net0103\<0\>) inv_1x
I82\<1\> (nand9 net0103\<1\>) inv_1x
I82\<0\> (nand9 net0103\<2\>) inv_1x
I81\<2\> (nand8 net0104\<0\>) inv_1x
I81\<1\> (nand8 net0104\<1\>) inv_1x
I81\<0\> (nand8 net0104\<2\>) inv_1x
I80\<2\> (nand7 net0105\<0\>) inv_1x
I80\<1\> (nand7 net0105\<1\>) inv_1x
I80\<0\> (nand7 net0105\<2\>) inv_1x
I79\<2\> (nand6 net0106\<0\>) inv_1x
I79\<1\> (nand6 net0106\<1\>) inv_1x
I79\<0\> (nand6 net0106\<2\>) inv_1x
I78\<2\> (nand5 net0107\<0\>) inv_1x
I78\<1\> (nand5 net0107\<1\>) inv_1x
I78\<0\> (nand5 net0107\<2\>) inv_1x
I77\<2\> (nand4 net0108\<0\>) inv_1x
I77\<1\> (nand4 net0108\<1\>) inv_1x
I77\<0\> (nand4 net0108\<2\>) inv_1x
I76\<2\> (nand3 net0109\<0\>) inv_1x
I76\<1\> (nand3 net0109\<1\>) inv_1x
I76\<0\> (nand3 net0109\<2\>) inv_1x
I75\<2\> (nand2 net0110\<0\>) inv_1x
I75\<1\> (nand2 net0110\<1\>) inv_1x
I75\<0\> (nand2 net0110\<2\>) inv_1x
I74\<2\> (nand1 net0111\<0\>) inv_1x
I74\<1\> (nand1 net0111\<1\>) inv_1x
I74\<0\> (nand1 net0111\<2\>) inv_1x
I62 (nC10 nC0) inv_1x
I13\<2\> (inv1 net026\<0\>) inv_1x
I13\<1\> (inv1 net026\<1\>) inv_1x
I13\<0\> (inv1 net026\<2\>) inv_1x
I23\<2\> (inv0 net016\<0\>) inv_1x
I23\<1\> (inv0 net016\<1\>) inv_1x
I23\<0\> (inv0 net016\<2\>) inv_1x
I22\<2\> (inv10 net017\<0\>) inv_1x
I22\<1\> (inv10 net017\<1\>) inv_1x
I22\<0\> (inv10 net017\<2\>) inv_1x
I21\<2\> (inv9 net018\<0\>) inv_1x
I21\<1\> (inv9 net018\<1\>) inv_1x
I21\<0\> (inv9 net018\<2\>) inv_1x
I20\<2\> (inv8 net019\<0\>) inv_1x
I20\<1\> (inv8 net019\<1\>) inv_1x
I20\<0\> (inv8 net019\<2\>) inv_1x
I19\<2\> (inv7 net020\<0\>) inv_1x
I19\<1\> (inv7 net020\<1\>) inv_1x
I19\<0\> (inv7 net020\<2\>) inv_1x
I18\<2\> (inv6 net021\<0\>) inv_1x
I18\<1\> (inv6 net021\<1\>) inv_1x
I18\<0\> (inv6 net021\<2\>) inv_1x
I17\<2\> (inv5 net022\<0\>) inv_1x
I17\<1\> (inv5 net022\<1\>) inv_1x
I17\<0\> (inv5 net022\<2\>) inv_1x
I16\<2\> (inv4 net023\<0\>) inv_1x
I16\<1\> (inv4 net023\<1\>) inv_1x
I16\<0\> (inv4 net023\<2\>) inv_1x
I15\<2\> (inv3 net024\<0\>) inv_1x
I15\<1\> (inv3 net024\<1\>) inv_1x
I15\<0\> (inv3 net024\<2\>) inv_1x
I14\<2\> (inv2 net025\<0\>) inv_1x
I14\<1\> (inv2 net025\<1\>) inv_1x
I14\<0\> (inv2 net025\<2\>) inv_1x
I12 (inv5 inv6) inv_1x
I11 (inv10 inv0) inv_1x
I10 (inv4 inv5) inv_1x
I9 (inv9 inv10) inv_1x
I8 (inv3 inv4) inv_1x
I7 (inv8 inv9) inv_1x
I4 (inv2 inv3) inv_1x
I3 (inv7 inv8) inv_1x
I2 (inv1 inv2) inv_1x
I1 (inv6 inv7) inv_1x
I0 (inv0 inv1) inv_1x
I28 (no2 no2 nor3) nor_1x
I27 (nor7 nor7 nor8) nor_1x
I26 (nor1 nor1 no2) nor_1x
I25 (not6 not6 nor7) nor_1x
I24 (nor0 nor0 nor1) nor_1x
I29 (nor8 nor8 nor9) nor_1x
I30 (nor3 nor3 nor4) nor_1x
I31 (nor9 nor9 nor10) nor_1x
I32 (nor4 nor4 nor5) nor_1x
I33 (nor10 nor10 nor0) nor_1x
I34 (nor5 nor5 not6) nor_1x
I45 (nand2 nand2 nand3) nand_1x
I44 (nand7 nand7 nand8) nand_1x
I43 (nand1 nand1 nand2) nand_1x
I42 (nand6 nand6 nand7) nand_1x
I41 (nand0 nand0 nand1) nand_1x
I40 (nand8 nand8 nand9) nand_1x
I39 (nand3 nand3 nand4) nand_1x
I35 (nand5 nand5 nand6) nand_1x
I36 (nand10 nand10 nand0) nand_1x
I37 (nand4 nand4 nand5) nand_1x
I38 (nand9 nand9 nand10) nand_1x
I56 (nC2 nC2 nC3) TH22
I55 (nC6 nC6 nC7) TH22
I54 (nC1 nC1 nC2) TH22
I53 (nC5 nC5 nC6) TH22
I52 (nC0 nC0 nC1) TH22
I51 (nC7 nC7 nC8) TH22
I50 (nC3 nC3 nC4) TH22
I48 (nC9 nC9 nC10) TH22
I47 (nC4 nC4 nC5) TH22
I46 (nC8 nC8 nC9) TH22
I63 (net08 net08 net03) SG_nand_1x
I73 (net010 net010 net078) SG_nand_1x
I72 (net05 net05 net010) SG_nand_1x
I71 (SG_0 SG_0 net05) SG_nand_1x
I70 (net078 net078 net076) SG_nand_1x
I69 (net076 net076 net032) SG_nand_1x
I68 (net032 net032 net029) SG_nand_1x
I67 (net077 net077 net014) SG_nand_1x
I66 (net029 net029 net077) SG_nand_1x
I65 (net014 net014 net08) SG_nand_1x
I64 (net03 net03 SG_0) SG_nand_1x
ic net014=0 net029=0 net076=0 net010=0 SG_0=0 nC10=vdd nC0=0 nand8=0 nand6=0 nand4=0 nand2=0 nand0=0 nor8=0 not6=0 nor4=0 no2=0 nor0=0 inv8=0 inv6=0 inv4=0 inv2=0 inv0=0
simulatorOptions options temp=27
tran tran stop=500p errpreset=conservative
save inv0 nand0 nor0 nC0 SG_0
