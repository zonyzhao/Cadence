// Verilog-AMS cds_globals module for top-level cell:
//    16nm_Tests/MC_6TWrite_Test.
// Generated by ADE.
// Cadence Design Systems, Inc.

// This is an autoGenerated file, any changes done to this file may get lost.

`include "disciplines.vams"
`include "userDisciplines.vams"

module cds_globals;

// Global Signals
   wire \vdd! ;
   electrical \gnd! ;
   ground \gnd! ;
   wire \vcc! ;

// Design Variables
   dynamicparam real vdd = 0.500;

endmodule
