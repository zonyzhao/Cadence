simulator( 'spectre )
design(	 "/net/kafka/nfs/rstdenis/Cadence/simulation/MCsetup_Test/spectre/schematic/netlist/netlist")
resultsDir( "/net/kafka/nfs/rstdenis/Cadence/simulation/MCsetup_Test/spectre/schematic" )
modelFile(
    '("/root/Desktop/Cadence/ncsu-FreePDK15/hspice_16nm_hp.include" "")
    '("/root/Desktop/Cadence/ncsu-FreePDK15/PTM-MG/stats.scs" "")
)
analysis('tran ?stop "12n"  ?errpreset "conservative"  )
desVar(	  "vdd" ".500\\"	)
desVar(	  "time2" 5n	)
envOption(
	'cmd64bit  t
	'analysisOrder  list("tran")
)
option(	'multithread  "on"
	'temp  "30.0"
)
save( 'i "/V0/MINUS" )
temp( 30.0 )
run()
selectResult( 'tran )
plot(getData("/V0/MINUS") )
modelFile(
    '("/root/Desktop/Cadence/ncsu-FreePDK15/hspice_16nm_hp.include" "")
    '("/root/Desktop/Cadence/ncsu-FreePDK15/PTM-MG/stats.scs" "")
)
run()
selectResult( 'tran )
plot(getData("/V0/MINUS") )
modelFile(
    '("/root/Desktop/Cadence/ncsu-FreePDK15/hspice_16nm_hp.include" "")
    '("/root/Desktop/Cadence/ncsu-FreePDK15/PTM-MG/stats.scs" "")
)
run()
selectResult( 'tran )
plot(getData("/V0/MINUS") )
modelFile(
    '("/root/Desktop/Cadence/ncsu-FreePDK15/hspice_16nm_hp.include" "")
    '("/root/Desktop/Cadence/ncsu-FreePDK15/PTM-MG/stats.scs" "")
)
run()
selectResult( 'tran )
plot(getData("/V0/MINUS") )
modelFile(
    '("/root/Desktop/Cadence/ncsu-FreePDK15/hspice_16nm_lstp.include" "")
    '("/root/Desktop/Cadence/ncsu-FreePDK15/PTM-MG/stats.scs" "")
)
run()
selectResult( 'tran )
plot(getData("/V0/MINUS") )
modelFile(
    '("/root/Desktop/Cadence/ncsu-FreePDK15/hspice_16nm_hp.include" "")
    '("/root/Desktop/Cadence/ncsu-FreePDK15/PTM-MG/stats.scs" "")
)
desVar(	  "vdd" .500	)
run()
selectResult( 'tran )
plot(getData("/V0/MINUS") )
modelFile(
    '("/root/Desktop/Cadence/ncsu-FreePDK15/hspice_16nm_hp.include" "")
    '("/root/Desktop/Cadence/ncsu-FreePDK15/PTM-MG/stats.scs" "")
)
run()
selectResult( 'tran )
plot(getData("/Y") getData("/V0/MINUS") )
plot( pv("I0.M0.mnfet" "vth" ?result "tranOp") )
plot( pv("I0.M1.mpfet" "vth" ?result "tranOp") )
modelFile(
    '("/root/Desktop/Cadence/ncsu-FreePDK15/hspice_16nm_hp.include" "")
    '("/root/Desktop/Cadence/ncsu-FreePDK15/PTM-MG/stats.scs" "")
)
save( 'v "/Y" )
run()
selectResult( 'tran )
plot(getData("/V0/MINUS") getData("/Y") )
plot( pv("I0.M0.mnfet" "vth" ?result "tranOp") )
plot( pv("I0.M1.mpfet" "vth" ?result "tranOp") )
modelFile(
    '("/root/Desktop/Cadence/ncsu-FreePDK15/hspice_16nm_hp.include" "")
    '("/root/Desktop/Cadence/ncsu-FreePDK15/PTM-MG/stats.scs" "")
)
run()
selectResult( 'tran )
plot(getData("/V0/MINUS") getData("/Y") )
plot( pv("I0.M0.mnfet" "vth" ?result "tranOp") )
plot( pv("I0.M1.mpfet" "vth" ?result "tranOp") )
modelFile(
    '("/root/Desktop/Cadence/ncsu-FreePDK15/hspice_16nm_hp.include" "")
    '("/root/Desktop/Cadence/ncsu-FreePDK15/PTM-MG/stats.scs" "")
)
run()
selectResult( 'tran )
plot(getData("/V0/MINUS") getData("/Y") )
plot( pv("I0.M0.mnfet" "vth" ?result "tranOp") )
plot( pv("I0.M1.mpfet" "vth" ?result "tranOp") )
modelFile(
    '("/root/Desktop/Cadence/ncsu-FreePDK15/hspice_16nm_hp.include" "")
    '("/root/Desktop/Cadence/ncsu-FreePDK15/PTM-MG/stats.scs" "")
)
run()
selectResult( 'tran )
plot(getData("/V0/MINUS") getData("/Y") )
plot( pv("I0.M0.mnfet" "vth" ?result "tranOp") )
plot( pv("I0.M1.mpfet" "vth" ?result "tranOp") )
modelFile(
    '("/root/Desktop/Cadence/ncsu-FreePDK15/hspice_16nm_hp.include" "")
    '("/root/Desktop/Cadence/ncsu-FreePDK15/PTM-MG/stats.scs" "")
)
run()
selectResult( 'tran )
plot(getData("/V0/MINUS") getData("/Y") )
plot( pv("I0.M0.mnfet" "vth" ?result "tranOp") )
plot( pv("I0.M1.mpfet" "vth" ?result "tranOp") )
modelFile(
    '("/root/Desktop/Cadence/ncsu-FreePDK15/hspice_16nm_hp.include" "")
    '("/root/Desktop/Cadence/ncsu-FreePDK15/PTM-MG/stats.scs" "")
)
run()
selectResult( 'tran )
plot(getData("/V0/MINUS") getData("/Y") )
plot( pv("I0.M0.mnfet" "vth" ?result "tranOp") )
plot( pv("I0.M1.mpfet" "vth" ?result "tranOp") )
