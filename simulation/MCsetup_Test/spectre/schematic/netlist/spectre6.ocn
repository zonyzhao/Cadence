simulator( 'spectre )
design(	 "/net/kafka/nfs/rstdenis/Cadence/simulation/MCsetup_Test/spectre/schematic/netlist/netlist")
resultsDir( "/net/kafka/nfs/rstdenis/Cadence/simulation/MCsetup_Test/spectre/schematic" )
modelFile(
    '("/root/Desktop/Cadence/ncsu-FreePDK15/hspice_16nm_hp.include" "")
)
analysis('tran ?stop "12n"  ?errpreset "conservative"  )
desVar(	  "vdd" .500	)
desVar(	  "time2" 5n	)
envOption(
	'cmd64bit  t
	'userCmdLineOption  "+spice"
	'analysisOrder  list("tran")
)
option(	'multithread  "on"
	'temp  "30.0"
)
save( 'v "/Y" )
save( 'i "/V0/MINUS" )
temp( 30.0 )
run()
selectResult( 'tran )
plot(getData("/V0/MINUS") getData("/Y") )
plot( OP("/I0/M1" "vth") )
plot( OP("/I0/M0" "vth") )
modelFile(
    '("/root/Desktop/Cadence/ncsu-FreePDK15/hspice_16nm_hp.include" "")
)
run()
selectResult( 'tran )
plot(getData("/V0/MINUS") getData("/Y") )
plot( OP("/I0/M1" "vth") )
plot( OP("/I0/M0" "vth") )
