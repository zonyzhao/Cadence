simulator( 'ams )
design(	 "/net/kafka/nfs/rstdenis/Cadence/simulation/MC_6TWrite_Test/ams/ams_config/netlist/netlist")
resultsDir( "/net/kafka/nfs/rstdenis/Cadence/simulation/MC_6TWrite_Test/ams/ams_config" )
modelFile(
    '("/root/Desktop/Cadence/ncsu-FreePDK15/PTM-MG/smodels.scs" "")
)
analysis('tran ?stop "4n"  ?errpreset "conservative"  ?write ""
		?writefinal ""  )
desVar(	  "vdd" 0.500	)
envOption(
	'netlisterMode  "OSS-based"
	'invocationStyle  "irun"
	'solver  "UltraSim"
	'cmd64bit  t
)
option( ?categ 'elaborator
	'unitsSimPrecision  "ps"
	'unitsSimTime  "ps"
)
saveOption( ?outputParamInfo nil )
saveOption( ?elementInfo nil )
saveOption( ?modelParamInfo nil )
save( 'v "/Aline<0>" "/ValAddr" "/Ack" "/S<0>" "/A<16>" "/B1<0>" "/B0<0>" "/W1<0>" "/W0<0>" "/RW<0>" "/ICHUNK/IARRAY0/ISRAM0/I7/I3/Q0" "/ICHUNK/IARRAY0/ISRAM0/I7/I3/Q1" "/ICHUNK/IARRAY0/B1P1" "/ICHUNK/IARRAY0/B0P1" )
converge( 'ic "/ICHUNK/IARRAY0/ISRAM0/I7/I3/Q1" "0" )
converge( 'ic "/ICHUNK/IARRAY0/ISRAM0/I7/I3/Q0" "vdd" )
converge( 'ic "/A<0>" "0" )
converge( 'ic "/A<1>" "0" )
converge( 'ic "/A<2>" "0" )
converge( 'ic "/A<3>" "0" )
converge( 'ic "/A<8>" "0" )
converge( 'ic "/A<9>" "0" )
converge( 'ic "/A<10>" "0" )
converge( 'ic "/A<11>" "0" )
converge( 'ic "/A<4>" "0" )
converge( 'ic "/A<5>" "0" )
converge( 'ic "/A<6>" "0" )
converge( 'ic "/A<7>" "0" )
converge( 'ic "/A<12>" "0" )
converge( 'ic "/A<13>" "0" )
converge( 'ic "/A<14>" "0" )
converge( 'ic "/A<15>" "0" )
converge( 'ic "/A<16>" "0" )
converge( 'ic "/Aline<0>" "0" )
converge( 'ic "/Aline<1>" "0" )
converge( 'ic "/Aline<2>" "0" )
converge( 'ic "/Aline<3>" "0" )
converge( 'ic "/Aline<4>" "0" )
converge( 'ic "/Aline<5>" "0" )
converge( 'ic "/Aline<6>" "0" )
converge( 'ic "/Aline<7>" "0" )
converge( 'ic "/Aline<8>" "0" )
converge( 'ic "/Aline<9>" "0" )
converge( 'ic "/Aline<10>" "0" )
converge( 'ic "/Aline<11>" "0" )
converge( 'ic "/Aline<12>" "0" )
converge( 'ic "/Aline<13>" "0" )
converge( 'ic "/Aline<14>" "0" )
converge( 'ic "/Aline<15>" "0" )
converge( 'ic "/Aline<16>" "0" )
converge( 'ic "/Aline<17>" "0" )
converge( 'ic "/Aline<18>" "0" )
converge( 'ic "/Aline<19>" "0" )
converge( 'ic "/Aline<20>" "0" )
converge( 'ic "/Aline<21>" "0" )
converge( 'ic "/Aline<22>" "0" )
converge( 'ic "/Aline<23>" "0" )
converge( 'ic "/Aline<24>" "0" )
converge( 'ic "/Aline<25>" "0" )
converge( 'ic "/Aline<26>" "0" )
converge( 'ic "/Aline<27>" "0" )
converge( 'ic "/Aline<28>" "0" )
converge( 'ic "/Aline<29>" "0" )
converge( 'ic "/Aline<30>" "0" )
converge( 'ic "/Aline<31>" "0" )
converge( 'ic "/Aline<32>" "0" )
converge( 'ic "/Aline<33>" "0" )
converge( 'ic "/Aline<34>" "0" )
converge( 'ic "/Aline<35>" "0" )
converge( 'ic "/Aline<36>" "0" )
converge( 'ic "/Aline<37>" "0" )
converge( 'ic "/Aline<38>" "0" )
converge( 'ic "/Aline<39>" "0" )
converge( 'ic "/Aline<40>" "0" )
converge( 'ic "/Aline<41>" "0" )
converge( 'ic "/Aline<42>" "0" )
converge( 'ic "/Aline<43>" "0" )
converge( 'ic "/Aline<44>" "0" )
converge( 'ic "/Aline<45>" "0" )
converge( 'ic "/Aline<46>" "0" )
converge( 'ic "/Aline<47>" "0" )
converge( 'ic "/Aline<48>" "0" )
converge( 'ic "/Aline<49>" "0" )
converge( 'ic "/Aline<50>" "0" )
converge( 'ic "/Aline<51>" "0" )
converge( 'ic "/Aline<52>" "0" )
converge( 'ic "/Aline<53>" "0" )
converge( 'ic "/Aline<54>" "0" )
converge( 'ic "/Aline<55>" "0" )
converge( 'ic "/Aline<56>" "0" )
converge( 'ic "/Aline<57>" "0" )
converge( 'ic "/Aline<58>" "0" )
converge( 'ic "/Aline<59>" "0" )
converge( 'ic "/Aline<60>" "0" )
converge( 'ic "/Aline<61>" "0" )
converge( 'ic "/Aline<62>" "0" )
converge( 'ic "/Aline<63>" "0" )
converge( 'ic "/S<0>" "0" )
converge( 'ic "/S<1>" "0" )
converge( 'ic "/S<2>" "0" )
converge( 'ic "/S<3>" "0" )
converge( 'ic "/S<4>" "0" )
converge( 'ic "/S<5>" "0" )
converge( 'ic "/S<6>" "0" )
converge( 'ic "/S<7>" "0" )
converge( 'ic "/Ack" "0" )
converge( 'ic "/ValAddr" "0" )
converge( 'ic "/RDataAck<0>" "0" )
converge( 'ic "/RDataAck<1>" "0" )
converge( 'ic "/R2<0>" "0" )
converge( 'ic "/R2<1>" "0" )
converge( 'ic "/R2<2>" "0" )
converge( 'ic "/R2<3>" "0" )
converge( 'ic "/R1<0>" "0" )
converge( 'ic "/R1<1>" "0" )
converge( 'ic "/R1<2>" "0" )
converge( 'ic "/R1<3>" "0" )
converge( 'ic "/WdataAck<0>" "0" )
converge( 'ic "/WdataAck<1>" "0" )
converge( 'ic "/WD2<0>" "0" )
converge( 'ic "/WD2<1>" "0" )
converge( 'ic "/WD2<2>" "0" )
converge( 'ic "/WD2<3>" "0" )
converge( 'ic "/WD1<0>" "0" )
converge( 'ic "/WD1<1>" "0" )
converge( 'ic "/WD1<2>" "0" )
converge( 'ic "/WD1<3>" "0" )
converge( 'ic "/RW<0>" "0" )
converge( 'ic "/RW<1>" "0" )
converge( 'ic "/Go" "0" )
converge( 'ic "/W0<0>" "0" )
converge( 'ic "/W0<1>" "0" )
converge( 'ic "/W0<2>" "0" )
converge( 'ic "/W0<3>" "0" )
converge( 'ic "/W1<0>" "0" )
converge( 'ic "/W1<1>" "0" )
converge( 'ic "/W1<2>" "0" )
converge( 'ic "/W1<3>" "0" )
converge( 'ic "/B0<0>" "0" )
converge( 'ic "/B0<1>" "0" )
converge( 'ic "/B0<2>" "0" )
converge( 'ic "/B0<3>" "0" )
converge( 'ic "/B1<0>" "0" )
converge( 'ic "/B1<1>" "0" )
converge( 'ic "/B1<2>" "0" )
converge( 'ic "/B1<3>" "0" )
temp( 27 )
run()
selectResult( 'tran )
plot(getData("/Aline<0>") getData("/ValAddr") getData("/Ack") getData("/S<0>") getData("/A<16>") getData("/B1<0>") getData("/B0<0>") getData("/W1<0>") getData("/W0<0>") getData("/RW<0>") getData("/ICHUNK/IARRAY0/ISRAM0/I7/I3/Q0") getData("/ICHUNK/IARRAY0/ISRAM0/I7/I3/Q1") getData("/ICHUNK/IARRAY0/B1P1") getData("/ICHUNK/IARRAY0/B0P1") )
modelFile(
    '("/root/Desktop/Cadence/ncsu-FreePDK15/PTM-MG/smodels.scs" "")
)
run()
selectResult( 'tran )
plot(getData("/Aline<0>") getData("/ValAddr") getData("/Ack") getData("/S<0>") getData("/A<16>") getData("/B1<0>") getData("/B0<0>") getData("/W1<0>") getData("/W0<0>") getData("/RW<0>") getData("/ICHUNK/IARRAY0/ISRAM0/I7/I3/Q0") getData("/ICHUNK/IARRAY0/ISRAM0/I7/I3/Q1") getData("/ICHUNK/IARRAY0/B1P1") getData("/ICHUNK/IARRAY0/B0P1") )
plot( OP("/ICHUNK/IARRAY0/ISRAM0/I7/I3/M0" "vth") )
plot( OP("/ICHUNK/IARRAY0/ISRAM0/I7/I3/M1" "vth") )
plot( OP("/ICHUNK/IARRAY0/ISRAM0/I7/I3/M2" "vth") )
plot( OP("/ICHUNK/IARRAY0/ISRAM0/I7/I3/M3" "vth") )
plot( OP("/ICHUNK/IARRAY0/ISRAM0/I7/I3/M4" "vth") )
plot( OP("/ICHUNK/IARRAY0/ISRAM0/I7/I3/M5" "vth") )
passfail = xval(intersect(VT("/ICHUNK/IARRAY0/ISRAM0/I7/I3/Q1") VT("/ICHUNK/IARRAY0/ISRAM0/I7/I3/Q0")))
plot( passfail ?expr '( "passfail" ) )
modelFile(
    '("/root/Desktop/Cadence/ncsu-FreePDK15/PTM-MG/smodels.scs" "")
)
run()
selectResult( 'tran )
plot(getData("/Aline<0>") getData("/ValAddr") getData("/Ack") getData("/S<0>") getData("/A<16>") getData("/B1<0>") getData("/B0<0>") getData("/W1<0>") getData("/W0<0>") getData("/RW<0>") getData("/ICHUNK/IARRAY0/ISRAM0/I7/I3/Q0") getData("/ICHUNK/IARRAY0/ISRAM0/I7/I3/Q1") getData("/ICHUNK/IARRAY0/B1P1") getData("/ICHUNK/IARRAY0/B0P1") )
plot( OP("/ICHUNK/IARRAY0/ISRAM0/I7/I3/M0" "vth") )
plot( OP("/ICHUNK/IARRAY0/ISRAM0/I7/I3/M1" "vth") )
plot( OP("/ICHUNK/IARRAY0/ISRAM0/I7/I3/M2" "vth") )
plot( OP("/ICHUNK/IARRAY0/ISRAM0/I7/I3/M3" "vth") )
plot( OP("/ICHUNK/IARRAY0/ISRAM0/I7/I3/M4" "vth") )
plot( OP("/ICHUNK/IARRAY0/ISRAM0/I7/I3/M5" "vth") )
passfail = value(xval(intersect(VT("/ICHUNK/IARRAY0/ISRAM0/I7/I3/Q1") VT("/ICHUNK/IARRAY0/ISRAM0/I7/I3/Q0"))) 1)
plot( passfail ?expr '( "passfail" ) )
