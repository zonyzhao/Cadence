simulator( 'ams )
design(	 "/net/kafka/nfs/rstdenis/Cadence/simulation/MC_6TWrite_Test/ams/ams_config/netlist/netlist")
resultsDir( "/net/kafka/nfs/rstdenis/Cadence/simulation/MC_6TWrite_Test/ams/ams_config" )
modelFile(
    '("/root/Desktop/Cadence/ncsu-FreePDK15/PTM-MG/smodels.scs" "")
)
analysis('tran ?stop "4n"  ?errpreset "conservative"  )
desVar(	  "vdd" 0.500	)
desVar(	  "time5" 3n	)
desVar(	  "time4" 2.85n	)
desVar(	  "time3" 2.22n	)
desVar(	  "time2" 2n	)
envOption(
	'netlisterMode  "OSS-based"
	'invocationStyle  "irun"
)
save( 'v "/Aline<0>" "/S<0>" "/W1_1<3>" "/W1_1<2>" "/W1_1<1>" "/W1_1<0>" "/B1_1<3>" "/B1_1<2>" "/B1_1<1>" "/B1_1<0>" "/ICHUNK/IARRAY0/ISRAM0/I7/I3/Q1" "/ICHUNK/IARRAY0/ISRAM0/I7/I3/Q0" "/ICHUNK/IARRAY0/B1P1" "/ICHUNK/IARRAY0/B0P1" )
temp( 27 )
run()
selectResult( 'tran )
plot(getData("/Aline<0>") getData("/S<0>") getData("/W1_1<3>") getData("/W1_1<2>") getData("/W1_1<1>") getData("/W1_1<0>") getData("/B1_1<3>") getData("/B1_1<2>") getData("/B1_1<1>") getData("/B1_1<0>") getData("/ICHUNK/IARRAY0/ISRAM0/I7/I3/Q1") getData("/ICHUNK/IARRAY0/ISRAM0/I7/I3/Q0") getData("/ICHUNK/IARRAY0/B1P1") getData("/ICHUNK/IARRAY0/B0P1") )
modelFile(
    '("/root/Desktop/Cadence/ncsu-FreePDK15/PTM-MG/smodels.scs" "")
)
run()
selectResult( 'tran )
plot(getData("/Aline<0>") getData("/S<0>") getData("/W1_1<3>") getData("/W1_1<2>") getData("/W1_1<1>") getData("/W1_1<0>") getData("/B1_1<3>") getData("/B1_1<2>") getData("/B1_1<1>") getData("/B1_1<0>") getData("/ICHUNK/IARRAY0/ISRAM0/I7/I3/Q1") getData("/ICHUNK/IARRAY0/ISRAM0/I7/I3/Q0") getData("/ICHUNK/IARRAY0/B1P1") getData("/ICHUNK/IARRAY0/B0P1") )
modelFile(
    '("/root/Desktop/Cadence/ncsu-FreePDK15/PTM-MG/smodels.scs" "")
)
run()
selectResult( 'tran )
plot(getData("/Aline<0>") getData("/S<0>") getData("/W1_1<3>") getData("/W1_1<2>") getData("/W1_1<1>") getData("/W1_1<0>") getData("/B1_1<3>") getData("/B1_1<2>") getData("/B1_1<1>") getData("/B1_1<0>") getData("/ICHUNK/IARRAY0/ISRAM0/I7/I3/Q1") getData("/ICHUNK/IARRAY0/ISRAM0/I7/I3/Q0") getData("/ICHUNK/IARRAY0/B1P1") getData("/ICHUNK/IARRAY0/B0P1") )
modelFile(
    '("/root/Desktop/Cadence/ncsu-FreePDK15/PTM-MG/smodels.scs" "")
)
run()
selectResult( 'tran )
plot(getData("/Aline<0>") getData("/S<0>") getData("/W1_1<3>") getData("/W1_1<2>") getData("/W1_1<1>") getData("/W1_1<0>") getData("/B1_1<3>") getData("/B1_1<2>") getData("/B1_1<1>") getData("/B1_1<0>") getData("/ICHUNK/IARRAY0/ISRAM0/I7/I3/Q1") getData("/ICHUNK/IARRAY0/ISRAM0/I7/I3/Q0") getData("/ICHUNK/IARRAY0/B1P1") getData("/ICHUNK/IARRAY0/B0P1") )
modelFile(
    '("/root/Desktop/Cadence/ncsu-FreePDK15/PTM-MG/smodels.scs" "")
)
converge( 'ic "/ICHUNK/IARRAY0/ISRAM0/I7/I3/Q0" "0" )
converge( 'ic "/ICHUNK/IARRAY0/ISRAM0/I7/I3/Q1" "vdd" )
run()
selectResult( 'tran )
plot(getData("/Aline<0>") getData("/S<0>") getData("/W1_1<3>") getData("/W1_1<2>") getData("/W1_1<1>") getData("/W1_1<0>") getData("/B1_1<3>") getData("/B1_1<2>") getData("/B1_1<1>") getData("/B1_1<0>") getData("/ICHUNK/IARRAY0/ISRAM0/I7/I3/Q1") getData("/ICHUNK/IARRAY0/ISRAM0/I7/I3/Q0") getData("/ICHUNK/IARRAY0/B1P1") getData("/ICHUNK/IARRAY0/B0P1") )
modelFile(
    '("/root/Desktop/Cadence/ncsu-FreePDK15/PTM-MG/smodels.scs" "")
)
delete( 'save 'v /Aline<0> /S<0> /W1_1<3> /W1_1<2> /W1_1<1> /W1_1<0> /B1_1<3> /B1_1<2> /B1_1<1> /B1_1<0> )
run()
selectResult( 'tran )
plot(getData("/ICHUNK/IARRAY0/ISRAM0/I7/I3/Q1") getData("/ICHUNK/IARRAY0/ISRAM0/I7/I3/Q0") getData("/ICHUNK/IARRAY0/B1P1") getData("/ICHUNK/IARRAY0/B0P1") )
modelFile(
    '("/root/Desktop/Cadence/ncsu-FreePDK15/PTM-MG/smodels.scs" "")
)
save( 'i "/I84/Go" "/I84/Ack" "/I84/ValAddr" "/I84/Reset" "/I84/AckThruBot" "/I84/AckThruTop" )
run()
selectResult( 'tran )
plot(getData("/ICHUNK/IARRAY0/ISRAM0/I7/I3/Q1") getData("/ICHUNK/IARRAY0/ISRAM0/I7/I3/Q0") getData("/ICHUNK/IARRAY0/B1P1") getData("/ICHUNK/IARRAY0/B0P1") getData("/I84/Go") getData("/I84/Ack") getData("/I84/ValAddr") getData("/I84/Reset") getData("/I84/AckThruBot") getData("/I84/AckThruTop") )
modelFile(
    '("/root/Desktop/Cadence/ncsu-FreePDK15/PTM-MG/smodels.scs" "")
)
run()
selectResult( 'tran )
plot(getData("/ICHUNK/IARRAY0/ISRAM0/I7/I3/Q1") getData("/ICHUNK/IARRAY0/ISRAM0/I7/I3/Q0") getData("/ICHUNK/IARRAY0/B1P1") getData("/ICHUNK/IARRAY0/B0P1") getData("/I84/Go") getData("/I84/Ack") getData("/I84/ValAddr") getData("/I84/Reset") getData("/I84/AckThruBot") getData("/I84/AckThruTop") )
modelFile(
    '("/root/Desktop/Cadence/ncsu-FreePDK15/PTM-MG/smodels.scs" "")
)
save( 'v "/Aline<0>" "/S<0>" "/A<16>" "/net44" "/WD1<3>" "/WD1<2>" "/WD1<1>" "/WD1<0>" "/WD2<3>" "/WD2<2>" "/WD2<1>" "/WD2<0>" "/R1<3>" "/R1<2>" "/R1<1>" "/R1<0>" "/R2<3>" "/R2<2>" "/R2<1>" "/R2<0>" "/RDataAck<1>" "/RDataAck<0>" "/WdataAck<1>" "/WdataAck<0>" "/ValAddr" )
save( 'i /I84/Go /I84/Ack /I84/ValAddr /I84/Reset /I84/AckThruBot /I84/AckThruTop )
converge( 'ic "/net44" "0" )
converge( 'ic "/A<0>" "0" )
converge( 'ic "/A<1>" "0" )
converge( 'ic "/A<2>" "0" )
converge( 'ic "/A<3>" "0" )
converge( 'ic "/A<4>" "0" )
converge( 'ic "/A<5>" "0" )
converge( 'ic "/A<6>" "0" )
converge( 'ic "/A<7>" "0" )
converge( 'ic "/A<8>" "0" )
converge( 'ic "/A<9>" "0" )
converge( 'ic "/A<10>" "0" )
converge( 'ic "/A<11>" "0" )
converge( 'ic "/A<12>" "0" )
converge( 'ic "/A<13>" "0" )
converge( 'ic "/A<14>" "0" )
converge( 'ic "/A<15>" "0" )
converge( 'ic "/A<16>" "0" )
converge( 'ic "/RW<0>" "0" )
converge( 'ic "/RW<1>" "0" )
converge( 'ic "/RDataAck<0>" "0" )
converge( 'ic "/RDataAck<1>" "0" )
converge( 'ic "/R2<0>" "0" )
converge( 'ic "/R2<1>" "0" )
converge( 'ic "/R2<2>" "0" )
converge( 'ic "/R2<3>" "0" )
converge( 'ic "/R1<0>" "0" )
converge( 'ic "/R1<1>" "0" )
converge( 'ic "/R1<2>" "0" )
converge( 'ic "/R1<3>" "0" )
converge( 'ic "/WdataAck<0>" "0" )
converge( 'ic "/WdataAck<1>" "0" )
converge( 'ic "/net020<3>" "0" )
converge( 'ic "/net020<2>" "0" )
converge( 'ic "/net020<1>" "0" )
converge( 'ic "/net020<0>" "0" )
converge( 'ic "/net021<3>" "0" )
converge( 'ic "/net021<2>" "0" )
converge( 'ic "/net021<1>" "0" )
converge( 'ic "/net021<0>" "0" )
converge( 'ic "/ValAddr" "0" )
converge( 'ic "/net39<7>" "0" )
converge( 'ic "/net39<6>" "0" )
converge( 'ic "/net39<5>" "0" )
converge( 'ic "/net39<4>" "0" )
converge( 'ic "/net39<3>" "0" )
converge( 'ic "/net39<2>" "0" )
converge( 'ic "/net39<1>" "0" )
converge( 'ic "/net39<0>" "0" )
converge( 'ic "/net38<63>" "0" )
converge( 'ic "/net38<62>" "0" )
converge( 'ic "/net38<61>" "0" )
converge( 'ic "/net38<60>" "0" )
converge( 'ic "/net38<59>" "0" )
converge( 'ic "/net38<58>" "0" )
converge( 'ic "/net38<57>" "0" )
converge( 'ic "/net38<56>" "0" )
converge( 'ic "/net38<55>" "0" )
converge( 'ic "/net38<54>" "0" )
converge( 'ic "/net38<53>" "0" )
converge( 'ic "/net38<52>" "0" )
converge( 'ic "/net38<51>" "0" )
converge( 'ic "/net38<50>" "0" )
converge( 'ic "/net38<49>" "0" )
converge( 'ic "/net38<48>" "0" )
converge( 'ic "/net38<47>" "0" )
converge( 'ic "/net38<46>" "0" )
converge( 'ic "/net38<45>" "0" )
converge( 'ic "/net38<44>" "0" )
converge( 'ic "/net38<43>" "0" )
converge( 'ic "/net38<42>" "0" )
converge( 'ic "/net38<41>" "0" )
converge( 'ic "/net38<40>" "0" )
converge( 'ic "/net38<39>" "0" )
converge( 'ic "/net38<38>" "0" )
converge( 'ic "/net38<37>" "0" )
converge( 'ic "/net38<36>" "0" )
converge( 'ic "/net38<35>" "0" )
converge( 'ic "/net38<34>" "0" )
converge( 'ic "/net38<33>" "0" )
converge( 'ic "/net38<32>" "0" )
converge( 'ic "/net38<31>" "0" )
converge( 'ic "/net38<30>" "0" )
converge( 'ic "/net38<29>" "0" )
converge( 'ic "/net38<28>" "0" )
converge( 'ic "/net38<27>" "0" )
converge( 'ic "/net38<26>" "0" )
converge( 'ic "/net38<25>" "0" )
converge( 'ic "/net38<24>" "0" )
converge( 'ic "/net38<23>" "0" )
converge( 'ic "/net38<22>" "0" )
converge( 'ic "/net38<21>" "0" )
converge( 'ic "/net38<20>" "0" )
converge( 'ic "/net38<19>" "0" )
converge( 'ic "/net38<18>" "0" )
converge( 'ic "/net38<17>" "0" )
converge( 'ic "/net38<16>" "0" )
converge( 'ic "/net38<15>" "0" )
converge( 'ic "/net38<14>" "0" )
converge( 'ic "/net38<13>" "0" )
converge( 'ic "/net38<12>" "0" )
converge( 'ic "/net38<11>" "0" )
converge( 'ic "/net38<10>" "0" )
converge( 'ic "/net38<9>" "0" )
converge( 'ic "/net38<8>" "0" )
converge( 'ic "/net38<7>" "0" )
converge( 'ic "/net38<6>" "0" )
converge( 'ic "/net38<5>" "0" )
converge( 'ic "/net38<4>" "0" )
converge( 'ic "/net38<3>" "0" )
converge( 'ic "/net38<2>" "0" )
converge( 'ic "/net38<1>" "0" )
converge( 'ic "/net38<0>" "0" )
run()
selectResult( 'tran )
plot(getData("/ICHUNK/IARRAY0/ISRAM0/I7/I3/Q1") getData("/ICHUNK/IARRAY0/ISRAM0/I7/I3/Q0") getData("/ICHUNK/IARRAY0/B1P1") getData("/ICHUNK/IARRAY0/B0P1") getData("/Aline<0>") getData("/S<0>") getData("/A<16>") getData("/net44") getData("/WD1<3>") getData("/WD1<2>") getData("/WD1<1>") getData("/WD1<0>") getData("/WD2<3>") getData("/WD2<2>") getData("/WD2<1>") getData("/WD2<0>") getData("/R1<3>") getData("/R1<2>") getData("/R1<1>") getData("/R1<0>") getData("/R2<3>") getData("/R2<2>") getData("/R2<1>") getData("/R2<0>") getData("/RDataAck<1>") getData("/RDataAck<0>") getData("/WdataAck<1>") getData("/WdataAck<0>") getData("/ValAddr") )
modelFile(
    '("/root/Desktop/Cadence/ncsu-FreePDK15/PTM-MG/smodels.scs" "")
)
delete( 'converge 'ic "/net44" )
delete( 'converge 'ic "/A<0>" )
delete( 'converge 'ic "/A<1>" )
delete( 'converge 'ic "/A<2>" )
delete( 'converge 'ic "/A<3>" )
delete( 'converge 'ic "/A<4>" )
delete( 'converge 'ic "/A<5>" )
delete( 'converge 'ic "/A<6>" )
delete( 'converge 'ic "/A<7>" )
delete( 'converge 'ic "/A<8>" )
delete( 'converge 'ic "/A<9>" )
delete( 'converge 'ic "/A<10>" )
delete( 'converge 'ic "/A<11>" )
delete( 'converge 'ic "/A<12>" )
delete( 'converge 'ic "/A<13>" )
delete( 'converge 'ic "/A<14>" )
delete( 'converge 'ic "/A<15>" )
delete( 'converge 'ic "/A<16>" )
delete( 'converge 'ic "/RW<0>" )
delete( 'converge 'ic "/RW<1>" )
delete( 'converge 'ic "/RDataAck<0>" )
delete( 'converge 'ic "/RDataAck<1>" )
delete( 'converge 'ic "/R2<0>" )
delete( 'converge 'ic "/R2<1>" )
delete( 'converge 'ic "/R2<2>" )
delete( 'converge 'ic "/R2<3>" )
delete( 'converge 'ic "/R1<0>" )
delete( 'converge 'ic "/R1<1>" )
delete( 'converge 'ic "/R1<2>" )
delete( 'converge 'ic "/R1<3>" )
delete( 'converge 'ic "/WdataAck<0>" )
delete( 'converge 'ic "/WdataAck<1>" )
delete( 'converge 'ic "/net020<3>" )
delete( 'converge 'ic "/net020<2>" )
delete( 'converge 'ic "/net020<1>" )
delete( 'converge 'ic "/net020<0>" )
delete( 'converge 'ic "/net021<3>" )
delete( 'converge 'ic "/net021<2>" )
delete( 'converge 'ic "/net021<1>" )
delete( 'converge 'ic "/net021<0>" )
delete( 'converge 'ic "/ValAddr" )
delete( 'converge 'ic "/net39<7>" )
delete( 'converge 'ic "/net39<6>" )
delete( 'converge 'ic "/net39<5>" )
delete( 'converge 'ic "/net39<4>" )
delete( 'converge 'ic "/net39<3>" )
delete( 'converge 'ic "/net39<2>" )
delete( 'converge 'ic "/net39<1>" )
delete( 'converge 'ic "/net39<0>" )
delete( 'converge 'ic "/net38<63>" )
delete( 'converge 'ic "/net38<62>" )
delete( 'converge 'ic "/net38<61>" )
delete( 'converge 'ic "/net38<60>" )
delete( 'converge 'ic "/net38<59>" )
delete( 'converge 'ic "/net38<58>" )
delete( 'converge 'ic "/net38<57>" )
delete( 'converge 'ic "/net38<56>" )
delete( 'converge 'ic "/net38<55>" )
delete( 'converge 'ic "/net38<54>" )
delete( 'converge 'ic "/net38<53>" )
delete( 'converge 'ic "/net38<52>" )
delete( 'converge 'ic "/net38<51>" )
delete( 'converge 'ic "/net38<50>" )
delete( 'converge 'ic "/net38<49>" )
delete( 'converge 'ic "/net38<48>" )
delete( 'converge 'ic "/net38<47>" )
delete( 'converge 'ic "/net38<46>" )
delete( 'converge 'ic "/net38<45>" )
delete( 'converge 'ic "/net38<44>" )
delete( 'converge 'ic "/net38<43>" )
delete( 'converge 'ic "/net38<42>" )
delete( 'converge 'ic "/net38<41>" )
delete( 'converge 'ic "/net38<40>" )
delete( 'converge 'ic "/net38<39>" )
delete( 'converge 'ic "/net38<38>" )
delete( 'converge 'ic "/net38<37>" )
delete( 'converge 'ic "/net38<36>" )
delete( 'converge 'ic "/net38<35>" )
delete( 'converge 'ic "/net38<34>" )
delete( 'converge 'ic "/net38<33>" )
delete( 'converge 'ic "/net38<32>" )
delete( 'converge 'ic "/net38<31>" )
delete( 'converge 'ic "/net38<30>" )
delete( 'converge 'ic "/net38<29>" )
delete( 'converge 'ic "/net38<28>" )
delete( 'converge 'ic "/net38<27>" )
delete( 'converge 'ic "/net38<26>" )
delete( 'converge 'ic "/net38<25>" )
delete( 'converge 'ic "/net38<24>" )
delete( 'converge 'ic "/net38<23>" )
delete( 'converge 'ic "/net38<22>" )
delete( 'converge 'ic "/net38<21>" )
delete( 'converge 'ic "/net38<20>" )
delete( 'converge 'ic "/net38<19>" )
delete( 'converge 'ic "/net38<18>" )
delete( 'converge 'ic "/net38<17>" )
delete( 'converge 'ic "/net38<16>" )
delete( 'converge 'ic "/net38<15>" )
delete( 'converge 'ic "/net38<14>" )
delete( 'converge 'ic "/net38<13>" )
delete( 'converge 'ic "/net38<12>" )
delete( 'converge 'ic "/net38<11>" )
delete( 'converge 'ic "/net38<10>" )
delete( 'converge 'ic "/net38<9>" )
delete( 'converge 'ic "/net38<8>" )
delete( 'converge 'ic "/net38<7>" )
delete( 'converge 'ic "/net38<6>" )
delete( 'converge 'ic "/net38<5>" )
delete( 'converge 'ic "/net38<4>" )
delete( 'converge 'ic "/net38<3>" )
delete( 'converge 'ic "/net38<2>" )
delete( 'converge 'ic "/net38<1>" )
delete( 'converge 'ic "/net38<0>" )
run()
selectResult( 'tran )
plot(getData("/ICHUNK/IARRAY0/ISRAM0/I7/I3/Q1") getData("/ICHUNK/IARRAY0/ISRAM0/I7/I3/Q0") getData("/ICHUNK/IARRAY0/B1P1") getData("/ICHUNK/IARRAY0/B0P1") getData("/Aline<0>") getData("/S<0>") getData("/A<16>") getData("/net44") getData("/WD1<3>") getData("/WD1<2>") getData("/WD1<1>") getData("/WD1<0>") getData("/WD2<3>") getData("/WD2<2>") getData("/WD2<1>") getData("/WD2<0>") getData("/R1<3>") getData("/R1<2>") getData("/R1<1>") getData("/R1<0>") getData("/R2<3>") getData("/R2<2>") getData("/R2<1>") getData("/R2<0>") getData("/RDataAck<1>") getData("/RDataAck<0>") getData("/WdataAck<1>") getData("/WdataAck<0>") getData("/ValAddr") )
modelFile(
    '("/root/Desktop/Cadence/ncsu-FreePDK15/PTM-MG/smodels.scs" "")
)
option( ?categ 'elaborator
	'unitsSimPrecision  "ps"
	'unitsSimTime  "ps"
)
run()
selectResult( 'tran )
plot(getData("/ICHUNK/IARRAY0/ISRAM0/I7/I3/Q1") getData("/ICHUNK/IARRAY0/ISRAM0/I7/I3/Q0") getData("/ICHUNK/IARRAY0/B1P1") getData("/ICHUNK/IARRAY0/B0P1") getData("/Aline<0>") getData("/S<0>") getData("/A<16>") getData("/net44") getData("/WD1<3>") getData("/WD1<2>") getData("/WD1<1>") getData("/WD1<0>") getData("/WD2<3>") getData("/WD2<2>") getData("/WD2<1>") getData("/WD2<0>") getData("/R1<3>") getData("/R1<2>") getData("/R1<1>") getData("/R1<0>") getData("/R2<3>") getData("/R2<2>") getData("/R2<1>") getData("/R2<0>") getData("/RDataAck<1>") getData("/RDataAck<0>") getData("/WdataAck<1>") getData("/WdataAck<0>") getData("/ValAddr") )
modelFile(
    '("/root/Desktop/Cadence/ncsu-FreePDK15/PTM-MG/smodels.scs" "")
)
run()
selectResult( 'tran )
plot(getData("/ICHUNK/IARRAY0/ISRAM0/I7/I3/Q1") getData("/ICHUNK/IARRAY0/ISRAM0/I7/I3/Q0") getData("/ICHUNK/IARRAY0/B1P1") getData("/ICHUNK/IARRAY0/B0P1") getData("/Aline<0>") getData("/S<0>") getData("/A<16>") getData("/net44") getData("/WD1<3>") getData("/WD1<2>") getData("/WD1<1>") getData("/WD1<0>") getData("/WD2<3>") getData("/WD2<2>") getData("/WD2<1>") getData("/WD2<0>") getData("/R1<3>") getData("/R1<2>") getData("/R1<1>") getData("/R1<0>") getData("/R2<3>") getData("/R2<2>") getData("/R2<1>") getData("/R2<0>") getData("/RDataAck<1>") getData("/RDataAck<0>") getData("/WdataAck<1>") getData("/WdataAck<0>") getData("/ValAddr") )
modelFile(
    '("/root/Desktop/Cadence/ncsu-FreePDK15/PTM-MG/smodels.scs" "")
)
run()
selectResult( 'tran )
plot(getData("/ICHUNK/IARRAY0/ISRAM0/I7/I3/Q1") getData("/ICHUNK/IARRAY0/ISRAM0/I7/I3/Q0") getData("/ICHUNK/IARRAY0/B1P1") getData("/ICHUNK/IARRAY0/B0P1") getData("/Aline<0>") getData("/S<0>") getData("/A<16>") getData("/net44") getData("/WD1<3>") getData("/WD1<2>") getData("/WD1<1>") getData("/WD1<0>") getData("/WD2<3>") getData("/WD2<2>") getData("/WD2<1>") getData("/WD2<0>") getData("/R1<3>") getData("/R1<2>") getData("/R1<1>") getData("/R1<0>") getData("/R2<3>") getData("/R2<2>") getData("/R2<1>") getData("/R2<0>") getData("/RDataAck<1>") getData("/RDataAck<0>") getData("/WdataAck<1>") getData("/WdataAck<0>") getData("/ValAddr") )
modelFile(
    '("/root/Desktop/Cadence/ncsu-FreePDK15/PTM-MG/smodels.scs" "")
)
run()
selectResult( 'tran )
plot(getData("/ICHUNK/IARRAY0/ISRAM0/I7/I3/Q1") getData("/ICHUNK/IARRAY0/ISRAM0/I7/I3/Q0") getData("/ICHUNK/IARRAY0/B1P1") getData("/ICHUNK/IARRAY0/B0P1") getData("/Aline<0>") getData("/S<0>") getData("/A<16>") getData("/net44") getData("/WD1<3>") getData("/WD1<2>") getData("/WD1<1>") getData("/WD1<0>") getData("/WD2<3>") getData("/WD2<2>") getData("/WD2<1>") getData("/WD2<0>") getData("/R1<3>") getData("/R1<2>") getData("/R1<1>") getData("/R1<0>") getData("/R2<3>") getData("/R2<2>") getData("/R2<1>") getData("/R2<0>") getData("/RDataAck<1>") getData("/RDataAck<0>") getData("/WdataAck<1>") getData("/WdataAck<0>") getData("/ValAddr") )
modelFile(
    '("/root/Desktop/Cadence/ncsu-FreePDK15/PTM-MG/smodels.scs" "")
)
run()
selectResult( 'tran )
plot(getData("/ICHUNK/IARRAY0/ISRAM0/I7/I3/Q1") getData("/ICHUNK/IARRAY0/ISRAM0/I7/I3/Q0") getData("/ICHUNK/IARRAY0/B1P1") getData("/ICHUNK/IARRAY0/B0P1") getData("/Aline<0>") getData("/S<0>") getData("/A<16>") getData("/net44") getData("/WD1<3>") getData("/WD1<2>") getData("/WD1<1>") getData("/WD1<0>") getData("/WD2<3>") getData("/WD2<2>") getData("/WD2<1>") getData("/WD2<0>") getData("/R1<3>") getData("/R1<2>") getData("/R1<1>") getData("/R1<0>") getData("/R2<3>") getData("/R2<2>") getData("/R2<1>") getData("/R2<0>") getData("/RDataAck<1>") getData("/RDataAck<0>") getData("/WdataAck<1>") getData("/WdataAck<0>") getData("/ValAddr") )
modelFile(
    '("/root/Desktop/Cadence/ncsu-FreePDK15/PTM-MG/smodels.scs" "")
)
run()
selectResult( 'tran )
plot(getData("/ICHUNK/IARRAY0/ISRAM0/I7/I3/Q1") getData("/ICHUNK/IARRAY0/ISRAM0/I7/I3/Q0") getData("/ICHUNK/IARRAY0/B1P1") getData("/ICHUNK/IARRAY0/B0P1") getData("/Aline<0>") getData("/S<0>") getData("/A<16>") getData("/net44") getData("/WD1<3>") getData("/WD1<2>") getData("/WD1<1>") getData("/WD1<0>") getData("/WD2<3>") getData("/WD2<2>") getData("/WD2<1>") getData("/WD2<0>") getData("/R1<3>") getData("/R1<2>") getData("/R1<1>") getData("/R1<0>") getData("/R2<3>") getData("/R2<2>") getData("/R2<1>") getData("/R2<0>") getData("/RDataAck<1>") getData("/RDataAck<0>") getData("/WdataAck<1>") getData("/WdataAck<0>") getData("/ValAddr") )
modelFile(
    '("/root/Desktop/Cadence/ncsu-FreePDK15/PTM-MG/smodels.scs" "")
)
run()
selectResult( 'tran )
plot(getData("/ICHUNK/IARRAY0/ISRAM0/I7/I3/Q1") getData("/ICHUNK/IARRAY0/ISRAM0/I7/I3/Q0") getData("/ICHUNK/IARRAY0/B1P1") getData("/ICHUNK/IARRAY0/B0P1") getData("/Aline<0>") getData("/S<0>") getData("/A<16>") getData("/net44") getData("/WD1<3>") getData("/WD1<2>") getData("/WD1<1>") getData("/WD1<0>") getData("/WD2<3>") getData("/WD2<2>") getData("/WD2<1>") getData("/WD2<0>") getData("/R1<3>") getData("/R1<2>") getData("/R1<1>") getData("/R1<0>") getData("/R2<3>") getData("/R2<2>") getData("/R2<1>") getData("/R2<0>") getData("/RDataAck<1>") getData("/RDataAck<0>") getData("/WdataAck<1>") getData("/WdataAck<0>") getData("/ValAddr") )
modelFile(
    '("/root/Desktop/Cadence/ncsu-FreePDK15/PTM-MG/smodels.scs" "")
)
run()
selectResult( 'tran )
plot(getData("/ICHUNK/IARRAY0/ISRAM0/I7/I3/Q1") getData("/ICHUNK/IARRAY0/ISRAM0/I7/I3/Q0") getData("/ICHUNK/IARRAY0/B1P1") getData("/ICHUNK/IARRAY0/B0P1") getData("/Aline<0>") getData("/S<0>") getData("/A<16>") getData("/net44") getData("/WD1<3>") getData("/WD1<2>") getData("/WD1<1>") getData("/WD1<0>") getData("/WD2<3>") getData("/WD2<2>") getData("/WD2<1>") getData("/WD2<0>") getData("/R1<3>") getData("/R1<2>") getData("/R1<1>") getData("/R1<0>") getData("/R2<3>") getData("/R2<2>") getData("/R2<1>") getData("/R2<0>") getData("/RDataAck<1>") getData("/RDataAck<0>") getData("/WdataAck<1>") getData("/WdataAck<0>") getData("/ValAddr") )
modelFile(
    '("/root/Desktop/Cadence/ncsu-FreePDK15/PTM-MG/smodels.scs" "")
)
delete( 'desVar "time5" )
delete( 'desVar "time4" )
delete( 'desVar "time3" )
delete( 'desVar "time2" )
delete( 'save 'v /net44 )
run()
selectResult( 'tran )
plot(getData("/ICHUNK/IARRAY0/ISRAM0/I7/I3/Q1") getData("/ICHUNK/IARRAY0/ISRAM0/I7/I3/Q0") getData("/ICHUNK/IARRAY0/B1P1") getData("/ICHUNK/IARRAY0/B0P1") getData("/Aline<0>") getData("/S<0>") getData("/A<16>") getData("/WD1<3>") getData("/WD1<2>") getData("/WD1<1>") getData("/WD1<0>") getData("/WD2<3>") getData("/WD2<2>") getData("/WD2<1>") getData("/WD2<0>") getData("/R1<3>") getData("/R1<2>") getData("/R1<1>") getData("/R1<0>") getData("/R2<3>") getData("/R2<2>") getData("/R2<1>") getData("/R2<0>") getData("/RDataAck<1>") getData("/RDataAck<0>") getData("/WdataAck<1>") getData("/WdataAck<0>") getData("/ValAddr") )
modelFile(
    '("/root/Desktop/Cadence/ncsu-FreePDK15/PTM-MG/smodels.scs" "")
)
run()
selectResult( 'tran )
plot(getData("/ICHUNK/IARRAY0/ISRAM0/I7/I3/Q1") getData("/ICHUNK/IARRAY0/ISRAM0/I7/I3/Q0") getData("/ICHUNK/IARRAY0/B1P1") getData("/ICHUNK/IARRAY0/B0P1") getData("/Aline<0>") getData("/S<0>") getData("/A<16>") getData("/WD1<3>") getData("/WD1<2>") getData("/WD1<1>") getData("/WD1<0>") getData("/WD2<3>") getData("/WD2<2>") getData("/WD2<1>") getData("/WD2<0>") getData("/R1<3>") getData("/R1<2>") getData("/R1<1>") getData("/R1<0>") getData("/R2<3>") getData("/R2<2>") getData("/R2<1>") getData("/R2<0>") getData("/RDataAck<1>") getData("/RDataAck<0>") getData("/WdataAck<1>") getData("/WdataAck<0>") getData("/ValAddr") )
modelFile(
    '("/root/Desktop/Cadence/ncsu-FreePDK15/PTM-MG/smodels.scs" "")
)
run()
selectResult( 'tran )
plot(getData("/ICHUNK/IARRAY0/ISRAM0/I7/I3/Q1") getData("/ICHUNK/IARRAY0/ISRAM0/I7/I3/Q0") getData("/ICHUNK/IARRAY0/B1P1") getData("/ICHUNK/IARRAY0/B0P1") getData("/Aline<0>") getData("/S<0>") getData("/A<16>") getData("/WD1<3>") getData("/WD1<2>") getData("/WD1<1>") getData("/WD1<0>") getData("/WD2<3>") getData("/WD2<2>") getData("/WD2<1>") getData("/WD2<0>") getData("/R1<3>") getData("/R1<2>") getData("/R1<1>") getData("/R1<0>") getData("/R2<3>") getData("/R2<2>") getData("/R2<1>") getData("/R2<0>") getData("/RDataAck<1>") getData("/RDataAck<0>") getData("/WdataAck<1>") getData("/WdataAck<0>") getData("/ValAddr") )
modelFile(
    '("/root/Desktop/Cadence/ncsu-FreePDK15/PTM-MG/smodels.scs" "")
)
option( ?categ 'netlister
	'vlogSupply1Sigs  "vdd!"
	'vlogSupply0Sigs  "vcc!"
)
run()
selectResult( 'tran )
plot(getData("/ICHUNK/IARRAY0/ISRAM0/I7/I3/Q1") getData("/ICHUNK/IARRAY0/ISRAM0/I7/I3/Q0") getData("/ICHUNK/IARRAY0/B1P1") getData("/ICHUNK/IARRAY0/B0P1") getData("/Aline<0>") getData("/S<0>") getData("/A<16>") getData("/WD1<3>") getData("/WD1<2>") getData("/WD1<1>") getData("/WD1<0>") getData("/WD2<3>") getData("/WD2<2>") getData("/WD2<1>") getData("/WD2<0>") getData("/R1<3>") getData("/R1<2>") getData("/R1<1>") getData("/R1<0>") getData("/R2<3>") getData("/R2<2>") getData("/R2<1>") getData("/R2<0>") getData("/RDataAck<1>") getData("/RDataAck<0>") getData("/WdataAck<1>") getData("/WdataAck<0>") getData("/ValAddr") )
modelFile(
    '("/root/Desktop/Cadence/ncsu-FreePDK15/PTM-MG/smodels.scs" "")
)
run()
selectResult( 'tran )
plot(getData("/ICHUNK/IARRAY0/ISRAM0/I7/I3/Q1") getData("/ICHUNK/IARRAY0/ISRAM0/I7/I3/Q0") getData("/ICHUNK/IARRAY0/B1P1") getData("/ICHUNK/IARRAY0/B0P1") getData("/Aline<0>") getData("/S<0>") getData("/A<16>") getData("/WD1<3>") getData("/WD1<2>") getData("/WD1<1>") getData("/WD1<0>") getData("/WD2<3>") getData("/WD2<2>") getData("/WD2<1>") getData("/WD2<0>") getData("/R1<3>") getData("/R1<2>") getData("/R1<1>") getData("/R1<0>") getData("/R2<3>") getData("/R2<2>") getData("/R2<1>") getData("/R2<0>") getData("/RDataAck<1>") getData("/RDataAck<0>") getData("/WdataAck<1>") getData("/WdataAck<0>") getData("/ValAddr") )
modelFile(
    '("/root/Desktop/Cadence/ncsu-FreePDK15/PTM-MG/smodels.scs" "")
)
option( ?categ 'netlister
	'vlogSupply1Sigs  ""
	'vlogSupply0Sigs  ""
)
run()
selectResult( 'tran )
plot(getData("/ICHUNK/IARRAY0/ISRAM0/I7/I3/Q1") getData("/ICHUNK/IARRAY0/ISRAM0/I7/I3/Q0") getData("/ICHUNK/IARRAY0/B1P1") getData("/ICHUNK/IARRAY0/B0P1") getData("/Aline<0>") getData("/S<0>") getData("/A<16>") getData("/WD1<3>") getData("/WD1<2>") getData("/WD1<1>") getData("/WD1<0>") getData("/WD2<3>") getData("/WD2<2>") getData("/WD2<1>") getData("/WD2<0>") getData("/R1<3>") getData("/R1<2>") getData("/R1<1>") getData("/R1<0>") getData("/R2<3>") getData("/R2<2>") getData("/R2<1>") getData("/R2<0>") getData("/RDataAck<1>") getData("/RDataAck<0>") getData("/WdataAck<1>") getData("/WdataAck<0>") getData("/ValAddr") )
modelFile(
    '("/root/Desktop/Cadence/ncsu-FreePDK15/PTM-MG/smodels.scs" "")
)
analysis('tran ?write ""  ?writefinal ""  )
saveOption( ?outputParamInfo nil )
saveOption( ?elementInfo nil )
saveOption( ?modelParamInfo nil )
temp( 27 )
run()
selectResult( 'tran )
plot(getData("/ICHUNK/IARRAY0/ISRAM0/I7/I3/Q1") getData("/ICHUNK/IARRAY0/ISRAM0/I7/I3/Q0") getData("/ICHUNK/IARRAY0/B1P1") getData("/ICHUNK/IARRAY0/B0P1") getData("/Aline<0>") getData("/S<0>") getData("/A<16>") getData("/WD1<3>") getData("/WD1<2>") getData("/WD1<1>") getData("/WD1<0>") getData("/WD2<3>") getData("/WD2<2>") getData("/WD2<1>") getData("/WD2<0>") getData("/R1<3>") getData("/R1<2>") getData("/R1<1>") getData("/R1<0>") getData("/R2<3>") getData("/R2<2>") getData("/R2<1>") getData("/R2<0>") getData("/RDataAck<1>") getData("/RDataAck<0>") getData("/WdataAck<1>") getData("/WdataAck<0>") getData("/ValAddr") )
modelFile(
    '("/root/Desktop/Cadence/ncsu-FreePDK15/PTM-MG/smodels.scs" "")
)
run()
selectResult( 'tran )
plot(getData("/ICHUNK/IARRAY0/ISRAM0/I7/I3/Q1") getData("/ICHUNK/IARRAY0/ISRAM0/I7/I3/Q0") getData("/ICHUNK/IARRAY0/B1P1") getData("/ICHUNK/IARRAY0/B0P1") getData("/Aline<0>") getData("/S<0>") getData("/A<16>") getData("/WD1<3>") getData("/WD1<2>") getData("/WD1<1>") getData("/WD1<0>") getData("/WD2<3>") getData("/WD2<2>") getData("/WD2<1>") getData("/WD2<0>") getData("/R1<3>") getData("/R1<2>") getData("/R1<1>") getData("/R1<0>") getData("/R2<3>") getData("/R2<2>") getData("/R2<1>") getData("/R2<0>") getData("/RDataAck<1>") getData("/RDataAck<0>") getData("/WdataAck<1>") getData("/WdataAck<0>") getData("/ValAddr") )
modelFile(
    '("/root/Desktop/Cadence/ncsu-FreePDK15/PTM-MG/smodels.scs" "")
)
run()
selectResult( 'tran )
plot(getData("/ICHUNK/IARRAY0/ISRAM0/I7/I3/Q1") getData("/ICHUNK/IARRAY0/ISRAM0/I7/I3/Q0") getData("/ICHUNK/IARRAY0/B1P1") getData("/ICHUNK/IARRAY0/B0P1") getData("/Aline<0>") getData("/S<0>") getData("/A<16>") getData("/WD1<3>") getData("/WD1<2>") getData("/WD1<1>") getData("/WD1<0>") getData("/WD2<3>") getData("/WD2<2>") getData("/WD2<1>") getData("/WD2<0>") getData("/R1<3>") getData("/R1<2>") getData("/R1<1>") getData("/R1<0>") getData("/R2<3>") getData("/R2<2>") getData("/R2<1>") getData("/R2<0>") getData("/RDataAck<1>") getData("/RDataAck<0>") getData("/WdataAck<1>") getData("/WdataAck<0>") getData("/ValAddr") )
modelFile(
    '("/root/Desktop/Cadence/ncsu-FreePDK15/PTM-MG/smodels.scs" "")
)
converge( 'ic "/RDataAck<0>" "0" )
converge( 'ic "/RDataAck<1>" "0" )
converge( 'ic "/R2<0>" "0" )
converge( 'ic "/R2<1>" "0" )
converge( 'ic "/R2<2>" "0" )
converge( 'ic "/R2<3>" "0" )
converge( 'ic "/R1<0>" "0" )
converge( 'ic "/R1<1>" "0" )
converge( 'ic "/R1<2>" "0" )
converge( 'ic "/R1<3>" "0" )
converge( 'ic "/WdataAck<0>" "0" )
converge( 'ic "/WdataAck<1>" "0" )
converge( 'ic "/WD2<0>" "0" )
converge( 'ic "/WD2<1>" "0" )
converge( 'ic "/WD2<2>" "0" )
converge( 'ic "/WD2<3>" "0" )
converge( 'ic "/WD1<0>" "0" )
converge( 'ic "/WD1<1>" "0" )
converge( 'ic "/WD1<2>" "0" )
converge( 'ic "/WD1<3>" "0" )
converge( 'ic "/A<0>" "0" )
converge( 'ic "/A<1>" "0" )
converge( 'ic "/A<2>" "0" )
converge( 'ic "/A<3>" "0" )
converge( 'ic "/A<4>" "0" )
converge( 'ic "/A<5>" "0" )
converge( 'ic "/A<6>" "0" )
converge( 'ic "/A<7>" "0" )
converge( 'ic "/A<8>" "0" )
converge( 'ic "/A<9>" "0" )
converge( 'ic "/A<10>" "0" )
converge( 'ic "/A<11>" "0" )
converge( 'ic "/A<12>" "0" )
converge( 'ic "/A<13>" "0" )
converge( 'ic "/A<14>" "0" )
converge( 'ic "/A<15>" "0" )
converge( 'ic "/A<16>" "0" )
converge( 'ic "/Ack" "0" )
converge( 'ic "/RW<0>" "0" )
converge( 'ic "/RW<1>" "0" )
converge( 'ic "/Go" "0" )
converge( 'ic "/W0<0>" "0" )
converge( 'ic "/W0<1>" "0" )
converge( 'ic "/W0<2>" "0" )
converge( 'ic "/W0<3>" "0" )
converge( 'ic "/W1<0>" "0" )
converge( 'ic "/W1<1>" "0" )
converge( 'ic "/W1<2>" "0" )
converge( 'ic "/W1<3>" "0" )
converge( 'ic "/B0<0>" "0" )
converge( 'ic "/B0<1>" "0" )
converge( 'ic "/B0<2>" "0" )
converge( 'ic "/B0<3>" "0" )
converge( 'ic "/B1<0>" "0" )
converge( 'ic "/B1<1>" "0" )
converge( 'ic "/B1<2>" "0" )
converge( 'ic "/B1<3>" "0" )
converge( 'ic "/Aline<0>" "0" )
converge( 'ic "/Aline<1>" "0" )
converge( 'ic "/Aline<2>" "0" )
converge( 'ic "/Aline<3>" "0" )
converge( 'ic "/Aline<4>" "0" )
converge( 'ic "/Aline<5>" "0" )
converge( 'ic "/Aline<6>" "0" )
converge( 'ic "/Aline<7>" "0" )
converge( 'ic "/Aline<8>" "0" )
converge( 'ic "/Aline<9>" "0" )
converge( 'ic "/Aline<10>" "0" )
converge( 'ic "/Aline<11>" "0" )
converge( 'ic "/Aline<12>" "0" )
converge( 'ic "/Aline<13>" "0" )
converge( 'ic "/Aline<14>" "0" )
converge( 'ic "/Aline<15>" "0" )
converge( 'ic "/Aline<16>" "0" )
converge( 'ic "/Aline<17>" "0" )
converge( 'ic "/Aline<18>" "0" )
converge( 'ic "/Aline<19>" "0" )
converge( 'ic "/Aline<20>" "0" )
converge( 'ic "/Aline<21>" "0" )
converge( 'ic "/Aline<22>" "0" )
converge( 'ic "/Aline<23>" "0" )
converge( 'ic "/Aline<24>" "0" )
converge( 'ic "/Aline<25>" "0" )
converge( 'ic "/Aline<26>" "0" )
converge( 'ic "/Aline<27>" "0" )
converge( 'ic "/Aline<28>" "0" )
converge( 'ic "/Aline<29>" "0" )
converge( 'ic "/Aline<30>" "0" )
converge( 'ic "/Aline<31>" "0" )
converge( 'ic "/Aline<32>" "0" )
converge( 'ic "/Aline<33>" "0" )
converge( 'ic "/Aline<34>" "0" )
converge( 'ic "/Aline<35>" "0" )
converge( 'ic "/Aline<36>" "0" )
converge( 'ic "/Aline<37>" "0" )
converge( 'ic "/Aline<38>" "0" )
converge( 'ic "/Aline<39>" "0" )
converge( 'ic "/Aline<40>" "0" )
converge( 'ic "/Aline<41>" "0" )
converge( 'ic "/Aline<42>" "0" )
converge( 'ic "/Aline<43>" "0" )
converge( 'ic "/Aline<44>" "0" )
converge( 'ic "/Aline<45>" "0" )
converge( 'ic "/Aline<46>" "0" )
converge( 'ic "/Aline<47>" "0" )
converge( 'ic "/Aline<48>" "0" )
converge( 'ic "/Aline<49>" "0" )
converge( 'ic "/Aline<50>" "0" )
converge( 'ic "/Aline<51>" "0" )
converge( 'ic "/Aline<52>" "0" )
converge( 'ic "/Aline<53>" "0" )
converge( 'ic "/Aline<54>" "0" )
converge( 'ic "/Aline<55>" "0" )
converge( 'ic "/Aline<56>" "0" )
converge( 'ic "/Aline<57>" "0" )
converge( 'ic "/Aline<58>" "0" )
converge( 'ic "/Aline<59>" "0" )
converge( 'ic "/Aline<60>" "0" )
converge( 'ic "/Aline<61>" "0" )
converge( 'ic "/Aline<62>" "0" )
converge( 'ic "/Aline<63>" "0" )
converge( 'ic "/S<0>" "0" )
converge( 'ic "/S<1>" "0" )
converge( 'ic "/S<2>" "0" )
converge( 'ic "/S<3>" "0" )
converge( 'ic "/S<4>" "0" )
converge( 'ic "/S<5>" "0" )
converge( 'ic "/S<6>" "0" )
converge( 'ic "/S<7>" "0" )
run()
selectResult( 'tran )
plot(getData("/ICHUNK/IARRAY0/ISRAM0/I7/I3/Q1") getData("/ICHUNK/IARRAY0/ISRAM0/I7/I3/Q0") getData("/ICHUNK/IARRAY0/B1P1") getData("/ICHUNK/IARRAY0/B0P1") getData("/Aline<0>") getData("/S<0>") getData("/A<16>") getData("/WD1<3>") getData("/WD1<2>") getData("/WD1<1>") getData("/WD1<0>") getData("/WD2<3>") getData("/WD2<2>") getData("/WD2<1>") getData("/WD2<0>") getData("/R1<3>") getData("/R1<2>") getData("/R1<1>") getData("/R1<0>") getData("/R2<3>") getData("/R2<2>") getData("/R2<1>") getData("/R2<0>") getData("/RDataAck<1>") getData("/RDataAck<0>") getData("/WdataAck<1>") getData("/WdataAck<0>") getData("/ValAddr") )
modelFile(
    '("/root/Desktop/Cadence/ncsu-FreePDK15/PTM-MG/smodels.scs" "")
)
run()
selectResult( 'tran )
plot(getData("/ICHUNK/IARRAY0/ISRAM0/I7/I3/Q1") getData("/ICHUNK/IARRAY0/ISRAM0/I7/I3/Q0") getData("/ICHUNK/IARRAY0/B1P1") getData("/ICHUNK/IARRAY0/B0P1") getData("/Aline<0>") getData("/S<0>") getData("/A<16>") getData("/WD1<3>") getData("/WD1<2>") getData("/WD1<1>") getData("/WD1<0>") getData("/WD2<3>") getData("/WD2<2>") getData("/WD2<1>") getData("/WD2<0>") getData("/R1<3>") getData("/R1<2>") getData("/R1<1>") getData("/R1<0>") getData("/R2<3>") getData("/R2<2>") getData("/R2<1>") getData("/R2<0>") getData("/RDataAck<1>") getData("/RDataAck<0>") getData("/WdataAck<1>") getData("/WdataAck<0>") getData("/ValAddr") )
modelFile(
    '("/root/Desktop/Cadence/ncsu-FreePDK15/PTM-MG/smodels.scs" "")
)
converge( 'ic "/ValAddr" "0" )
converge( 'ic "/net33<3>" "vdd" )
converge( 'ic "/net33<2>" "vdd" )
converge( 'ic "/net33<1>" "vdd" )
converge( 'ic "/net33<0>" "vdd" )
converge( 'ic "/net32<3>" "vdd" )
converge( 'ic "/net32<2>" "vdd" )
converge( 'ic "/net32<1>" "vdd" )
converge( 'ic "/net32<0>" "vdd" )
run()
selectResult( 'tran )
plot(getData("/ICHUNK/IARRAY0/ISRAM0/I7/I3/Q1") getData("/ICHUNK/IARRAY0/ISRAM0/I7/I3/Q0") getData("/ICHUNK/IARRAY0/B1P1") getData("/ICHUNK/IARRAY0/B0P1") getData("/Aline<0>") getData("/S<0>") getData("/A<16>") getData("/WD1<3>") getData("/WD1<2>") getData("/WD1<1>") getData("/WD1<0>") getData("/WD2<3>") getData("/WD2<2>") getData("/WD2<1>") getData("/WD2<0>") getData("/R1<3>") getData("/R1<2>") getData("/R1<1>") getData("/R1<0>") getData("/R2<3>") getData("/R2<2>") getData("/R2<1>") getData("/R2<0>") getData("/RDataAck<1>") getData("/RDataAck<0>") getData("/WdataAck<1>") getData("/WdataAck<0>") getData("/ValAddr") )
modelFile(
    '("/root/Desktop/Cadence/ncsu-FreePDK15/PTM-MG/smodels.scs" "")
)
run()
selectResult( 'tran )
plot(getData("/ICHUNK/IARRAY0/ISRAM0/I7/I3/Q1") getData("/ICHUNK/IARRAY0/ISRAM0/I7/I3/Q0") getData("/ICHUNK/IARRAY0/B1P1") getData("/ICHUNK/IARRAY0/B0P1") getData("/Aline<0>") getData("/S<0>") getData("/A<16>") getData("/WD1<3>") getData("/WD1<2>") getData("/WD1<1>") getData("/WD1<0>") getData("/WD2<3>") getData("/WD2<2>") getData("/WD2<1>") getData("/WD2<0>") getData("/R1<3>") getData("/R1<2>") getData("/R1<1>") getData("/R1<0>") getData("/R2<3>") getData("/R2<2>") getData("/R2<1>") getData("/R2<0>") getData("/RDataAck<1>") getData("/RDataAck<0>") getData("/WdataAck<1>") getData("/WdataAck<0>") getData("/ValAddr") )
modelFile(
    '("/root/Desktop/Cadence/ncsu-FreePDK15/PTM-MG/smodels.scs" "")
)
save( 'v "/Ack" )
delete( 'save 'v /A<16> /WD1<3> /WD1<2> /WD1<1> /WD1<0> /WD2<3> /WD2<2> /WD2<1> /WD2<0> /R1<3> /R1<2> /R1<1> /R1<0> /R2<3> /R2<2> /R2<1> /R2<0> /RDataAck<1> /RDataAck<0> /WdataAck<1> /WdataAck<0> )
delete( 'converge 'ic "/RDataAck<0>" )
delete( 'converge 'ic "/RDataAck<1>" )
delete( 'converge 'ic "/R2<0>" )
delete( 'converge 'ic "/R2<1>" )
delete( 'converge 'ic "/R2<2>" )
delete( 'converge 'ic "/R2<3>" )
delete( 'converge 'ic "/R1<0>" )
delete( 'converge 'ic "/R1<1>" )
delete( 'converge 'ic "/R1<2>" )
delete( 'converge 'ic "/R1<3>" )
delete( 'converge 'ic "/WdataAck<0>" )
delete( 'converge 'ic "/WdataAck<1>" )
delete( 'converge 'ic "/WD2<0>" )
delete( 'converge 'ic "/WD2<1>" )
delete( 'converge 'ic "/WD2<2>" )
delete( 'converge 'ic "/WD2<3>" )
delete( 'converge 'ic "/WD1<0>" )
delete( 'converge 'ic "/WD1<1>" )
delete( 'converge 'ic "/WD1<2>" )
delete( 'converge 'ic "/WD1<3>" )
delete( 'converge 'ic "/Ack" )
delete( 'converge 'ic "/RW<0>" )
delete( 'converge 'ic "/RW<1>" )
delete( 'converge 'ic "/Go" )
delete( 'converge 'ic "/W0<0>" )
delete( 'converge 'ic "/W0<1>" )
delete( 'converge 'ic "/W0<2>" )
delete( 'converge 'ic "/W0<3>" )
delete( 'converge 'ic "/W1<0>" )
delete( 'converge 'ic "/W1<1>" )
delete( 'converge 'ic "/W1<2>" )
delete( 'converge 'ic "/W1<3>" )
delete( 'converge 'ic "/B0<0>" )
delete( 'converge 'ic "/B0<1>" )
delete( 'converge 'ic "/B0<2>" )
delete( 'converge 'ic "/B0<3>" )
delete( 'converge 'ic "/B1<0>" )
delete( 'converge 'ic "/B1<1>" )
delete( 'converge 'ic "/B1<2>" )
delete( 'converge 'ic "/B1<3>" )
delete( 'converge 'ic "/ValAddr" )
delete( 'converge 'ic "/net33<3>" )
delete( 'converge 'ic "/net33<2>" )
delete( 'converge 'ic "/net33<1>" )
delete( 'converge 'ic "/net33<0>" )
delete( 'converge 'ic "/net32<3>" )
delete( 'converge 'ic "/net32<2>" )
delete( 'converge 'ic "/net32<1>" )
delete( 'converge 'ic "/net32<0>" )
run()
selectResult( 'tran )
plot(getData("/ICHUNK/IARRAY0/ISRAM0/I7/I3/Q1") getData("/ICHUNK/IARRAY0/ISRAM0/I7/I3/Q0") getData("/ICHUNK/IARRAY0/B0P1") getData("/ICHUNK/IARRAY0/B1P1") getData("/Aline<0>") getData("/ValAddr") getData("/Ack") getData("/S<0>") )
modelFile(
    '("/root/Desktop/Cadence/ncsu-FreePDK15/PTM-MG/smodels.scs" "")
)
analysis('tran ?write "spectre.ic"  ?writefinal "spectre.fc"  )
saveOption( ?outputParamInfo t )
saveOption( ?elementInfo t )
saveOption( ?modelParamInfo t )
temp( 27 )
run()
selectResult( 'tran )
plot(getData("/ICHUNK/IARRAY0/ISRAM0/I7/I3/Q1") getData("/ICHUNK/IARRAY0/ISRAM0/I7/I3/Q0") getData("/ICHUNK/IARRAY0/B0P1") getData("/ICHUNK/IARRAY0/B1P1") getData("/Aline<0>") getData("/ValAddr") getData("/Ack") getData("/S<0>") )
modelFile(
    '("/root/Desktop/Cadence/ncsu-FreePDK15/PTM-MG/smodels.scs" "")
)
run()
selectResult( 'tran )
plot(getData("/ICHUNK/IARRAY0/ISRAM0/I7/I3/Q1") getData("/ICHUNK/IARRAY0/ISRAM0/I7/I3/Q0") getData("/ICHUNK/IARRAY0/B0P1") getData("/ICHUNK/IARRAY0/B1P1") getData("/Aline<0>") getData("/ValAddr") getData("/Ack") getData("/S<0>") )
modelFile(
    '("/root/Desktop/Cadence/ncsu-FreePDK15/PTM-MG/smodels.scs" "")
)
analysis('tran ?write ""  ?writefinal ""  )
saveOption( ?outputParamInfo nil )
saveOption( ?elementInfo nil )
saveOption( ?modelParamInfo nil )
converge( 'ic "/Ack" "0" )
converge( 'ic "/ValAddr" "0" )
converge( 'ic "/RDataAck<0>" "0" )
converge( 'ic "/RDataAck<1>" "0" )
converge( 'ic "/R2<0>" "0" )
converge( 'ic "/R2<1>" "0" )
converge( 'ic "/R2<2>" "0" )
converge( 'ic "/R2<3>" "0" )
converge( 'ic "/R1<0>" "0" )
converge( 'ic "/R1<1>" "0" )
converge( 'ic "/R1<2>" "0" )
converge( 'ic "/R1<3>" "0" )
converge( 'ic "/WdataAck<0>" "0" )
converge( 'ic "/WdataAck<1>" "0" )
converge( 'ic "/WD2<0>" "0" )
converge( 'ic "/WD2<1>" "0" )
converge( 'ic "/WD2<2>" "0" )
converge( 'ic "/WD2<3>" "0" )
converge( 'ic "/WD1<0>" "0" )
converge( 'ic "/WD1<1>" "0" )
converge( 'ic "/WD1<2>" "0" )
converge( 'ic "/WD1<3>" "0" )
converge( 'ic "/RW<0>" "0" )
converge( 'ic "/RW<1>" "0" )
converge( 'ic "/Go" "0" )
converge( 'ic "/W0<0>" "0" )
converge( 'ic "/W0<1>" "0" )
converge( 'ic "/W0<2>" "0" )
converge( 'ic "/W0<3>" "0" )
converge( 'ic "/W1<0>" "0" )
converge( 'ic "/W1<1>" "0" )
converge( 'ic "/W1<2>" "0" )
converge( 'ic "/W1<3>" "0" )
converge( 'ic "/B0<0>" "0" )
converge( 'ic "/B0<1>" "0" )
converge( 'ic "/B0<2>" "0" )
converge( 'ic "/B0<3>" "0" )
converge( 'ic "/B1<0>" "0" )
converge( 'ic "/B1<1>" "0" )
converge( 'ic "/B1<2>" "0" )
converge( 'ic "/B1<3>" "0" )
temp( 27 )
run()
selectResult( 'tran )
plot(getData("/ICHUNK/IARRAY0/ISRAM0/I7/I3/Q1") getData("/ICHUNK/IARRAY0/ISRAM0/I7/I3/Q0") getData("/ICHUNK/IARRAY0/B0P1") getData("/ICHUNK/IARRAY0/B1P1") getData("/Aline<0>") getData("/ValAddr") getData("/Ack") getData("/S<0>") )
modelFile(
    '("/root/Desktop/Cadence/ncsu-FreePDK15/PTM-MG/smodels.scs" "")
)
save( 'v "/A<16>" "/B1<0>" "/B0<0>" "/W1<0>" "/W0<0>" "/RW<0>" )
run()
selectResult( 'tran )
plot(getData("/ICHUNK/IARRAY0/ISRAM0/I7/I3/Q1") getData("/ICHUNK/IARRAY0/ISRAM0/I7/I3/Q0") getData("/ICHUNK/IARRAY0/B0P1") getData("/ICHUNK/IARRAY0/B1P1") getData("/Aline<0>") getData("/ValAddr") getData("/Ack") getData("/S<0>") getData("/A<16>") getData("/B1<0>") getData("/B0<0>") getData("/W1<0>") getData("/W0<0>") getData("/RW<0>") )
modelFile(
    '("/root/Desktop/Cadence/ncsu-FreePDK15/PTM-MG/smodels.scs" "")
)
run()
selectResult( 'tran )
plot(getData("/ICHUNK/IARRAY0/ISRAM0/I7/I3/Q1") getData("/ICHUNK/IARRAY0/ISRAM0/I7/I3/Q0") getData("/ICHUNK/IARRAY0/B0P1") getData("/ICHUNK/IARRAY0/B1P1") getData("/Aline<0>") getData("/ValAddr") getData("/Ack") getData("/S<0>") getData("/A<16>") getData("/B1<0>") getData("/B0<0>") getData("/W1<0>") getData("/W0<0>") getData("/RW<0>") )
modelFile(
    '("/root/Desktop/Cadence/ncsu-FreePDK15/PTM-MG/smodels.scs" "")
)
delete( 'save 'v /ICHUNK/IARRAY0/B0P1 /ICHUNK/IARRAY0/B1P1 )
run()
selectResult( 'tran )
plot(getData("/Aline<0>") getData("/ValAddr") getData("/Ack") getData("/S<0>") getData("/A<16>") getData("/B1<0>") getData("/B0<0>") getData("/W1<0>") getData("/W0<0>") getData("/RW<0>") getData("/ICHUNK/IARRAY0/ISRAM0/I7/I3/Q0") getData("/ICHUNK/IARRAY0/ISRAM0/I7/I3/Q1") )
modelFile(
    '("/root/Desktop/Cadence/ncsu-FreePDK15/PTM-MG/smodels.scs" "")
)
analysis('tran ?write "spectre.ic"  ?writefinal "spectre.fc"  )
saveOption( ?outputParamInfo t )
saveOption( ?elementInfo t )
saveOption( ?modelParamInfo t )
temp( 27 )
run()
selectResult( 'tran )
plot(getData("/Aline<0>") getData("/ValAddr") getData("/Ack") getData("/S<0>") getData("/A<16>") getData("/B1<0>") getData("/B0<0>") getData("/W1<0>") getData("/W0<0>") getData("/RW<0>") getData("/ICHUNK/IARRAY0/ISRAM0/I7/I3/Q0") getData("/ICHUNK/IARRAY0/ISRAM0/I7/I3/Q1") )
modelFile(
    '("/root/Desktop/Cadence/ncsu-FreePDK15/PTM-MG/smodels.scs" "")
)
analysis('tran ?write ""  ?writefinal ""  )
saveOption( ?outputParamInfo nil )
saveOption( ?elementInfo nil )
saveOption( ?modelParamInfo nil )
temp( 27 )
run()
selectResult( 'tran )
plot(getData("/Aline<0>") getData("/ValAddr") getData("/Ack") getData("/S<0>") getData("/A<16>") getData("/B1<0>") getData("/B0<0>") getData("/W1<0>") getData("/W0<0>") getData("/RW<0>") getData("/ICHUNK/IARRAY0/ISRAM0/I7/I3/Q0") getData("/ICHUNK/IARRAY0/ISRAM0/I7/I3/Q1") )
modelFile(
    '("/root/Desktop/Cadence/ncsu-FreePDK15/PTM-MG/smodels.scs" "")
)
save( 'v "/ICHUNK/IARRAY0/B1P1" "/ICHUNK/IARRAY0/B0P1" )
run()
selectResult( 'tran )
plot(getData("/Aline<0>") getData("/ValAddr") getData("/Ack") getData("/S<0>") getData("/A<16>") getData("/B1<0>") getData("/B0<0>") getData("/W1<0>") getData("/W0<0>") getData("/RW<0>") getData("/ICHUNK/IARRAY0/ISRAM0/I7/I3/Q0") getData("/ICHUNK/IARRAY0/ISRAM0/I7/I3/Q1") getData("/ICHUNK/IARRAY0/B1P1") getData("/ICHUNK/IARRAY0/B0P1") )
modelFile(
    '("/root/Desktop/Cadence/ncsu-FreePDK15/PTM-MG/smodels.scs" "")
)
delete( 'save 'v /ICHUNK/IARRAY0/B1P1 /ICHUNK/IARRAY0/B0P1 )
run()
selectResult( 'tran )
plot(getData("/Aline<0>") getData("/ValAddr") getData("/Ack") getData("/S<0>") getData("/A<16>") getData("/B1<0>") getData("/B0<0>") getData("/W1<0>") getData("/W0<0>") getData("/RW<0>") getData("/ICHUNK/IARRAY0/ISRAM0/I7/I3/Q0") getData("/ICHUNK/IARRAY0/ISRAM0/I7/I3/Q1") )
modelFile(
    '("/root/Desktop/Cadence/ncsu-FreePDK15/PTM-MG/smodels.scs" "")
)
run()
selectResult( 'tran )
plot(getData("/Aline<0>") getData("/ValAddr") getData("/Ack") getData("/S<0>") getData("/A<16>") getData("/B1<0>") getData("/B0<0>") getData("/W1<0>") getData("/W0<0>") getData("/RW<0>") getData("/ICHUNK/IARRAY0/ISRAM0/I7/I3/Q0") getData("/ICHUNK/IARRAY0/ISRAM0/I7/I3/Q1") )
modelFile(
    '("/root/Desktop/Cadence/ncsu-FreePDK15/PTM-MG/smodels.scs" "")
)
analysis('tran ?write "spectre.ic"  ?writefinal "spectre.fc"  )
saveOption( ?outputParamInfo t )
saveOption( ?elementInfo t )
saveOption( ?modelParamInfo t )
temp( 27 )
run()
selectResult( 'tran )
plot(getData("/Aline<0>") getData("/ValAddr") getData("/Ack") getData("/S<0>") getData("/A<16>") getData("/B1<0>") getData("/B0<0>") getData("/W1<0>") getData("/W0<0>") getData("/RW<0>") getData("/ICHUNK/IARRAY0/ISRAM0/I7/I3/Q0") getData("/ICHUNK/IARRAY0/ISRAM0/I7/I3/Q1") )
modelFile(
    '("/root/Desktop/Cadence/ncsu-FreePDK15/PTM-MG/smodels.scs" "")
)
analysis('tran ?write ""  ?writefinal ""  )
saveOption( ?outputParamInfo nil )
saveOption( ?elementInfo nil )
saveOption( ?modelParamInfo nil )
temp( 27 )
run()
selectResult( 'tran )
plot(getData("/Aline<0>") getData("/ValAddr") getData("/Ack") getData("/S<0>") getData("/A<16>") getData("/B1<0>") getData("/B0<0>") getData("/W1<0>") getData("/W0<0>") getData("/RW<0>") getData("/ICHUNK/IARRAY0/ISRAM0/I7/I3/Q0") getData("/ICHUNK/IARRAY0/ISRAM0/I7/I3/Q1") )
modelFile(
    '("/root/Desktop/Cadence/ncsu-FreePDK15/PTM-MG/smodels.scs" "")
)
save( 'v "/ICHUNK/IARRAY0/B1P1" "/ICHUNK/IARRAY0/B0P1" )
run()
selectResult( 'tran )
plot(getData("/Aline<0>") getData("/ValAddr") getData("/Ack") getData("/S<0>") getData("/A<16>") getData("/B1<0>") getData("/B0<0>") getData("/W1<0>") getData("/W0<0>") getData("/RW<0>") getData("/ICHUNK/IARRAY0/ISRAM0/I7/I3/Q0") getData("/ICHUNK/IARRAY0/ISRAM0/I7/I3/Q1") getData("/ICHUNK/IARRAY0/B1P1") getData("/ICHUNK/IARRAY0/B0P1") )
modelFile(
    '("/root/Desktop/Cadence/ncsu-FreePDK15/PTM-MG/smodels.scs" "")
)
run()
selectResult( 'tran )
plot(getData("/Aline<0>") getData("/ValAddr") getData("/Ack") getData("/S<0>") getData("/A<16>") getData("/B1<0>") getData("/B0<0>") getData("/W1<0>") getData("/W0<0>") getData("/RW<0>") getData("/ICHUNK/IARRAY0/ISRAM0/I7/I3/Q0") getData("/ICHUNK/IARRAY0/ISRAM0/I7/I3/Q1") getData("/ICHUNK/IARRAY0/B1P1") getData("/ICHUNK/IARRAY0/B0P1") )
modelFile(
    '("/root/Desktop/Cadence/ncsu-FreePDK15/PTM-MG/smodels.scs" "")
)
run()
selectResult( 'tran )
plot(getData("/Aline<0>") getData("/ValAddr") getData("/Ack") getData("/S<0>") getData("/A<16>") getData("/B1<0>") getData("/B0<0>") getData("/W1<0>") getData("/W0<0>") getData("/RW<0>") getData("/ICHUNK/IARRAY0/ISRAM0/I7/I3/Q0") getData("/ICHUNK/IARRAY0/ISRAM0/I7/I3/Q1") getData("/ICHUNK/IARRAY0/B1P1") getData("/ICHUNK/IARRAY0/B0P1") )
modelFile(
    '("/root/Desktop/Cadence/ncsu-FreePDK15/PTM-MG/smodels.scs" "")
)
run()
selectResult( 'tran )
plot(getData("/Aline<0>") getData("/ValAddr") getData("/Ack") getData("/S<0>") getData("/A<16>") getData("/B1<0>") getData("/B0<0>") getData("/W1<0>") getData("/W0<0>") getData("/RW<0>") getData("/ICHUNK/IARRAY0/ISRAM0/I7/I3/Q0") getData("/ICHUNK/IARRAY0/ISRAM0/I7/I3/Q1") getData("/ICHUNK/IARRAY0/B1P1") getData("/ICHUNK/IARRAY0/B0P1") )
modelFile(
    '("/root/Desktop/Cadence/ncsu-FreePDK15/PTM-MG/smodels.scs" "")
)
run()
selectResult( 'tran )
plot(getData("/Aline<0>") getData("/ValAddr") getData("/Ack") getData("/S<0>") getData("/A<16>") getData("/B1<0>") getData("/B0<0>") getData("/W1<0>") getData("/W0<0>") getData("/RW<0>") getData("/ICHUNK/IARRAY0/ISRAM0/I7/I3/Q0") getData("/ICHUNK/IARRAY0/ISRAM0/I7/I3/Q1") getData("/ICHUNK/IARRAY0/B1P1") getData("/ICHUNK/IARRAY0/B0P1") )
modelFile(
    '("/root/Desktop/Cadence/ncsu-FreePDK15/PTM-MG/smodels.scs" "")
)
run()
selectResult( 'tran )
plot(getData("/Aline<0>") getData("/ValAddr") getData("/Ack") getData("/S<0>") getData("/A<16>") getData("/B1<0>") getData("/B0<0>") getData("/W1<0>") getData("/W0<0>") getData("/RW<0>") getData("/ICHUNK/IARRAY0/ISRAM0/I7/I3/Q0") getData("/ICHUNK/IARRAY0/ISRAM0/I7/I3/Q1") getData("/ICHUNK/IARRAY0/B1P1") getData("/ICHUNK/IARRAY0/B0P1") )
modelFile(
    '("/root/Desktop/Cadence/ncsu-FreePDK15/PTM-MG/smodels.scs" "")
)
run()
selectResult( 'tran )
plot(getData("/Aline<0>") getData("/ValAddr") getData("/Ack") getData("/S<0>") getData("/A<16>") getData("/B1<0>") getData("/B0<0>") getData("/W1<0>") getData("/W0<0>") getData("/RW<0>") getData("/ICHUNK/IARRAY0/ISRAM0/I7/I3/Q0") getData("/ICHUNK/IARRAY0/ISRAM0/I7/I3/Q1") getData("/ICHUNK/IARRAY0/B1P1") getData("/ICHUNK/IARRAY0/B0P1") )
modelFile(
    '("/root/Desktop/Cadence/ncsu-FreePDK15/PTM-MG/smodels.scs" "")
)
run()
selectResult( 'tran )
plot(getData("/Aline<0>") getData("/ValAddr") getData("/Ack") getData("/S<0>") getData("/A<16>") getData("/B1<0>") getData("/B0<0>") getData("/W1<0>") getData("/W0<0>") getData("/RW<0>") getData("/ICHUNK/IARRAY0/ISRAM0/I7/I3/Q0") getData("/ICHUNK/IARRAY0/ISRAM0/I7/I3/Q1") getData("/ICHUNK/IARRAY0/B1P1") getData("/ICHUNK/IARRAY0/B0P1") )
modelFile(
    '("/root/Desktop/Cadence/ncsu-FreePDK15/PTM-MG/smodels.scs" "")
)
run()
selectResult( 'tran )
plot(getData("/Aline<0>") getData("/ValAddr") getData("/Ack") getData("/S<0>") getData("/A<16>") getData("/B1<0>") getData("/B0<0>") getData("/W1<0>") getData("/W0<0>") getData("/RW<0>") getData("/ICHUNK/IARRAY0/ISRAM0/I7/I3/Q0") getData("/ICHUNK/IARRAY0/ISRAM0/I7/I3/Q1") getData("/ICHUNK/IARRAY0/B1P1") getData("/ICHUNK/IARRAY0/B0P1") )
modelFile(
    '("/root/Desktop/Cadence/ncsu-FreePDK15/PTM-MG/smodels.scs" "")
)
run()
selectResult( 'tran )
plot(getData("/Aline<0>") getData("/ValAddr") getData("/Ack") getData("/S<0>") getData("/A<16>") getData("/B1<0>") getData("/B0<0>") getData("/W1<0>") getData("/W0<0>") getData("/RW<0>") getData("/ICHUNK/IARRAY0/ISRAM0/I7/I3/Q0") getData("/ICHUNK/IARRAY0/ISRAM0/I7/I3/Q1") getData("/ICHUNK/IARRAY0/B1P1") getData("/ICHUNK/IARRAY0/B0P1") )
modelFile(
    '("/root/Desktop/Cadence/ncsu-FreePDK15/PTM-MG/smodels.scs" "")
)
run()
selectResult( 'tran )
plot(getData("/Aline<0>") getData("/ValAddr") getData("/Ack") getData("/S<0>") getData("/A<16>") getData("/B1<0>") getData("/B0<0>") getData("/W1<0>") getData("/W0<0>") getData("/RW<0>") getData("/ICHUNK/IARRAY0/ISRAM0/I7/I3/Q0") getData("/ICHUNK/IARRAY0/ISRAM0/I7/I3/Q1") getData("/ICHUNK/IARRAY0/B1P1") getData("/ICHUNK/IARRAY0/B0P1") )
modelFile(
    '("/root/Desktop/Cadence/ncsu-FreePDK15/PTM-MG/smodels.scs" "")
)
run()
selectResult( 'tran )
plot(getData("/Aline<0>") getData("/ValAddr") getData("/Ack") getData("/S<0>") getData("/A<16>") getData("/B1<0>") getData("/B0<0>") getData("/W1<0>") getData("/W0<0>") getData("/RW<0>") getData("/ICHUNK/IARRAY0/ISRAM0/I7/I3/Q0") getData("/ICHUNK/IARRAY0/ISRAM0/I7/I3/Q1") getData("/ICHUNK/IARRAY0/B1P1") getData("/ICHUNK/IARRAY0/B0P1") )
