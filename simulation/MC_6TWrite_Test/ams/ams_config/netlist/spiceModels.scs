simulator lang=spectre
include "/root/Desktop/Cadence/ncsu-FreePDK15/PTM-MG/smodels.scs" amsd_subckt_bind=yes
