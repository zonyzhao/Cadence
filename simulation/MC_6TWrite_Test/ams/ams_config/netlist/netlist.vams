// AMS netlist generated by the OSS based AMS netlister
// IC subversion:  IC6.1.6.500.10
// IUS version: 14.20-p001
// Copyright(C) 2005-2009, Cadence Design Systems, Inc
// User: root Pid: 6000
// Design library name: 16nm_Tests
// Design cell name: MC_6TWrite_Test
// Design view name: ams_config
// Solver: UltraSim

`include "disciplines.vams"
`include "userDisciplines.vams"
// Library - 16nm, Cell - 6T, View - schematic
// LAST TIME SAVED: May 25 23:30:46 2015
// NETLIST TIME: May 27 21:54:26 2015
`timescale 1ns / 1ns

(* cds_ams_schematic *)
module \6T  (A, B0, B1);

inout  A, B0, B1;

nfet #(.w(60n), .l(20n), .nfin(1), .nf(1), .m(1))
(* integer passed_mfactor = "m"; *)
M5 (Q0, Q1, cds_globals.\gnd! , cds_globals.\gnd! );

nfet #(.w(60n), .l(20n), .nfin(1), .nf(1), .m(1))
(* integer passed_mfactor = "m"; *)
M4 (Q1, Q0, cds_globals.\gnd! , cds_globals.\gnd! );

nfet #(.w(120n), .l(20n), .nfin(2), .nf(1), .m(1))
(* integer passed_mfactor = "m"; *)
M1 (Q1, A, B1, cds_globals.\gnd! );

nfet #(.w(120n), .l(20n), .nfin(2), .nf(1), .m(1))
(* integer passed_mfactor = "m"; *)
M0 (Q0, A, B0, cds_globals.\gnd! );

pfet #(.w(100n), .l(20n), .nfin(1), .nf(1), .m(1))
(* integer passed_mfactor = "m"; *)
M3 (Q0, Q1, cds_globals.\vdd! , cds_globals.\vdd! );

pfet #(.w(100n), .l(20n), .nfin(1), .nf(1), .m(1))
(* integer passed_mfactor = "m"; *)
M2 (Q1, Q0, cds_globals.\vdd! , cds_globals.\vdd! );

endmodule
// Library - 16nm, Cell - 6T_4x, View - schematic
// LAST TIME SAVED: Feb 19 23:02:55 2015
// NETLIST TIME: May 27 21:54:26 2015
`timescale 1ns / 1ns

(* cds_ams_schematic *)
module \6T_4x  (A, B0, B1);

inout  B0, B1;

inout [3:0]  A;

\6T  I3 ( .A(A[0]), .B0(B0), .B1(B1));

\6T  I2 ( .A(A[1]), .B0(B0), .B1(B1));

\6T  I1 ( .A(A[2]), .B0(B0), .B1(B1));

\6T  I0 ( .A(A[3]), .B0(B0), .B1(B1));

endmodule
// Library - 16nm, Cell - nor_1x, View - schematic
// LAST TIME SAVED: Apr 24 05:23:53 2015
// NETLIST TIME: May 27 21:54:27 2015
`timescale 1ns / 1ns

(* cds_ams_schematic *)
module nor_1x (Y, A, B);

output  Y;

input  A, B;

pfet #(.w(200n), .l(20n), .nfin(1), .nf(1), .m(1))
(* integer passed_mfactor = "m"; *)
M3 (Y, B, or_pd_ps, cds_globals.\vdd! );

pfet #(.w(200n), .l(20n), .nfin(1), .nf(1), .m(1))
(* integer passed_mfactor = "m"; *)
M2 (or_pd_ps, A, cds_globals.\vdd! , cds_globals.\vdd! );

nfet #(.w(60n), .l(20n), .nfin(1), .nf(1), .m(1))
(* integer passed_mfactor = "m"; *)
M1 (Y, B, cds_globals.\gnd! , cds_globals.\gnd! );

nfet #(.w(60n), .l(20n), .nfin(1), .nf(1), .m(1))
(* integer passed_mfactor = "m"; *)
M0 (Y, A, cds_globals.\gnd! , cds_globals.\gnd! );

endmodule
// Library - 16nm, Cell - or_1x, View - schematic
// LAST TIME SAVED: Apr  1 19:23:46 2015
// NETLIST TIME: May 27 21:54:27 2015
`timescale 1ns / 1ns

(* cds_ams_schematic *)
module or_1x (Y, A, B);

output  Y;

input  A, B;

nor_1x I6 ( .Y(AnorB), .B(B), .A(A));

inv_1x I7 ( .Y(Y), .A(AnorB));

endmodule
// Library - 16nm, Cell - inv_weak_1x, View - schematic
// LAST TIME SAVED: Apr 24 03:08:40 2015
// NETLIST TIME: May 27 21:54:27 2015
`timescale 1ns / 1ns

(* cds_ams_schematic *)
module inv_weak_1x (Y, A);

output  Y;

input  A;

nfet #(.w(60n), .l(20n), .nfin(1), .nf(1), .ls(105n), .m(1))
(* integer passed_mfactor = "m"; *)
M2 (net13, cds_globals.\vdd! , cds_globals.\gnd! , cds_globals.\gnd! );

nfet #(.w(60n), .l(20n), .nfin(1), .nf(1), .ls(105n), .m(1))
(* integer passed_mfactor = "m"; *)
M0 (Y, A, net13, cds_globals.\gnd! );

pfet #(.w(100n), .l(20n), .nfin(1), .nf(1), .m(1))
(* integer passed_mfactor = "m"; *)
M3 (net14, cds_globals.\gnd! , cds_globals.\vdd! , cds_globals.\vdd! );

pfet #(.w(100n), .l(20n), .nfin(1), .nf(1), .m(1))
(* integer passed_mfactor = "m"; *)
M1 (Y, A, net14, cds_globals.\vdd! );

endmodule
// Library - 16nm, Cell - TH22, View - schematic
// LAST TIME SAVED: Apr 24 03:40:50 2015
// NETLIST TIME: May 27 21:54:27 2015
`timescale 1ns / 1ns

(* cds_ams_schematic *)
module TH22 (Y, A, B);

output  Y;

input  A, B;

nfet #(.w(60n), .l(20n), .nfin(1), .nf(1), .m(1))
(* integer passed_mfactor = "m"; *)
M5 (Y, net5, cds_globals.\gnd! , cds_globals.\gnd! );

nfet #(.w(120n), .l(20n), .nfin(1), .nf(1), .m(1))
(* integer passed_mfactor = "m"; *)
M4 (net5, Y, net9, cds_globals.\gnd! );

nfet #(.w(120n), .l(20n), .nfin(1), .nf(1), .m(1))
(* integer passed_mfactor = "m"; *)
M3 (net9, B, cds_globals.\gnd! , cds_globals.\gnd! );

nfet #(.w(120n), .l(20n), .nfin(1), .nf(1), .m(1))
(* integer passed_mfactor = "m"; *)
M2 (net9, A, cds_globals.\gnd! , cds_globals.\gnd! );

nfet #(.w(120n), .l(20n), .nfin(1), .nf(1), .m(1))
(* integer passed_mfactor = "m"; *)
M1 (net5, B, net17, cds_globals.\gnd! );

nfet #(.w(120n), .l(20n), .nfin(1), .nf(1), .m(1))
(* integer passed_mfactor = "m"; *)
M0 (net17, A, cds_globals.\gnd! , cds_globals.\gnd! );

pfet #(.w(100n), .l(20n), .nfin(1), .nf(1), .m(1))
(* integer passed_mfactor = "m"; *)
M11 (Y, net5, cds_globals.\vdd! , cds_globals.\vdd! );

pfet #(.w(200n), .l(20n), .nfin(1), .nf(1), .m(1))
(* integer passed_mfactor = "m"; *)
M10 (net5, B, net032, cds_globals.\vdd! );

pfet #(.w(200n), .l(20n), .nfin(1), .nf(1), .m(1))
(* integer passed_mfactor = "m"; *)
M9 (net032, A, cds_globals.\vdd! , cds_globals.\vdd! );

pfet #(.w(200n), .l(20n), .nfin(1), .nf(1), .m(1))
(* integer passed_mfactor = "m"; *)
M8 (net037, B, cds_globals.\vdd! , cds_globals.\vdd! );

pfet #(.w(200n), .l(20n), .nfin(1), .nf(1), .m(1))
(* integer passed_mfactor = "m"; *)
M7 (net037, A, cds_globals.\vdd! , cds_globals.\vdd! );

pfet #(.w(200n), .l(20n), .nfin(1), .nf(1), .m(1))
(* integer passed_mfactor = "m"; *)
M6 (net5, Y, net037, cds_globals.\vdd! );

endmodule
// Library - 16nm, Cell - PCHBd, View - schematic
// LAST TIME SAVED: Apr 25 22:07:21 2015
// NETLIST TIME: May 27 21:54:27 2015
`timescale 1ns / 1ns

(* cds_ams_schematic *)
module PCHBd (Ai, \R0i+1 , \R1i+1 , \Ai+1 , R0i, R1i);

output  Ai, \R0i+1 , \R1i+1 ;

input  \Ai+1 , R0i, R1i;

inv_1x I32 ( .Y(\R0i+1 ), .A(\~R0 ));

inv_1x I5 ( .Y(\R1i+1 ), .A(\~R1 ));

inv_1x I35 ( .Y(\~ack ), .A(Ai));

nfet #(.w(60n), .l(20n), .nfin(1), .nf(1), .m(1))
(* integer passed_mfactor = "m"; *)
M16 (\~R0 , R0i, net034, cds_globals.\gnd! );

nfet #(.w(60n), .l(20n), .nfin(1), .nf(1), .m(1))
(* integer passed_mfactor = "m"; *)
M3 (\~R1 , R1i, net033, cds_globals.\gnd! );

nfet #(.w(60n), .l(20n), .nfin(1), .nf(1), .m(1))
(* integer passed_mfactor = "m"; *)
M4 (net034, oE, cds_globals.\gnd! , cds_globals.\gnd! );

nfet #(.w(60n), .l(20n), .nfin(1), .nf(1), .m(1))
(* integer passed_mfactor = "m"; *)
M5 (net033, oE, cds_globals.\gnd! , cds_globals.\gnd! );

pfet #(.w(200n), .l(20n), .nfin(1), .nf(1), .m(1))
(* integer passed_mfactor = "m"; *)
M10 (\~R0 , oE, cds_globals.\vdd! , cds_globals.\vdd! );

pfet #(.w(200n), .l(20n), .nfin(1), .nf(1), .m(1))
(* integer passed_mfactor = "m"; *)
M1 (\~R1 , oE, cds_globals.\vdd! , cds_globals.\vdd! );

nand_1x I6 ( .A(\~R1 ), .Y(outValid), .B(\~R0 ));

or_1x I9 ( .Y(inValid), .B(R1i), .A(R0i));

inv_weak_1x I2 ( .Y(\~R0 ), .A(\R0i+1 ));

inv_weak_1x I33 ( .Y(\~R1 ), .A(\R1i+1 ));

TH22 I12 ( .B(inValid), .A(outValid), .Y(Ai));

TH22 I30 ( .B(\Ai+1 ), .A(\~ack ), .Y(oE));

endmodule
// Library - 16nm, Cell - THaC, View - schematic
// LAST TIME SAVED: Apr 24 03:06:58 2015
// NETLIST TIME: May 27 21:54:27 2015
`timescale 1ns / 1ns

(* cds_ams_schematic *)
module THaC (Y, A, \B+ , \C- );

output  Y;

input  A, \B+ , \C- ;

nfet #(.w(120n), .l(20n), .nfin(1), .nf(1), .m(1))
(* integer passed_mfactor = "m"; *)
M8 (net11, A, cds_globals.\gnd! , A);

nfet #(.w(120n), .l(20n), .nfin(1), .nf(1), .m(1))
(* integer passed_mfactor = "m"; *)
M5 (net7, A, net33, A);

nfet #(.w(120n), .l(20n), .nfin(1), .nf(1), .m(1))
(* integer passed_mfactor = "m"; *)
M6 (net7, Y, net11, Y);

nfet #(.w(120n), .l(20n), .nfin(1), .nf(1), .m(1))
(* integer passed_mfactor = "m"; *)
M9 (net11, \C- , cds_globals.\gnd! , \C- );

nfet #(.w(120n), .l(20n), .nfin(1), .nf(1), .m(1))
(* integer passed_mfactor = "m"; *)
M7 (net33, \~B+ , cds_globals.\gnd! , \~B+ );

inv_1x I2 ( .Y(Y), .A(net7));

inv_1x I9 ( .Y(\~B+ ), .A(\B+ ));

pfet #(.w(100n), .l(20n), .nfin(1), .nf(1), .m(1))
(* integer passed_mfactor = "m"; *)
M4 (net7, Y, net17, Y);

pfet #(.w(100n), .l(20n), .nfin(1), .nf(1), .m(1))
(* integer passed_mfactor = "m"; *)
M3 (net7, \C- , net32, \C- );

pfet #(.w(100n), .l(20n), .nfin(1), .nf(1), .m(1))
(* integer passed_mfactor = "m"; *)
M0 (net32, A, cds_globals.\vdd! , A);

pfet #(.w(100n), .l(20n), .nfin(1), .nf(1), .m(1))
(* integer passed_mfactor = "m"; *)
M2 (net17, \~B+ , cds_globals.\vdd! , \~B+ );

pfet #(.w(100n), .l(20n), .nfin(1), .nf(1), .m(1))
(* integer passed_mfactor = "m"; *)
M1 (net17, A, cds_globals.\vdd! , A);

endmodule
// Library - 16nm, Cell - PCHB_Write, View - schematic
// LAST TIME SAVED: Apr 24 04:37:27 2015
// NETLIST TIME: May 27 21:54:27 2015
`timescale 1ns / 1ns

(* cds_ams_schematic *)
module PCHB_Write (.Ai(outAck), B0, B1, R0i, R1i, W0, W1);

output  outAck, B0, B1;

input  R0i, R1i, W0, W1;

inv_1x I34 ( .Y(net027), .A(outAck));

inv_1x I5 ( .Y(B1), .A(net029));

inv_1x I4 ( .Y(B0), .A(net18));

THaC I12 ( .\B+ (inAck), .\C- (outValid), .A(inValid), .Y(outAck));

nfet #(.w(60n), .l(20n), .nfin(1), .nf(1), .m(1))
(* integer passed_mfactor = "m"; *)
M5 (net026, oE, cds_globals.\gnd! , cds_globals.\gnd! );

nfet #(.w(60n), .l(20n), .nfin(1), .nf(1), .m(1))
(* integer passed_mfactor = "m"; *)
M4 (net22, oE, cds_globals.\gnd! , cds_globals.\gnd! );

nfet #(.w(60n), .l(20n), .nfin(1), .nf(1), .m(1))
(* integer passed_mfactor = "m"; *)
M3 (net029, R1i, net026, cds_globals.\gnd! );

nfet #(.w(60n), .l(20n), .nfin(1), .nf(1), .m(1))
(* integer passed_mfactor = "m"; *)
M2 (net18, R0i, net22, cds_globals.\gnd! );

pfet #(.w(200n), .l(20n), .nfin(1), .nf(1), .m(1))
(* integer passed_mfactor = "m"; *)
M1 (net029, oE, cds_globals.\vdd! , cds_globals.\vdd! );

pfet #(.w(200n), .l(20n), .nfin(1), .nf(1), .m(1))
(* integer passed_mfactor = "m"; *)
M0 (net18, oE, cds_globals.\vdd! , cds_globals.\vdd! );

nand_1x I6 ( .Y(outValid), .B(net18), .A(net029));

or_1x I9 ( .Y(inValid), .B(R1i), .A(R0i));

inv_weak_1x I2 ( .Y(net18), .A(B0));

inv_weak_1x I3 ( .Y(net029), .A(B1));

TH22 I11 ( .Y(oE), .B(inAck), .A(net027));

nor_1x I31 ( .Y(inAck), .B(W0), .A(W1));

endmodule
// Library - 16nm, Cell - and_1x, View - schematic
// LAST TIME SAVED: Feb 27 19:23:03 2015
// NETLIST TIME: May 27 21:54:27 2015
`timescale 1ns / 1ns

(* cds_ams_schematic *)
module and_1x (Y, A, B);

output  Y;

input  A, B;

nand_1x I7 ( .A(A), .Y(ntYbar), .B(B));

inv_1x I6 ( .Y(Y), .A(ntYbar));

endmodule
// Library - 16nm, Cell - and4_1x, View - schematic
// LAST TIME SAVED: Apr 23 17:51:10 2015
// NETLIST TIME: May 27 21:54:27 2015
`timescale 1ns / 1ns

(* cds_ams_schematic *)
module and4_1x (Y, A, B, C, D);

output  Y;

input  A, B, C, D;

nand4_1x I15 ( .D(D), .C(C), .A(A), .B(B), .Y(net1));

inv_1x I16 ( .Y(Y), .A(net1));

endmodule
// Library - 16nm, Cell - WCHB_Read, View - schematic
// LAST TIME SAVED: Apr 25 22:08:40 2015
// NETLIST TIME: May 27 21:54:27 2015
`timescale 1ns / 1ns

(* cds_ams_schematic *)
module WCHB_Read (Lack, Out, L0, L1, Rack);

input  Rack;

output [3:0]  Out;
output [1:0]  Lack;

input [1:0]  L1;
input [1:0]  L0;

// Buses in the design

wire  [0:1]  n0;

wire  [0:1]  n1;

wire  [0:3]  \~Out ;

wire  [0:3]  m;

nor_1x I23 ( .Y(Lack[1]), .B(n1[1]), .A(n0[1]));

nor_1x I12 ( .Y(Lack[0]), .B(n1[0]), .A(n0[0]));

and4_1x I34 ( .D(\~Out [3]), .C(\~Out [2]), .Y(outAck), .B(\~Out [1]),
    .A(\~Out [0]));

nand_1x I29 ( .Y(m[2]), .B(n1[1]), .A(n0[0]));

nand_1x I26 ( .Y(m[3]), .B(n1[1]), .A(n1[0]));

nand_1x I25 ( .Y(m[1]), .B(n0[1]), .A(n1[0]));

nand_1x I24 ( .Y(m[0]), .B(n0[1]), .A(n0[0]));

TH22 I28 ( .Y(\~Out [2]), .B(m[2]), .A(Rack));

TH22 I27 ( .Y(\~Out [3]), .B(m[3]), .A(Rack));

TH22 I0 ( .Y(n0[0]), .B(outAck), .A(L0[0]));

TH22 I7 ( .Y(\~Out [0]), .B(m[0]), .A(Rack));

TH22 I1 ( .Y(n1[0]), .B(outAck), .A(L1[0]));

TH22 I21 ( .Y(n0[1]), .B(outAck), .A(L0[1]));

TH22 I6 ( .Y(\~Out [1]), .B(m[1]), .A(Rack));

TH22 I22 ( .Y(n1[1]), .B(outAck), .A(L1[1]));

inv_1x I42 ( .Y(Out[3]), .A(\~Out [3]));

inv_1x I41 ( .Y(Out[2]), .A(\~Out [2]));

inv_1x I39 ( .Y(Out[0]), .A(\~Out [0]));

inv_1x I40 ( .Y(Out[1]), .A(\~Out [1]));

endmodule
// Library - 16nm, Cell - 6T_32x, View - schematic
// LAST TIME SAVED: Feb 27 18:39:40 2015
// NETLIST TIME: May 27 21:54:26 2015
`timescale 1ns / 1ns

(* cds_ams_schematic *)
module \6T_32x  (A, B0, B1);

inout  B0, B1;

inout [31:0]  A;

\6T_4x  I7 ( .A(A[3:0]), .B0(B0), .B1(B1));

\6T_4x  I6 ( .A(A[7:4]), .B0(B0), .B1(B1));

\6T_4x  I5 ( .A(A[11:8]), .B0(B0), .B1(B1));

\6T_4x  I4 ( .A(A[15:12]), .B0(B0), .B1(B1));

\6T_4x  I3 ( .A(A[19:16]), .B0(B0), .B1(B1));

\6T_4x  I2 ( .A(A[23:20]), .B0(B0), .B1(B1));

\6T_4x  I1 ( .A(A[27:24]), .B0(B0), .B1(B1));

\6T_4x  I0 ( .A(A[31:28]), .B0(B0), .B1(B1));

endmodule
// Library - 16nm, Cell - TH44~, View - schematic
// LAST TIME SAVED: Apr 24 03:06:35 2015
// NETLIST TIME: May 27 21:54:27 2015
`timescale 1ns / 1ns

(* cds_ams_schematic *)
module \TH44~  (Y, A, B, C, D);

output  Y;

input  A, B, C, D;

nfet #(.w(80n), .l(16n), .nfin(1), .nf(1), .m(1))
(* integer passed_mfactor = "m"; *)
M19 (net13, A, cds_globals.\gnd! , cds_globals.\gnd! );

nfet #(.w(80n), .l(16n), .nfin(1), .nf(1), .m(1))
(* integer passed_mfactor = "m"; *)
M18 (net13, B, cds_globals.\gnd! , cds_globals.\gnd! );

nfet #(.w(80n), .l(16n), .nfin(1), .nf(1), .m(1))
(* integer passed_mfactor = "m"; *)
M17 (net13, C, cds_globals.\gnd! , cds_globals.\gnd! );

nfet #(.w(80n), .l(16n), .nfin(1), .nf(1), .m(1))
(* integer passed_mfactor = "m"; *)
M16 (net13, D, cds_globals.\gnd! , cds_globals.\gnd! );

nfet #(.w(40n), .l(16n), .nfin(1), .nf(1), .m(1))
(* integer passed_mfactor = "m"; *)
M15 (net011, net19, cds_globals.\gnd! , cds_globals.\gnd! );

nfet #(.w(160n), .l(16n), .nfin(1), .nf(1), .m(1))
(* integer passed_mfactor = "m"; *)
M14 (net42, A, cds_globals.\gnd! , cds_globals.\gnd! );

nfet #(.w(160n), .l(16n), .nfin(1), .nf(1), .m(1))
(* integer passed_mfactor = "m"; *)
M13 (net43, B, net42, cds_globals.\gnd! );

nfet #(.w(160n), .l(16n), .nfin(1), .nf(1), .m(1))
(* integer passed_mfactor = "m"; *)
M12 (net44, C, net43, cds_globals.\gnd! );

nfet #(.w(160n), .l(16n), .nfin(1), .nf(1), .m(1))
(* integer passed_mfactor = "m"; *)
M11 (net19, D, net44, cds_globals.\gnd! );

nfet #(.w(80n), .l(16n), .nfin(1), .nf(1), .m(1))
(* integer passed_mfactor = "m"; *)
M10 (net19, net011, net13, cds_globals.\gnd! );

inv_1x I6 ( .Y(Y), .A(net011));

pfet #(.w(80n), .l(16n), .nfin(1), .nf(1), .m(1))
(* integer passed_mfactor = "m"; *)
M9 (net011, net19, cds_globals.\vdd! , cds_globals.\vdd! );

pfet #(.w(160n), .l(16n), .nfin(1), .nf(1), .m(1))
(* integer passed_mfactor = "m"; *)
M8 (net19, net011, net15, cds_globals.\vdd! );

pfet #(.w(160n), .l(16n), .nfin(1), .nf(1), .m(1))
(* integer passed_mfactor = "m"; *)
M7 (net15, D, cds_globals.\vdd! , cds_globals.\vdd! );

pfet #(.w(160n), .l(16n), .nfin(1), .nf(1), .m(1))
(* integer passed_mfactor = "m"; *)
M6 (net15, C, cds_globals.\vdd! , cds_globals.\vdd! );

pfet #(.w(160n), .l(16n), .nfin(1), .nf(1), .m(1))
(* integer passed_mfactor = "m"; *)
M5 (net15, B, cds_globals.\vdd! , cds_globals.\vdd! );

pfet #(.w(160n), .l(16n), .nfin(1), .nf(1), .m(1))
(* integer passed_mfactor = "m"; *)
M4 (net15, A, cds_globals.\vdd! , cds_globals.\vdd! );

pfet #(.w(320n), .l(16n), .nfin(1), .nf(1), .m(1))
(* integer passed_mfactor = "m"; *)
M3 (net19, D, net45, cds_globals.\vdd! );

pfet #(.w(320n), .l(16n), .nfin(1), .nf(1), .m(1))
(* integer passed_mfactor = "m"; *)
M2 (net45, C, net46, cds_globals.\vdd! );

pfet #(.w(320n), .l(16n), .nfin(1), .nf(1), .m(1))
(* integer passed_mfactor = "m"; *)
M1 (net46, B, net47, cds_globals.\vdd! );

pfet #(.w(320n), .l(16n), .nfin(1), .nf(1), .m(1))
(* integer passed_mfactor = "m"; *)
M0 (net47, A, cds_globals.\vdd! , cds_globals.\vdd! );

endmodule
// Library - 16nm, Cell - nor4_1x, View - schematic
// LAST TIME SAVED: Apr 24 03:03:59 2015
// NETLIST TIME: May 27 21:54:27 2015
`timescale 1ns / 1ns

(* cds_ams_schematic *)
module nor4_1x (Y, A, B, C, D);

output  Y;

input  A, B, C, D;

pfet #(.w(400n), .l(20n), .nfin(1), .nf(1), .m(1))
(* integer passed_mfactor = "m"; *)
M5 (net017, C, net21, cds_globals.\vdd! );

pfet #(.w(400n), .l(20n), .nfin(1), .nf(1), .m(1))
(* integer passed_mfactor = "m"; *)
M4 (Y, D, net017, cds_globals.\vdd! );

pfet #(.w(400n), .l(20n), .nfin(1), .nf(1), .m(1))
(* integer passed_mfactor = "m"; *)
M3 (net21, B, net018, cds_globals.\vdd! );

pfet #(.w(400n), .l(20n), .nfin(1), .nf(1), .m(1))
(* integer passed_mfactor = "m"; *)
M2 (net018, A, cds_globals.\vdd! , cds_globals.\vdd! );

nfet #(.w(60n), .l(20n), .nfin(1), .nf(1), .m(1))
(* integer passed_mfactor = "m"; *)
M7 (Y, D, cds_globals.\gnd! , cds_globals.\gnd! );

nfet #(.w(60n), .l(20n), .nfin(1), .nf(1), .m(1))
(* integer passed_mfactor = "m"; *)
M6 (Y, C, cds_globals.\gnd! , cds_globals.\gnd! );

nfet #(.w(60n), .l(20n), .nfin(1), .nf(1), .m(1))
(* integer passed_mfactor = "m"; *)
M1 (Y, A, cds_globals.\gnd! , cds_globals.\gnd! );

nfet #(.w(60n), .l(20n), .nfin(1), .nf(1), .m(1))
(* integer passed_mfactor = "m"; *)
M0 (Y, B, cds_globals.\gnd! , cds_globals.\gnd! );

endmodule
// Library - 16nm, Cell - or4_1x, View - schematic
// LAST TIME SAVED: Mar  3 21:07:15 2015
// NETLIST TIME: May 27 21:54:27 2015
`timescale 1ns / 1ns

(* cds_ams_schematic *)
module or4_1x (Y, A, B, C, D);

output  Y;

input  A, B, C, D;

nor4_1x I0 ( .D(D), .C(C), .A(A), .B(B), .Y(net11));

inv_1x I1 ( .Y(Y), .A(net11));

endmodule
// Library - 16nm, Cell - WCHB_Write, View - schematic
// LAST TIME SAVED: Apr 25 22:08:09 2015
// NETLIST TIME: May 27 21:54:27 2015
`timescale 1ns / 1ns

(* cds_ams_schematic *)
module WCHB_Write (Lack, Out0, Out1, In, Rack);

output  Lack;

output [1:0]  Out1;
output [1:0]  Out0;

input [1:0]  Rack;
input [3:0]  In;

// Buses in the design

wire  [0:3]  n;

wire  [0:1]  b0;

wire  [0:1]  b1;

wire  [0:1]  \~Out1 ;

wire  [0:1]  \~Out0 ;

TH22 I26 ( .Y(\~Out1 [1]), .B(Rack[1]), .A(b1[1]));

TH22 I7 ( .Y(\~Out1 [0]), .B(Rack[0]), .A(b1[0]));

TH22 I24 ( .Y(\~Out0 [1]), .B(Rack[1]), .A(b0[1]));

TH22 I6 ( .Y(\~Out0 [0]), .B(Rack[0]), .A(b0[0]));

TH22 I3 ( .Y(n[3]), .B(nxa), .A(In[3]));

TH22 I2 ( .Y(n[2]), .B(nxa), .A(In[2]));

TH22 I1 ( .Y(n[1]), .B(nxa), .A(In[1]));

TH22 I0 ( .Y(n[0]), .B(nxa), .A(In[0]));

inv_1x I30 ( .Y(Out1[1]), .A(\~Out1 [1]));

inv_1x I29 ( .Y(Out0[0]), .A(\~Out0 [0]));

inv_1x I31 ( .Y(Out0[1]), .A(\~Out0 [1]));

inv_1x I28 ( .Y(Out1[0]), .A(\~Out1 [0]));

or4_1x I12 ( .D(n[3]), .C(n[2]), .A(n[0]), .B(n[1]), .Y(Lack));

nor_1x I19 ( .Y(b1[0]), .B(n[1]), .A(n[3]));

nor_1x I22 ( .Y(b1[1]), .B(n[3]), .A(n[2]));

nor_1x I21 ( .Y(b0[1]), .B(n[1]), .A(n[0]));

nor_1x I20 ( .Y(b0[0]), .B(n[2]), .A(n[0]));

and4_1x I27 ( .D(\~Out0 [1]), .C(\~Out1 [1]), .A(\~Out1 [0]), .B(\~Out0
    [0]), .Y(nxa));

endmodule
// Library - 16nm, Cell - 6T_DATAb, View - schematic
// LAST TIME SAVED: May 24 19:27:52 2015
// NETLIST TIME: May 27 21:54:27 2015
`timescale 1ns / 1ns

(* cds_ams_schematic *)
module \6T_DATAb  (Ack, B0, B1, Go, Read_1of4[3:0], Read_1of4[7:4], W0,
    W1, WdataAck, AckThruBot, AckThruTop, RW, Reset, ValAddr, RdataAck,
    W1_1of4, W2_1of4, \~R0 , \~R1 );

output  Ack, Go;

inout  AckThruBot, AckThruTop, Reset, ValAddr;

output [3:0]  W0;
output [3:0]  W1;
output [7:0]  Read_1of4;
output [3:0]  B1;
output [3:0]  B0;
output [1:0]  WdataAck;

inout [1:0]  RW;

input [3:0]  \~R0 ;
input [1:0]  RdataAck;
input [3:0]  W1_1of4;
input [3:0]  \~R1 ;
input [3:0]  W2_1of4;

// Buses in the design

wire  [3:0]  R0;

wire  [3:0]  R1;

wire  [3:0]  nB1;

wire  [3:0]  nB0;

wire  [0:3]  wack;

wire  [3:0]  RpAck;

wire  [3:0]  R1q;

wire  [3:0]  R0q;

wire  [3:0]  Lack;

PCHBd IRPCHB_3 ( .\Ai+1 (RpAck[3]), .Ai(Lack[3]), .\R0i+1 (R0q[3]),
    .\R1i+1 (R1q[3]), .R0i(R0[3]), .R1i(R1[3]));

PCHBd IRPCHB_2 ( .\Ai+1 (RpAck[2]), .Ai(Lack[2]), .\R0i+1 (R0q[2]),
    .\R1i+1 (R1q[2]), .R0i(R0[2]), .R1i(R1[2]));

PCHBd IRPCHB_1 ( .\Ai+1 (RpAck[1]), .Ai(Lack[1]), .\R0i+1 (R0q[1]),
    .\R1i+1 (R1q[1]), .R0i(R0[1]), .R1i(R1[1]));

PCHBd IRPCHB_0 ( .\Ai+1 (RpAck[0]), .Ai(Lack[0]), .\R0i+1 (R0q[0]),
    .\R1i+1 (R1q[0]), .R0i(R0[0]), .R1i(R1[0]));

nand_1x I8 ( .Y(Ack), .B(intWack), .A(intRack));

PCHB_Write IWPCHB0_1 ( .B0(B0[1]), .B1(B1[1]), .W1(W1[1]),
    .Ai(wack[1]), .R0i(nB0[1]), .R1i(nB1[1]), .W0(W0[1]));

PCHB_Write IWPCHB0_0 ( .B0(B0[0]), .B1(B1[0]), .W1(W1[0]),
    .Ai(wack[0]), .R0i(nB0[0]), .R1i(nB1[0]), .W0(W0[0]));

PCHB_Write IWPCHB1_1 ( .B0(B0[3]), .B1(B1[3]), .W1(W1[3]),
    .Ai(wack[3]), .R0i(nB0[3]), .R1i(nB1[3]), .W0(W0[3]));

PCHB_Write IWPCHB1_0 ( .B0(B0[2]), .B1(B1[2]), .W1(W1[2]),
    .Ai(wack[2]), .R0i(nB0[2]), .R1i(nB1[2]), .W0(W0[2]));

and_1x I13_3 ( .Y(W0[3]), .B(B0[3]), .A(Wen));

and_1x I13_2 ( .Y(W0[2]), .B(B0[2]), .A(Wen));

and_1x I13_1 ( .Y(W0[1]), .B(B0[1]), .A(Wen));

and_1x I13_0 ( .Y(W0[0]), .B(B0[0]), .A(Wen));

and_1x I11_3 ( .Y(W1[3]), .B(B1[3]), .A(Wen));

and_1x I11_2 ( .Y(W1[2]), .B(B1[2]), .A(Wen));

and_1x I11_1 ( .Y(W1[1]), .B(B1[1]), .A(Wen));

and_1x I11_0 ( .Y(W1[0]), .B(B1[0]), .A(Wen));

pfet #(.w(100n), .l(20n), .nfin(1), .nf(1), .m(1))
(* integer passed_mfactor = "m"; *)
M0_3 (\~R1 [3], Go, cds_globals.\vdd! , cds_globals.\vdd! );

pfet #(.w(100n), .l(20n), .nfin(1), .nf(1), .m(1))
(* integer passed_mfactor = "m"; *)
M0_2 (\~R1 [2], Go, cds_globals.\vdd! , cds_globals.\vdd! );

pfet #(.w(100n), .l(20n), .nfin(1), .nf(1), .m(1))
(* integer passed_mfactor = "m"; *)
M0_1 (\~R1 [1], Go, cds_globals.\vdd! , cds_globals.\vdd! );

pfet #(.w(100n), .l(20n), .nfin(1), .nf(1), .m(1))
(* integer passed_mfactor = "m"; *)
M0_0 (\~R1 [0], Go, cds_globals.\vdd! , cds_globals.\vdd! );

pfet #(.w(100n), .l(20n), .nfin(1), .nf(1), .m(1))
(* integer passed_mfactor = "m"; *)
M1_3 (\~R0 [3], Go, cds_globals.\vdd! , cds_globals.\vdd! );

pfet #(.w(100n), .l(20n), .nfin(1), .nf(1), .m(1))
(* integer passed_mfactor = "m"; *)
M1_2 (\~R0 [2], Go, cds_globals.\vdd! , cds_globals.\vdd! );

pfet #(.w(100n), .l(20n), .nfin(1), .nf(1), .m(1))
(* integer passed_mfactor = "m"; *)
M1_1 (\~R0 [1], Go, cds_globals.\vdd! , cds_globals.\vdd! );

pfet #(.w(100n), .l(20n), .nfin(1), .nf(1), .m(1))
(* integer passed_mfactor = "m"; *)
M1_0 (\~R0 [0], Go, cds_globals.\vdd! , cds_globals.\vdd! );

inv_1x I4_3 ( .Y(R1[3]), .A(\~R1 [3]));

inv_1x I4_2 ( .Y(R1[2]), .A(\~R1 [2]));

inv_1x I4_1 ( .Y(R1[1]), .A(\~R1 [1]));

inv_1x I4_0 ( .Y(R1[0]), .A(\~R1 [0]));

inv_1x I6_3 ( .Y(R0[3]), .A(\~R0 [3]));

inv_1x I6_2 ( .Y(R0[2]), .A(\~R0 [2]));

inv_1x I6_1 ( .Y(R0[1]), .A(\~R0 [1]));

inv_1x I6_0 ( .Y(R0[0]), .A(\~R0 [0]));

iprobe I1 (AckThruBot, AckThruTop);

TH22 I9 ( .Y(Wen), .B(RW[0]), .A(ValAddr));

TH22 I7 ( .Y(Go), .B(RW[1]), .A(ValAddr));

WCHB_Read IRWCHB_1 ( .Out(Read_1of4[7:4]), .Rack(RdataAck[1]),
    .L0(R0q[3:2]), .L1(R1q[3:2]), .Lack(RpAck[3:2]));

WCHB_Read IRWCHB_0 ( .Out(Read_1of4[3:0]), .Rack(RdataAck[0]),
    .L0(R0q[1:0]), .L1(R1q[1:0]), .Lack(RpAck[1:0]));

\TH44~  I16 ( .D(wack[1]), .C(wack[3]), .A(wack[0]), .B(wack[2]),
    .Y(intWack));

\TH44~  I0 ( .D(Lack[0]), .C(Lack[1]), .A(Lack[3]), .B(Lack[2]),
    .Y(intRack));

WCHB_Write IWWCHB1 ( .Out0(nB0[3:2]), .Out1(nB1[3:2]),
    .Lack(WdataAck[1]), .Rack({wack[3], wack[2]}), .In(W2_1of4[3:0]));

WCHB_Write IWWCHB0 ( .Out0(nB0[1:0]), .Out1(nB1[1:0]),
    .Lack(WdataAck[0]), .Rack({wack[1], wack[0]}), .In(W1_1of4[3:0]));

endmodule
// Library - 16nm, Cell - Demux_2e1of4, View - schematic
// LAST TIME SAVED: Feb  3 01:32:33 2015
// NETLIST TIME: May 27 21:54:27 2015
`timescale 1ns / 1ns

(* cds_ams_schematic *)
module Demux_2e1of4 (A, \1of4_1 , \1of4_2 , En, EnOut);

input  En, EnOut;

output [15:0]  A;

input [3:0]  \1of4_1 ;
input [3:0]  \1of4_2 ;

and4_1x I15 ( .D(En), .C(EnOut), .A(\1of4_1 [3]), .B(\1of4_2 [3]),
    .Y(A[15]));

and4_1x I14 ( .D(En), .C(EnOut), .A(\1of4_1 [2]), .B(\1of4_2 [3]),
    .Y(A[14]));

and4_1x I13 ( .D(En), .C(EnOut), .A(\1of4_1 [1]), .B(\1of4_2 [3]),
    .Y(A[13]));

and4_1x I12 ( .D(En), .C(EnOut), .A(\1of4_1 [0]), .B(\1of4_2 [3]),
    .Y(A[12]));

and4_1x I11 ( .D(En), .C(EnOut), .A(\1of4_1 [3]), .B(\1of4_2 [2]),
    .Y(A[11]));

and4_1x I10 ( .D(En), .C(EnOut), .A(\1of4_1 [2]), .B(\1of4_2 [2]),
    .Y(A[10]));

and4_1x I9 ( .D(En), .C(EnOut), .A(\1of4_1 [1]), .B(\1of4_2 [2]),
    .Y(A[9]));

and4_1x I8 ( .D(En), .C(EnOut), .A(\1of4_1 [0]), .B(\1of4_2 [2]),
    .Y(A[8]));

and4_1x I7 ( .D(En), .C(EnOut), .A(\1of4_1 [3]), .B(\1of4_2 [1]),
    .Y(A[7]));

and4_1x I6 ( .D(En), .C(EnOut), .A(\1of4_1 [2]), .B(\1of4_2 [1]),
    .Y(A[6]));

and4_1x I5 ( .D(En), .C(EnOut), .A(\1of4_1 [1]), .B(\1of4_2 [1]),
    .Y(A[5]));

and4_1x I4 ( .D(En), .C(EnOut), .A(\1of4_1 [0]), .B(\1of4_2 [1]),
    .Y(A[4]));

and4_1x I3 ( .D(En), .C(EnOut), .A(\1of4_1 [3]), .B(\1of4_2 [0]),
    .Y(A[3]));

and4_1x I2 ( .D(En), .C(EnOut), .A(\1of4_1 [2]), .B(\1of4_2 [0]),
    .Y(A[2]));

and4_1x I1 ( .D(En), .C(EnOut), .A(\1of4_1 [1]), .B(\1of4_2 [0]),
    .Y(A[1]));

and4_1x I0 ( .D(En), .C(EnOut), .A(\1of4_1 [0]), .B(\1of4_2 [0]),
    .Y(A[0]));

endmodule
// Library - 16nm, Cell - or16_1x, View - schematic
// LAST TIME SAVED: Feb 19 23:25:58 2015
// NETLIST TIME: May 27 21:54:27 2015
`timescale 1ns / 1ns

(* cds_ams_schematic *)
module or16_1x (Y, X);

output  Y;

input [15:0]  X;

nand4_1x I2 ( .D(nX1512), .C(nX118), .A(nX30), .B(nX74), .Y(Y));

nor4_1x I0 ( .D(X[3]), .C(X[2]), .A(X[0]), .B(X[1]), .Y(nX30));

nor4_1x I1 ( .D(X[7]), .C(X[6]), .A(X[4]), .B(X[5]), .Y(nX74));

nor4_1x I3 ( .D(X[11]), .C(X[10]), .A(X[8]), .B(X[9]), .Y(nX118));

nor4_1x I4 ( .D(X[15]), .C(X[14]), .A(X[12]), .B(X[13]), .Y(nX1512));

endmodule
// Library - 16nm, Cell - Demux_3e1of4, View - schematic
// LAST TIME SAVED: Apr 18 21:45:09 2015
// NETLIST TIME: May 27 21:54:27 2015
`timescale 1ns / 1ns

(* cds_ams_schematic *)
module Demux_3e1of4 (A, AddrValid, \1of4_1 , \1of4_2 , \1of4_3 , En);

output  AddrValid;

input  En;

output [63:0]  A;

input [3:0]  \1of4_1 ;
input [3:0]  \1of4_2 ;
input [3:0]  \1of4_3 ;

Demux_2e1of4 I3 ( .En(En), .EnOut(\1of4_3 [3]), .A(A[63:48]), .\1of4_1
    (\1of4_1 [3:0]), .\1of4_2 (\1of4_2 [3:0]));

Demux_2e1of4 I2 ( .En(En), .EnOut(\1of4_3 [2]), .A(A[47:32]), .\1of4_1
    (\1of4_1 [3:0]), .\1of4_2 (\1of4_2 [3:0]));

Demux_2e1of4 I1 ( .En(En), .EnOut(\1of4_3 [1]), .A(A[31:16]), .\1of4_1
    (\1of4_1 [3:0]), .\1of4_2 (\1of4_2 [3:0]));

Demux_2e1of4 I0 ( .En(En), .EnOut(\1of4_3 [0]), .A(A[15:0]), .\1of4_1
    (\1of4_1 [3:0]), .\1of4_2 (\1of4_2 [3:0]));

or16_1x I8 ( .Y(net22), .X(A[63:48]));

or16_1x I7 ( .Y(net23), .X(A[47:32]));

or16_1x I6 ( .Y(net24), .X(A[31:16]));

or16_1x I17 ( .Y(net25), .X(A[15:0]));

or4_1x I11 ( .D(net22), .C(net23), .A(net25), .B(net24),
    .Y(AddrValid));

endmodule
// Library - 16nm, Cell - nor3_1x, View - schematic
// LAST TIME SAVED: Apr 24 03:03:49 2015
// NETLIST TIME: May 27 21:54:27 2015
`timescale 1ns / 1ns

(* cds_ams_schematic *)
module nor3_1x (Y, A, B, C);

output  Y;

input  A, B, C;

pfet #(.w(300n), .l(20n), .nfin(1), .nf(1), .m(1))
(* integer passed_mfactor = "m"; *)
M5 (Y, C, net21, cds_globals.\vdd! );

pfet #(.w(300n), .l(20n), .nfin(1), .nf(1), .m(1))
(* integer passed_mfactor = "m"; *)
M3 (net21, B, net018, cds_globals.\vdd! );

pfet #(.w(300n), .l(20n), .nfin(1), .nf(1), .m(1))
(* integer passed_mfactor = "m"; *)
M2 (net018, A, cds_globals.\vdd! , cds_globals.\vdd! );

nfet #(.w(60n), .l(20n), .nfin(1), .nf(1), .m(1))
(* integer passed_mfactor = "m"; *)
M6 (Y, C, cds_globals.\gnd! , cds_globals.\gnd! );

nfet #(.w(60n), .l(20n), .nfin(1), .nf(1), .m(1))
(* integer passed_mfactor = "m"; *)
M1 (Y, A, cds_globals.\gnd! , cds_globals.\gnd! );

nfet #(.w(60n), .l(20n), .nfin(1), .nf(1), .m(1))
(* integer passed_mfactor = "m"; *)
M0 (Y, B, cds_globals.\gnd! , cds_globals.\gnd! );

endmodule
// Library - 16nm, Cell - 6T_DEMUX_, View - schematic
// LAST TIME SAVED: Apr 18 21:16:00 2015
// NETLIST TIME: May 27 21:54:27 2015
`timescale 1ns / 1ns

(* cds_ams_schematic *)
module \6T_DEMUX_  (A, Ack, S, \1of4_1 , \1of4_2 , \1of4_3 , \1of4_4 ,
    En);

output  Ack;

input  En;

output [63:0]  A;
output [7:0]  S;

input [3:0]  \1of4_4 ;
input [3:0]  \1of4_1 ;
input [3:0]  \1of4_2 ;
input [3:0]  \1of4_3 ;

// Buses in the design

wire  [0:3]  net020;

Demux_3e1of4 I0 ( .AddrValid(Ack), .A(A[63:0]), .\1of4_1 (\1of4_1
    [3:0]), .\1of4_2 (\1of4_2 [3:0]), .\1of4_3 (\1of4_3 [3:0]),
    .En(En));

inv_1x I10_3 ( .Y(net020[0]), .A(\1of4_4 [3]));

inv_1x I10_2 ( .Y(net020[1]), .A(\1of4_4 [2]));

inv_1x I10_1 ( .Y(net020[2]), .A(\1of4_4 [1]));

inv_1x I10_0 ( .Y(net020[3]), .A(\1of4_4 [0]));

inv_1x I9 ( .Y(net015), .A(En));

inv_1x I6 ( .Y(net016), .A(En));

nor_1x I4 ( .Y(net23), .B(\1of4_3 [1]), .A(\1of4_3 [0]));

nor_1x I5 ( .Y(net22), .B(\1of4_3 [3]), .A(\1of4_3 [2]));

nor3_1x I1_3 ( .C(net016), .A(net020[0]), .B(net23), .Y(S[3]));

nor3_1x I1_2 ( .C(net016), .A(net020[1]), .B(net23), .Y(S[2]));

nor3_1x I1_1 ( .C(net016), .A(net020[2]), .B(net23), .Y(S[1]));

nor3_1x I1_0 ( .C(net016), .A(net020[3]), .B(net23), .Y(S[0]));

nor3_1x I2_3 ( .C(net015), .A(net020[0]), .B(net22), .Y(S[7]));

nor3_1x I2_2 ( .C(net015), .A(net020[1]), .B(net22), .Y(S[6]));

nor3_1x I2_1 ( .C(net015), .A(net020[2]), .B(net22), .Y(S[5]));

nor3_1x I2_0 ( .C(net015), .A(net020[3]), .B(net22), .Y(S[4]));

endmodule
// Library - 16nm, Cell - 6T_32x_CTRL, View - schematic
// LAST TIME SAVED: May 25 23:20:27 2015
// NETLIST TIME: May 27 21:54:26 2015
`timescale 1ns / 1ns

(* cds_ams_schematic *)
module \6T_32x_CTRL  (B0, B1, W0, W1, S);

inout  B0, B1, W0, W1;

input  S;

pfet #(.w(100n), .l(20n), .nfin(2), .nf(1), .m(1))
(* integer passed_mfactor = "m"; *)
M10 (B1, B0, net22, cds_globals.\vdd! );

pfet #(.w(100n), .l(20n), .nfin(2), .nf(1), .m(1))
(* integer passed_mfactor = "m"; *)
M9 (net22, W1, cds_globals.\vdd! , cds_globals.\vdd! );

pfet #(.w(100n), .l(20n), .nfin(2), .nf(1), .m(1))
(* integer passed_mfactor = "m"; *)
M8 (B0, B1, net23, cds_globals.\vdd! );

pfet #(.w(100n), .l(20n), .nfin(2), .nf(1), .m(1))
(* integer passed_mfactor = "m"; *)
M7 (net23, W0, cds_globals.\vdd! , cds_globals.\vdd! );

pfet #(.w(100n), .l(20n), .nfin(1), .nf(1), .m(1))
(* integer passed_mfactor = "m"; *)
M2 (B1, S, cds_globals.\vdd! , cds_globals.\vdd! );

pfet #(.w(100n), .l(20n), .nfin(1), .nf(1), .m(1))
(* integer passed_mfactor = "m"; *)
M0 (B0, S, cds_globals.\vdd! , cds_globals.\vdd! );

nfet #(.w(60n), .l(20n), .nfin(2), .nf(1), .m(1))
(* integer passed_mfactor = "m"; *)
M6 (B1, W1, net24, cds_globals.\gnd! );

nfet #(.w(60n), .l(20n), .nfin(2), .nf(1), .m(1))
(* integer passed_mfactor = "m"; *)
M5 (net24, S, cds_globals.\gnd! , cds_globals.\gnd! );

nfet #(.w(60n), .l(20n), .nfin(2), .nf(1), .m(1))
(* integer passed_mfactor = "m"; *)
M4 (net25, S, cds_globals.\gnd! , cds_globals.\gnd! );

nfet #(.w(60n), .l(20n), .nfin(2), .nf(1), .m(1))
(* integer passed_mfactor = "m"; *)
M3 (B0, W0, net25, cds_globals.\gnd! );

endmodule
// Library - 16nm_Tests, Cell - MC_6TWrite_Test, View - schematic
// LAST TIME SAVED: May 25 20:22:50 2015
// NETLIST TIME: May 27 21:54:28 2015
`timescale 1ns / 1ns

(* cds_ams_schematic *)
module MC_6TWrite_Test ();

// Buses in the design

wire  [3:0]  R1;

wire  [3:0]  WD1;

wire  [7:0]  S;

wire  [63:0]  Aline;

wire  [3:0]  B0;

wire  [0:3]  net33;

wire  [0:3]  net32;

wire  [1:0]  WdataAck;

wire  [1:0]  RW;

wire  [1:0]  RDataAck;

wire  [3:0]  WD2;

wire  [3:0]  W0;

wire  [3:0]  R2;

wire  [16:0]  A;

wire  [3:0]  B1;

wire  [3:0]  W1;

\6T_CHUNK  ICHUNK ( .S(S[7:0]), .A(Aline[63:0]), .\~R0 (net32[0:3]),
    .\~R1 (net33[0:3]), .B0(B0[3:0]), .B1(B1[3:0]), .Go(Go),
    .W0(W0[3:0]), .W1(W1[3:0]));

\6T_DATAb  I84 ( Ack, B0[3:0], B1[3:0], Go, R1[3:0], R2[3:0], W0[3:0],
    W1[3:0], WdataAck[1:0], net41, net40, RW[1:0], net42, ValAddr,
    RDataAck[1:0], WD1[3:0], WD2[3:0], net32[0:3], net33[0:3]);

\6T_DEMUX_  I85 ( .Ack(ValAddr), .A(Aline[63:0]), .S(S[7:0]), .\1of4_1
    (A[3:0]), .\1of4_2 (A[7:4]), .\1of4_3 (A[11:8]), .\1of4_4
    (A[15:12]), .En(A[16]));

vsource #(.dc(cds_globals.vdd), .type("dc")) V0 (cds_globals.\vcc! ,
    cds_globals.\gnd! );

vsource #(.dc(cds_globals.vdd), .type("dc")) V1 (cds_globals.\vdd! ,
    cds_globals.\gnd! );

Write_Testbench_verilog I83 ( .A(A[16:0]), .RDataAck(RDataAck[1:0]),
    .RW(RW[1:0]), .W1(WD1[3:0]), .W2(WD2[3:0]), .Ack(Ack),
    .R1(R1[3:0]), .R2(R2[3:0]), .VDD(cds_globals.\vcc! ),
    .VSS(cds_globals.\gnd! ), .WdataAck(WdataAck[1:0]));

endmodule
// Library - 16nm, Cell - nand4_1x, View - schematic
// LAST TIME SAVED: Apr 23 17:51:26 2015
// NETLIST TIME: May 27 21:54:26 2015
`timescale 1ns / 1ns

(* cds_ams_schematic *)
module nand4_1x (Y, A, B, C, D);

output  Y;

input  A, B, C, D;

pfet #(.w(100n), .l(20n), .nfin(1), .nf(1), .m(1))
(* integer passed_mfactor = "m"; *)
M5 (Y, D, cds_globals.\vdd! , cds_globals.\vdd! );

pfet #(.w(100n), .l(20n), .nfin(1), .nf(1), .m(1))
(* integer passed_mfactor = "m"; *)
M4 (Y, C, cds_globals.\vdd! , cds_globals.\vdd! );

pfet #(.w(100n), .l(20n), .nfin(1), .nf(1), .m(1))
(* integer passed_mfactor = "m"; *)
M1 (Y, B, cds_globals.\vdd! , cds_globals.\vdd! );

pfet #(.w(100n), .l(20n), .nfin(1), .nf(1), .m(1))
(* integer passed_mfactor = "m"; *)
M0 (Y, A, cds_globals.\vdd! , cds_globals.\vdd! );

nfet #(.w(240n), .l(20n), .nfin(1), .nf(1), .m(1))
(* integer passed_mfactor = "m"; *)
M7 (net23, D, cds_globals.\gnd! , cds_globals.\gnd! );

nfet #(.w(240n), .l(20n), .nfin(1), .nf(1), .m(1))
(* integer passed_mfactor = "m"; *)
M6 (net25, C, net23, cds_globals.\gnd! );

nfet #(.w(240n), .l(20n), .nfin(1), .nf(1), .m(1))
(* integer passed_mfactor = "m"; *)
M3 (net24, B, net25, cds_globals.\gnd! );

nfet #(.w(240n), .l(20n), .nfin(1), .nf(1), .m(1))
(* integer passed_mfactor = "m"; *)
M2 (Y, A, net24, cds_globals.\gnd! );

endmodule
// Library - 16nm, Cell - 6T_32x4, View - schematic
// LAST TIME SAVED: May 25 23:31:16 2015
// NETLIST TIME: May 27 21:54:26 2015
`timescale 1ns / 1ns

(* cds_ams_schematic *)
module \6T_32x4  (SM0, SM1, A, B0, B1, S, W0, W1);

output  SM0, SM1;

inout  B0, B1, W0, W1;

inout [31:0]  A;
inout [3:0]  S;

\6T_32x  ISRAM3 ( .A(A[31:0]), .B0(B0P4), .B1(B1P4));

\6T_32x  ISRAM1 ( .A(A[31:0]), .B0(B0P2), .B1(B1P2));

\6T_32x  ISRAM2 ( .A(A[31:0]), .B0(B0P3), .B1(B1P3));

\6T_32x  ISRAM0 ( .A(A[31:0]), .B0(B0P1), .B1(B1P1));

nfet #(.w(60n), .l(20n), .nfin(1), .nf(1), .m(1))
(* integer passed_mfactor = "m"; *)
M1 (B0P1, B0, net67, cds_globals.\gnd! );

nfet #(.w(60n), .l(20n), .nfin(1), .nf(1), .m(1))
(* integer passed_mfactor = "m"; *)
M0 (net67, S[0], cds_globals.\gnd! , cds_globals.\gnd! );

nfet #(.w(60n), .l(20n), .nfin(1), .nf(1), .m(1))
(* integer passed_mfactor = "m"; *)
M3 (net66, S[0], cds_globals.\gnd! , cds_globals.\gnd! );

nfet #(.w(60n), .l(20n), .nfin(1), .nf(1), .m(1))
(* integer passed_mfactor = "m"; *)
M10 (B1P2, B1, net65, cds_globals.\gnd! );

nfet #(.w(60n), .l(20n), .nfin(1), .nf(1), .m(1))
(* integer passed_mfactor = "m"; *)
M9 (net65, S[1], cds_globals.\gnd! , cds_globals.\gnd! );

nfet #(.w(60n), .l(20n), .nfin(1), .nf(1), .m(1))
(* integer passed_mfactor = "m"; *)
M6 (net64, S[1], cds_globals.\gnd! , cds_globals.\gnd! );

nfet #(.w(60n), .l(20n), .nfin(1), .nf(1), .m(1))
(* integer passed_mfactor = "m"; *)
M7 (B0P2, B0, net64, cds_globals.\gnd! );

nfet #(.w(60n), .l(20n), .nfin(1), .nf(1), .m(1))
(* integer passed_mfactor = "m"; *)
M13 (B0P3, B0, net63, cds_globals.\gnd! );

nfet #(.w(60n), .l(20n), .nfin(1), .nf(1), .m(1))
(* integer passed_mfactor = "m"; *)
M12 (net63, S[2], cds_globals.\gnd! , cds_globals.\gnd! );

nfet #(.w(60n), .l(20n), .nfin(1), .nf(1), .m(1))
(* integer passed_mfactor = "m"; *)
M15 (net62, S[2], cds_globals.\gnd! , cds_globals.\gnd! );

nfet #(.w(60n), .l(20n), .nfin(1), .nf(1), .m(1))
(* integer passed_mfactor = "m"; *)
M16 (B1P3, B1, net62, cds_globals.\gnd! );

nfet #(.w(60n), .l(20n), .nfin(1), .nf(1), .m(1))
(* integer passed_mfactor = "m"; *)
M22 (B1P4, B1, net61, cds_globals.\gnd! );

nfet #(.w(60n), .l(20n), .nfin(1), .nf(1), .m(1))
(* integer passed_mfactor = "m"; *)
M21 (net61, S[3], cds_globals.\gnd! , cds_globals.\gnd! );

nfet #(.w(60n), .l(20n), .nfin(1), .nf(1), .m(1))
(* integer passed_mfactor = "m"; *)
M18 (net60, S[3], cds_globals.\gnd! , cds_globals.\gnd! );

nfet #(.w(60n), .l(20n), .nfin(1), .nf(1), .m(1))
(* integer passed_mfactor = "m"; *)
M19 (B0P4, B0, net60, cds_globals.\gnd! );

nfet #(.w(60n), .l(20n), .nfin(1), .nf(1), .m(1))
(* integer passed_mfactor = "m"; *)
M4 (B1P1, B1, net66, cds_globals.\gnd! );

\6T_32x_CTRL  I4 ( .W1(W1), .W0(W0), .S(S[0]), .B0(B0P1), .B1(B1P1));

\6T_32x_CTRL  I11 ( .W1(W1), .W0(W0), .S(S[1]), .B0(B0P2), .B1(B1P2));

\6T_32x_CTRL  I20 ( .W1(W1), .W0(W0), .S(S[2]), .B0(B0P3), .B1(B1P3));

\6T_32x_CTRL  I27 ( .W1(W1), .W0(W0), .S(S[3]), .B0(B0P4), .B1(B1P4));

nand4_1x I16 ( .D(B1P4), .C(B1P3), .A(B1P1), .B(B1P2), .Y(SM1));

nand4_1x I13 ( .D(B0P4), .C(B0P3), .A(B0P1), .B(B0P2), .Y(SM0));

pfet #(.w(100n), .l(20n), .nfin(1), .nf(1), .m(1))
(* integer passed_mfactor = "m"; *)
M5 (B1P1, S[0], cds_globals.\vdd! , cds_globals.\vdd! );

pfet #(.w(100n), .l(20n), .nfin(1), .nf(1), .m(1))
(* integer passed_mfactor = "m"; *)
M2 (B0P1, S[0], cds_globals.\vdd! , cds_globals.\vdd! );

pfet #(.w(100n), .l(20n), .nfin(1), .nf(1), .m(1))
(* integer passed_mfactor = "m"; *)
M11 (B1P2, S[1], cds_globals.\vdd! , cds_globals.\vdd! );

pfet #(.w(100n), .l(20n), .nfin(1), .nf(1), .m(1))
(* integer passed_mfactor = "m"; *)
M8 (B0P2, S[1], cds_globals.\vdd! , cds_globals.\vdd! );

pfet #(.w(100n), .l(20n), .nfin(1), .nf(1), .m(1))
(* integer passed_mfactor = "m"; *)
M17 (B1P3, S[2], cds_globals.\vdd! , cds_globals.\vdd! );

pfet #(.w(100n), .l(20n), .nfin(1), .nf(1), .m(1))
(* integer passed_mfactor = "m"; *)
M14 (B0P3, S[2], cds_globals.\vdd! , cds_globals.\vdd! );

pfet #(.w(100n), .l(20n), .nfin(1), .nf(1), .m(1))
(* integer passed_mfactor = "m"; *)
M20 (B0P4, S[3], cds_globals.\vdd! , cds_globals.\vdd! );

pfet #(.w(100n), .l(20n), .nfin(1), .nf(1), .m(1))
(* integer passed_mfactor = "m"; *)
M23 (B1P4, S[3], cds_globals.\vdd! , cds_globals.\vdd! );

capacitor #(.c(1.2822f)) C7 (B1P4, cds_globals.\gnd! );

capacitor #(.c(1.2822f)) C3 (B1P2, cds_globals.\gnd! );

capacitor #(.c(1.2822f)) C5 (B1P3, cds_globals.\gnd! );

capacitor #(.c(1.2822f)) C6 (B0P4, cds_globals.\gnd! );

capacitor #(.c(1.2822f)) C4 (B0P3, cds_globals.\gnd! );

capacitor #(.c(1.2822f)) C2 (B0P2, cds_globals.\gnd! );

capacitor #(.c(1.2822f)) C1 (B1P1, cds_globals.\gnd! );

capacitor #(.c(1.2822f)) C0 (B0P1, cds_globals.\gnd! );

endmodule
// Library - 16nm, Cell - 6T_SetRead, View - schematic
// LAST TIME SAVED: May 25 23:31:31 2015
// NETLIST TIME: May 27 21:54:26 2015
`timescale 1ns / 1ns

(* cds_ams_schematic *)
module \6T_SetRead  (\~R0 , \~R1 , Go, SM0[0], SM0[1], SM1[0], SM1[1]);

output  \~R0 , \~R1 ;

input  Go;

input [0:1]  SM0;
input [0:1]  SM1;

nfet #(.w(40n), .l(16n), .nfin(1), .nf(1), .m(1))
(* integer passed_mfactor = "m"; *)
M5 (\~R0 , SM0[0], net18, cds_globals.\gnd! );

nfet #(.w(40n), .l(16n), .nfin(1), .nf(1), .m(1))
(* integer passed_mfactor = "m"; *)
M3 (\~R0 , SM0[1], net18, cds_globals.\gnd! );

nfet #(.w(40n), .l(16n), .nfin(1), .nf(1), .m(1))
(* integer passed_mfactor = "m"; *)
M2 (net18, Go, cds_globals.\gnd! , cds_globals.\gnd! );

nfet #(.w(40n), .l(16n), .nfin(1), .nf(1), .m(1))
(* integer passed_mfactor = "m"; *)
M1 (\~R1 , SM1[1], net18, cds_globals.\gnd! );

nfet #(.w(40n), .l(16n), .nfin(1), .nf(1), .m(1))
(* integer passed_mfactor = "m"; *)
M0 (\~R1 , SM1[0], net18, cds_globals.\gnd! );

endmodule
// Library - 16nm, Cell - 6T_CHUNK, View - schematic
// LAST TIME SAVED: May 24 22:57:48 2015
// NETLIST TIME: May 27 21:54:27 2015
`timescale 1ns / 1ns

(* cds_ams_schematic *)
module \6T_CHUNK  (A, B0, B1, Go, S, W0, W1, \~R0 , \~R1 );

inout  Go;

inout [7:0]  S;
inout [3:0]  W1;
inout [3:0]  B1;
inout [3:0]  B0;
inout [3:0]  \~R0 ;
inout [3:0]  \~R1 ;
inout [3:0]  W0;
inout [63:0]  A;

\6T_32x4  IARRAY7 ( .S(S[7:4]), .A(A[63:32]), .W0(W0[3]), .W1(W1[3]),
    .SM0(SM0_1_bit3), .SM1(SM1_1_bit3), .B0(B0[3]), .B1(B1[3]));

\6T_32x4  IARRAY6 ( .S(S[7:4]), .A(A[63:32]), .W0(W0[2]), .W1(W1[2]),
    .SM0(SM0_1_bit2), .SM1(SM1_1_bit2), .B0(B0[2]), .B1(B1[2]));

\6T_32x4  IARRAY5 ( .S(S[7:4]), .A(A[63:32]), .W0(W0[1]), .W1(W1[1]),
    .SM0(SM0_1_bit1), .SM1(SM1_1_bit1), .B0(B0[1]), .B1(B1[1]));

\6T_32x4  IARRAY4 ( .S(S[7:4]), .A(A[63:32]), .W0(W0[0]), .W1(W1[0]),
    .SM0(SM0_1_bit0), .SM1(SM1_1_bit0), .B0(B0[0]), .B1(B1[0]));

\6T_32x4  IARRAY3 ( .S(S[3:0]), .A(A[31:0]), .W0(W0[3]), .W1(W1[3]),
    .SM0(SM0_0_bit3), .SM1(SM1_0_bit3), .B0(B0[3]), .B1(B1[3]));

\6T_32x4  IARRAY2 ( .S(S[3:0]), .A(A[31:0]), .W0(W0[2]), .W1(W1[2]),
    .SM0(SM0_0_bit2), .SM1(SM1_0_bit2), .B0(B0[2]), .B1(B1[2]));

\6T_32x4  IARRAY1 ( .S(S[3:0]), .A(A[31:0]), .W0(W0[1]), .W1(W1[1]),
    .SM0(SM0_0_bit1), .SM1(SM1_0_bit1), .B0(B0[1]), .B1(B1[1]));

\6T_32x4  IARRAY0 ( .S(S[3:0]), .A(A[31:0]), .W0(W0[0]), .W1(W1[0]),
    .SM0(SM0_0_bit0), .SM1(SM1_0_bit0), .B0(B0[0]), .B1(B1[0]));

\6T_SetRead  I7 ( \~R0 [3], \~R1 [3], Go, SM0_0_bit3, SM0_1_bit3,
    SM1_0_bit3, SM1_1_bit3);

\6T_SetRead  I6 ( \~R0 [2], \~R1 [2], Go, SM0_0_bit2, SM0_1_bit2,
    SM1_0_bit2, SM1_1_bit2);

\6T_SetRead  I5 ( \~R0 [1], \~R1 [1], Go, SM0_0_bit1, SM0_1_bit1,
    SM1_0_bit1, SM1_1_bit1);

\6T_SetRead  I4 ( \~R0 [0], \~R1 [0], Go, SM0_0_bit0, SM0_1_bit0,
    SM1_0_bit0, SM1_1_bit0);

endmodule
// Library - 16nm, Cell - inv_1x, View - schematic
// LAST TIME SAVED: Apr 29 23:24:48 2015
// NETLIST TIME: May 27 21:54:27 2015
`timescale 1ns / 1ns

(* cds_ams_schematic *)
module inv_1x (Y, A);

output  Y;

input  A;

nfet #(.w(60n), .l(20n), .nfin(1), .nf(1), .m(1))
(* integer passed_mfactor = "m"; *)
M0 (Y, A, cds_globals.\gnd! , cds_globals.\gnd! );

pfet #(.w(100n), .l(20n), .nfin(1), .nf(1), .m(1))
(* integer passed_mfactor = "m"; *)
M1 (Y, A, cds_globals.\vdd! , cds_globals.\vdd! );

endmodule
// Library - 16nm, Cell - nand_1x, View - schematic
// LAST TIME SAVED: Apr  9 20:40:36 2015
// NETLIST TIME: May 27 21:54:27 2015
`timescale 1ns / 1ns

(* cds_ams_schematic *)
module nand_1x (Y, A, B);

output  Y;

input  A, B;

pfet #(.w(100n), .l(20n), .nfin(1), .nf(1), .m(1))
(* integer passed_mfactor = "m"; *)
M1 (Y, B, cds_globals.\vdd! , cds_globals.\vdd! );

pfet #(.w(100n), .l(20n), .nfin(1), .nf(1), .m(1))
(* integer passed_mfactor = "m"; *)
M0 (Y, A, cds_globals.\vdd! , cds_globals.\vdd! );

nfet #(.w(120n), .l(20n), .nfin(1), .nf(1), .m(1))
(* integer passed_mfactor = "m"; *)
M3 (net22, B, cds_globals.\gnd! , cds_globals.\gnd! );

nfet #(.w(120n), .l(20n), .nfin(1), .nf(1), .m(1))
(* integer passed_mfactor = "m"; *)
M2 (Y, A, net22, cds_globals.\gnd! );

endmodule
