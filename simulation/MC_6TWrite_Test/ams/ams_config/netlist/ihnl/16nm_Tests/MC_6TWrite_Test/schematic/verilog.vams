// Verilog-AMS netlist generated by the AMS netlister, version  IC6.1.6.500.10 .
// Cadence Design Systems, Inc.

`include "disciplines.vams"
`include "userDisciplines.vams"

(* cds_ams_schematic *)
module MC_6TWrite_Test (  );

wire [3:0] W1_1;
wire [3:0] B1_1;
wire [63:0] Aline;
wire [0:3] net15;
wire [3:0] \~R1_1 ;
wire [3:0] \~R0_1 ;
wire [7:0] S;

\6T_CHUNK  (*
integer library_binding = "16nm";
 *)
ICHUNK ( .B1(
B1_1[3:0] ), .B0( { cds_globals.\gnd! ,
 cds_globals.\gnd! , cds_globals.\gnd! , cds_globals.\gnd!  } ), .A(
Aline[63:0] ), .Go( cds_globals.\gnd!  ), .W1( W1_1[3:0] ), .W0( { cds_globals.\gnd! ,
 cds_globals.\gnd! , cds_globals.\gnd! , cds_globals.\gnd!  } ), .S(
S[7:0] ), .\~R1 ( \~R1_1 [3:0] ), .\~R0 ( \~R0_1 [3:0] ) );

pfet #(.m(1), .nf(1), .w(100n), .nfin(1), .l(20n)) (*
integer
library_binding = "NCSU_TechLib_FreePDK15";
integer passed_mfactor
 = "m";
integer elaboration_binding = "M0[3:0]";
 *)
M0_3 ( \~R1_1 [3],
net15[0], cds_globals.\vdd! , cds_globals.\vdd!  ),
  M0_2 ( \~R1_1 [2], net15[1], cds_globals.\vdd! , cds_globals.\vdd!  ),
  M0_1 ( \~R1_1 [1], net15[2], cds_globals.\vdd! , cds_globals.\vdd!  ),
  M0_0 ( \~R1_1 [0], net15[3], cds_globals.\vdd! , cds_globals.\vdd!  );
pfet #(.m(1), .nf(1), .w(100n), .nfin(1), .l(20n)) (*
integer
library_binding = "NCSU_TechLib_FreePDK15";
integer passed_mfactor
 = "m";
integer elaboration_binding = "M1[3:0]";
 *)
M1_3 ( \~R0_1 [3],
net15[0], cds_globals.\vdd! , cds_globals.\vdd!  ),
  M1_2 ( \~R0_1 [2], net15[1], cds_globals.\vdd! , cds_globals.\vdd!  ),
  M1_1 ( \~R0_1 [1], net15[2], cds_globals.\vdd! , cds_globals.\vdd!  ),
  M1_0 ( \~R0_1 [0], net15[3], cds_globals.\vdd! , cds_globals.\vdd!  );

vsource #(.mag(0), .wave({0,0,cds_globals.time2,0,cds_globals.time3,cds_globals.vdd,cds_globals.time4,cds_globals.vdd,cds_globals.time5,0}),
 .phase(0), .type("pwl")) (*
integer library_binding = "analogLib";

 *)
V2 ( Aline[0], cds_globals.\gnd!  );
vsource #(.mag(0), .wave({0,0,cds_globals.time2,0,cds_globals.time3,cds_globals.vdd,cds_globals.time4,cds_globals.vdd,cds_globals.time5,0}),
 .phase(0), .type("pwl")) (*
integer library_binding = "analogLib";

integer elaboration_binding = "V7[3:0]";
 *)
V7_3 ( B1_1[3],
cds_globals.\gnd!  ),
  V7_2 ( B1_1[2], cds_globals.\gnd!  ),
  V7_1 ( B1_1[1], cds_globals.\gnd!  ),
  V7_0 ( B1_1[0], cds_globals.\gnd!  );
vsource #(.mag(0), .wave({0,0,cds_globals.time2,0,cds_globals.time3,cds_globals.vdd,cds_globals.time4,cds_globals.vdd,cds_globals.time5,0}),
 .phase(0), .type("pwl")) (*
integer library_binding = "analogLib";

integer elaboration_binding = "V8[3:0]";
 *)
V8_3 ( W1_1[3],
cds_globals.\gnd!  ),
  V8_2 ( W1_1[2], cds_globals.\gnd!  ),
  V8_1 ( W1_1[1], cds_globals.\gnd!  ),
  V8_0 ( W1_1[0], cds_globals.\gnd!  );
vsource #(.mag(0), .wave({0,0,cds_globals.time2,0,cds_globals.time3,cds_globals.vdd,cds_globals.time4,cds_globals.vdd,cds_globals.time5,0}),
 .phase(0), .type("pwl")) (*
integer library_binding = "analogLib";

 *)
V6 ( S[0], cds_globals.\gnd!  );

vsource #(.type("dc"), .dc(cds_globals.vdd)) (*
integer
library_binding = "analogLib";
 *)
V0 ( cds_globals.\vcc! ,
cds_globals.\gnd!  );
vsource #(.type("dc"), .dc(cds_globals.vdd)) (*
integer
library_binding = "analogLib";
 *)
V1 ( cds_globals.\vdd! ,
cds_globals.\gnd!  );

inv_1x (*
integer library_binding = "16nm";
integer
elaboration_binding = "I4[3:0]";
 *)
I4_3 ( .Y( cds_globals.\gnd!  ),
.A( \~R1_1 [3] ) ),
  I4_2 ( .Y( cds_globals.\gnd!  ), .A( \~R1_1 [2] ) ),
  I4_1 ( .Y( cds_globals.\gnd!  ), .A( \~R1_1 [1] ) ),
  I4_0 ( .Y( cds_globals.\gnd!  ), .A( \~R1_1 [0] ) );
inv_1x (*
integer library_binding = "16nm";
integer
elaboration_binding = "I6[3:0]";
 *)
I6_3 ( .Y( cds_globals.\gnd!  ),
.A( \~R0_1 [3] ) ),
  I6_2 ( .Y( cds_globals.\gnd!  ), .A( \~R0_1 [2] ) ),
  I6_1 ( .Y( cds_globals.\gnd!  ), .A( \~R0_1 [1] ) ),
  I6_0 ( .Y( cds_globals.\gnd!  ), .A( \~R0_1 [0] ) );

endmodule
