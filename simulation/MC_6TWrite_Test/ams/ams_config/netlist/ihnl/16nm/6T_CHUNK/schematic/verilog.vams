// Verilog-AMS netlist generated by the AMS netlister, version  IC6.1.6.500.10 .
// Cadence Design Systems, Inc.

`include "disciplines.vams"
`include "userDisciplines.vams"

(* cds_ams_schematic *)
module \6T_CHUNK  ( \~R0 ,\~R1 ,A,B0,B1,S,W0,
W1,Go );

inout [3:0]  \~R0 ;
inout [3:0]  \~R1 ;
inout [63:0]  A;
inout [3:0]
 B0;
inout [3:0]  B1;
inout [7:0]  S;
inout [3:0]  W0;
inout [3:0]
 W1;
inout   Go;

parameter wp_grid=0;
parameter MinW="";
parameter pDLEcell="";
parameter \ln ="";
parameter MinL="";
parameter lp_grid=0;
parameter ModelType="system";
parameter lp="";
parameter wn="";
parameter wp="";
parameter pModel="pmos";
parameter ln_grid=0;
parameter nModel="nmos";
parameter wp_microns="";
parameter nDLEcell="";
parameter wn_microns="";
parameter bn="gnd!";
parameter wn_grid=0;
parameter bp="vdd!";

\6T_32x4  (*
integer library_binding = "16nm";
 *)
IARRAY7 ( .SM0(
SM0_1_bit3 ), .SM1( SM1_1_bit3 ), .B1( B1[3] ), .B0( B0[3] ), .A(
A[63:32] ), .W1( W1[3] ), .W0( W0[3] ), .S( S[7:4] ) );
\6T_32x4  (*
integer library_binding = "16nm";
 *)
IARRAY6 ( .SM0(
SM0_1_bit2 ), .SM1( SM1_1_bit2 ), .B1( B1[2] ), .B0( B0[2] ), .A(
A[63:32] ), .W1( W1[2] ), .W0( W0[2] ), .S( S[7:4] ) );
\6T_32x4  (*
integer library_binding = "16nm";
 *)
IARRAY5 ( .SM0(
SM0_1_bit1 ), .SM1( SM1_1_bit1 ), .B1( B1[1] ), .B0( B0[1] ), .A(
A[63:32] ), .W1( W1[1] ), .W0( W0[1] ), .S( S[7:4] ) );
\6T_32x4  (*
integer library_binding = "16nm";
 *)
IARRAY4 ( .SM0(
SM0_1_bit0 ), .SM1( SM1_1_bit0 ), .B1( B1[0] ), .B0( B0[0] ), .A(
A[63:32] ), .W1( W1[0] ), .W0( W0[0] ), .S( S[7:4] ) );
\6T_32x4  (*
integer library_binding = "16nm";
 *)
IARRAY3 ( .SM0(
SM0_0_bit3 ), .SM1( SM1_0_bit3 ), .B1( B1[3] ), .B0( B0[3] ), .A(
A[31:0] ), .W1( W1[3] ), .W0( W0[3] ), .S( S[3:0] ) );
\6T_32x4  (*
integer library_binding = "16nm";
 *)
IARRAY2 ( .SM0(
SM0_0_bit2 ), .SM1( SM1_0_bit2 ), .B1( B1[2] ), .B0( B0[2] ), .A(
A[31:0] ), .W1( W1[2] ), .W0( W0[2] ), .S( S[3:0] ) );
\6T_32x4  (*
integer library_binding = "16nm";
 *)
IARRAY1 ( .SM0(
SM0_0_bit1 ), .SM1( SM1_0_bit1 ), .B1( B1[1] ), .B0( B0[1] ), .A(
A[31:0] ), .W1( W1[1] ), .W0( W0[1] ), .S( S[3:0] ) );
\6T_32x4  (*
integer library_binding = "16nm";
 *)
IARRAY0 ( .SM0(
SM0_0_bit0 ), .SM1( SM1_0_bit0 ), .B1( B1[0] ), .B0( B0[0] ), .A(
A[31:0] ), .W1( W1[0] ), .W0( W0[0] ), .S( S[3:0] ) );

\6T_SetRead  (*
integer library_binding = "16nm";
 *)
I7 ( .SM0( { SM0_1_bit3,
SM0_0_bit3 } ), .SM1( { SM1_1_bit3,SM1_0_bit3 } ), .Go( Go ), .\~R1 (
\~R1 [3] ), .\~R0 ( \~R0 [3] ) );
\6T_SetRead  (*
integer library_binding = "16nm";
 *)
I6 ( .SM0( { SM0_1_bit2,
SM0_0_bit2 } ), .SM1( { SM1_1_bit2,SM1_0_bit2 } ), .Go( Go ), .\~R1 (
\~R1 [2] ), .\~R0 ( \~R0 [2] ) );
\6T_SetRead  (*
integer library_binding = "16nm";
 *)
I5 ( .SM0( { SM0_1_bit1,
SM0_0_bit1 } ), .SM1( { SM1_1_bit1,SM1_0_bit1 } ), .Go( Go ), .\~R1 (
\~R1 [1] ), .\~R0 ( \~R0 [1] ) );
\6T_SetRead  (*
integer library_binding = "16nm";
 *)
I4 ( .SM0( { SM0_1_bit0,
SM0_0_bit0 } ), .SM1( { SM1_1_bit0,SM1_0_bit0 } ), .Go( Go ), .\~R1 (
\~R1 [0] ), .\~R0 ( \~R0 [0] ) );

endmodule
