// Verilog-AMS netlist generated by the AMS netlister, version  IC6.1.6.500.10 .
// Cadence Design Systems, Inc.

`include "disciplines.vams"
`include "userDisciplines.vams"

(* cds_ams_schematic *)
module \6T_4x  ( A,B0,B1 );

inout [3:0]  A;
inout   B0;
inout   B1;

parameter wp_grid=0;
parameter MinW="";
parameter pDLEcell="";
parameter \ln ="";
parameter MinL="";
parameter lp_grid=0;
parameter ModelType="system";
parameter lp="";
parameter wn="";
parameter wp="";
parameter pModel="pmos";
parameter ln_grid=0;
parameter nModel="nmos";
parameter wp_microns="";
parameter nDLEcell="";
parameter wn_microns="";
parameter bn="gnd!";
parameter wn_grid=0;
parameter bp="vdd!";

\6T  (*
integer library_binding = "16nm";
 *)
I3 ( .B1( B1 ), .B0( B0 ),
.A( A[0] ) );
\6T  (*
integer library_binding = "16nm";
 *)
I2 ( .B1( B1 ), .B0( B0 ),
.A( A[1] ) );
\6T  (*
integer library_binding = "16nm";
 *)
I1 ( .B1( B1 ), .B0( B0 ),
.A( A[2] ) );
\6T  (*
integer library_binding = "16nm";
 *)
I0 ( .B1( B1 ), .B0( B0 ),
.A( A[3] ) );

endmodule
