// Verilog-AMS netlist generated by the AMS netlister, version  IC6.1.6.500.10 .
// Cadence Design Systems, Inc.

`include "disciplines.vams"
`include "userDisciplines.vams"

(* cds_ams_schematic *)
module \6T_32x_CTRL  ( B0,B1,S,W0,W1 );

inout   B0;
inout   B1;
input   S;
inout   W0;
inout   W1;

parameter wp_grid=0;
parameter MinW="";
parameter pDLEcell="";
parameter \ln ="";
parameter MinL="";
parameter lp_grid=0;
parameter ModelType="system";
parameter lp="";
parameter wn="";
parameter wp="";
parameter pModel="pmos";
parameter ln_grid=0;
parameter nModel="nmos";
parameter wp_microns="";
parameter nDLEcell="";
parameter wn_microns="";
parameter bn="gnd!";
parameter wn_grid=0;
parameter bp="vdd!";

pfet #(.m(1), .nf(1), .w(100n), .nfin(1), .l(20n)) (*
integer
library_binding = "NCSU_TechLib_FreePDK15";
integer passed_mfactor
 = "m";
 *)
M10 ( B1, B0, net22, cds_globals.\vdd!  );
pfet #(.m(1), .nf(1), .w(100n), .nfin(1), .l(20n)) (*
integer
library_binding = "NCSU_TechLib_FreePDK15";
integer passed_mfactor
 = "m";
 *)
M9 ( net22, W1, cds_globals.\vdd! , cds_globals.\vdd!  );
pfet #(.m(1), .nf(1), .w(100n), .nfin(1), .l(20n)) (*
integer
library_binding = "NCSU_TechLib_FreePDK15";
integer passed_mfactor
 = "m";
 *)
M8 ( B0, B1, net23, cds_globals.\vdd!  );
pfet #(.m(1), .nf(1), .w(100n), .nfin(1), .l(20n)) (*
integer
library_binding = "NCSU_TechLib_FreePDK15";
integer passed_mfactor
 = "m";
 *)
M7 ( net23, W0, cds_globals.\vdd! , cds_globals.\vdd!  );
pfet #(.m(1), .nf(1), .w(100n), .nfin(1), .l(20n)) (*
integer
library_binding = "NCSU_TechLib_FreePDK15";
integer passed_mfactor
 = "m";
 *)
M2 ( B1, S, cds_globals.\vdd! , cds_globals.\vdd!  );
pfet #(.m(1), .nf(1), .w(100n), .nfin(1), .l(20n)) (*
integer
library_binding = "NCSU_TechLib_FreePDK15";
integer passed_mfactor
 = "m";
 *)
M0 ( B0, S, cds_globals.\vdd! , cds_globals.\vdd!  );

nfet #(.m(1), .nf(1), .w(60n), .nfin(1), .l(20n)) (*
integer
library_binding = "NCSU_TechLib_FreePDK15";
integer passed_mfactor
 = "m";
 *)
M6 ( B1, W1, net24, cds_globals.\gnd!  );
nfet #(.m(1), .nf(1), .w(60n), .nfin(1), .l(20n)) (*
integer
library_binding = "NCSU_TechLib_FreePDK15";
integer passed_mfactor
 = "m";
 *)
M5 ( net24, S, cds_globals.\gnd! , cds_globals.\gnd!  );
nfet #(.m(1), .nf(1), .w(60n), .nfin(1), .l(20n)) (*
integer
library_binding = "NCSU_TechLib_FreePDK15";
integer passed_mfactor
 = "m";
 *)
M4 ( net25, S, cds_globals.\gnd! , cds_globals.\gnd!  );
nfet #(.m(1), .nf(1), .w(60n), .nfin(1), .l(20n)) (*
integer
library_binding = "NCSU_TechLib_FreePDK15";
integer passed_mfactor
 = "m";
 *)
M3 ( B0, W0, net25, cds_globals.\gnd!  );

endmodule
