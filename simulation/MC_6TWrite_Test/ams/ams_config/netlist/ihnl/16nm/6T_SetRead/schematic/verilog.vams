// Verilog-AMS netlist generated by the AMS netlister, version  IC6.1.6.500.10 .
// Cadence Design Systems, Inc.

`include "disciplines.vams"
`include "userDisciplines.vams"

(* cds_ams_schematic *)
module \6T_SetRead  ( \~R0 ,\~R1 ,Go,SM0,SM1 );

output   \~R0 ;
output   \~R1 ;
input   Go;
input [1:0]  SM0;

input [1:0]  SM1;

parameter wp_grid=0;
parameter MinW="";
parameter pDLEcell="";
parameter \ln ="";
parameter MinL="";
parameter lp_grid=0;
parameter ModelType="system";
parameter lp="";
parameter wn="";
parameter wp="";
parameter pModel="pmos";
parameter ln_grid=0;
parameter nModel="nmos";
parameter wp_microns="";
parameter nDLEcell="";
parameter wn_microns="";
parameter bn="gnd!";
parameter wn_grid=0;
parameter bp="vdd!";

nfet #(.m(1), .nf(1), .w(40n), .nfin(1), .l(16n)) (*
integer
library_binding = "NCSU_TechLib_FreePDK15";
integer passed_mfactor
 = "m";
 *)
M5 ( \~R0 , SM0[0], net18, cds_globals.\gnd!  );
nfet #(.m(1), .nf(1), .w(40n), .nfin(1), .l(16n)) (*
integer
library_binding = "NCSU_TechLib_FreePDK15";
integer passed_mfactor
 = "m";
 *)
M3 ( \~R0 , SM0[1], net18, cds_globals.\gnd!  );
nfet #(.m(1), .nf(1), .w(40n), .nfin(1), .l(16n)) (*
integer
library_binding = "NCSU_TechLib_FreePDK15";
integer passed_mfactor
 = "m";
 *)
M2 ( net18, Go, cds_globals.\gnd! , cds_globals.\gnd!  );
nfet #(.m(1), .nf(1), .w(40n), .nfin(1), .l(16n)) (*
integer
library_binding = "NCSU_TechLib_FreePDK15";
integer passed_mfactor
 = "m";
 *)
M1 ( \~R1 , SM1[1], net18, cds_globals.\gnd!  );
nfet #(.m(1), .nf(1), .w(40n), .nfin(1), .l(16n)) (*
integer
library_binding = "NCSU_TechLib_FreePDK15";
integer passed_mfactor
 = "m";
 *)
M0 ( \~R1 , SM1[0], net18, cds_globals.\gnd!  );

endmodule
