// Verilog-AMS netlist generated by the AMS netlister, version  IC6.1.6.500.10 .
// Cadence Design Systems, Inc.

`include "disciplines.vams"
`include "userDisciplines.vams"

(* cds_ams_schematic *)
module nand4_1x ( Y,A,B,C,D );

output   Y;
input   A;
input   B;
input   C;
input   D;

parameter wp_grid=0;
parameter MinW="";
parameter pDLEcell="";
parameter \ln ="";
parameter MinL="";
parameter lp_grid=0;
parameter ModelType="system";
parameter lp="";
parameter wn="";
parameter wp="";
parameter pModel="pmos";
parameter ln_grid=0;
parameter nModel="nmos";
parameter wp_microns="";
parameter nDLEcell="";
parameter wn_microns="";
parameter bn="gnd!";
parameter wn_grid=0;
parameter bp="vdd!";

pfet #(.m(1), .nf(1), .w(100n), .nfin(1), .l(20n)) (*
integer
library_binding = "NCSU_TechLib_FreePDK15";
integer passed_mfactor
 = "m";
 *)
M5 ( Y, D, cds_globals.\vdd! , cds_globals.\vdd!  );
pfet #(.m(1), .nf(1), .w(100n), .nfin(1), .l(20n)) (*
integer
library_binding = "NCSU_TechLib_FreePDK15";
integer passed_mfactor
 = "m";
 *)
M4 ( Y, C, cds_globals.\vdd! , cds_globals.\vdd!  );
pfet #(.m(1), .nf(1), .w(100n), .nfin(1), .l(20n)) (*
integer
library_binding = "NCSU_TechLib_FreePDK15";
integer passed_mfactor
 = "m";
 *)
M1 ( Y, B, cds_globals.\vdd! , cds_globals.\vdd!  );
pfet #(.m(1), .nf(1), .w(100n), .nfin(1), .l(20n)) (*
integer
library_binding = "NCSU_TechLib_FreePDK15";
integer passed_mfactor
 = "m";
 *)
M0 ( Y, A, cds_globals.\vdd! , cds_globals.\vdd!  );

nfet #(.m(1), .nf(1), .w(240n), .nfin(1), .l(20n)) (*
integer
library_binding = "NCSU_TechLib_FreePDK15";
integer passed_mfactor
 = "m";
 *)
M7 ( net23, D, cds_globals.\gnd! , cds_globals.\gnd!  );
nfet #(.m(1), .nf(1), .w(240n), .nfin(1), .l(20n)) (*
integer
library_binding = "NCSU_TechLib_FreePDK15";
integer passed_mfactor
 = "m";
 *)
M6 ( net25, C, net23, cds_globals.\gnd!  );
nfet #(.m(1), .nf(1), .w(240n), .nfin(1), .l(20n)) (*
integer
library_binding = "NCSU_TechLib_FreePDK15";
integer passed_mfactor
 = "m";
 *)
M3 ( net24, B, net25, cds_globals.\gnd!  );
nfet #(.m(1), .nf(1), .w(240n), .nfin(1), .l(20n)) (*
integer
library_binding = "NCSU_TechLib_FreePDK15";
integer passed_mfactor
 = "m";
 *)
M2 ( Y, A, net24, cds_globals.\gnd!  );

endmodule
