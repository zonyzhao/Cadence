// Verilog-AMS netlist generated by the AMS netlister, version  IC6.1.6.500.10 .
// Cadence Design Systems, Inc.

`include "disciplines.vams"
`include "userDisciplines.vams"

(* cds_ams_schematic *)
module \6T_32x4  ( SM0,SM1,B1,B0,A,W1,W0,S );

output   SM0;
output   SM1;
inout   B1;
inout   B0;
inout [31:0]  A;

inout   W1;
inout   W0;
inout [3:0]  S;

wire B0_nandC;
wire B0_Pass2;
wire B0_nandB;
wire B1_Pass1;
wire B1_Pass0;
wire B1_nandA;
wire B1_Pass3;
wire B1_nandC;
wire B1_Pass2;
wire B1_nandB;
wire B1_nandD;
wire B0_nandD;
wire B0_Pass1;
wire B0_nandA;
wire B0_Pass0;
wire B0_Pass3;

parameter wp_grid=0;
parameter MinW="";
parameter pDLEcell="";
parameter \ln ="";
parameter MinL="";
parameter lp_grid=0;
parameter ModelType="system";
parameter lp="";
parameter wn="";
parameter wp="";
parameter pModel="pmos";
parameter ln_grid=0;
parameter nModel="nmos";
parameter wp_microns="";
parameter nDLEcell="";
parameter wn_microns="";
parameter bn="gnd!";
parameter wn_grid=0;
parameter bp="vdd!";

cds_alias #(.width(1)) (*
integer library_binding = "basic";
integer
view_binding = "functional";
 *)
ams_alias_inst_0 (B0_nandC, B0P3);
cds_alias #(.width(1)) (*
integer library_binding = "basic";
integer
view_binding = "functional";
 *)
ams_alias_inst_1 (B0_Pass2, B0P3);
cds_alias #(.width(1)) (*
integer library_binding = "basic";
integer
view_binding = "functional";
 *)
ams_alias_inst_2 (B0_nandB, B0P2);
cds_alias #(.width(1)) (*
integer library_binding = "basic";
integer
view_binding = "functional";
 *)
ams_alias_inst_3 (B1_Pass1, B1P2);
cds_alias #(.width(1)) (*
integer library_binding = "basic";
integer
view_binding = "functional";
 *)
ams_alias_inst_4 (B1_Pass0, B1P1);
cds_alias #(.width(1)) (*
integer library_binding = "basic";
integer
view_binding = "functional";
 *)
ams_alias_inst_5 (B1_nandA, B1P1);
cds_alias #(.width(1)) (*
integer library_binding = "basic";
integer
view_binding = "functional";
 *)
ams_alias_inst_6 (B1_Pass3, B1P4);
cds_alias #(.width(1)) (*
integer library_binding = "basic";
integer
view_binding = "functional";
 *)
ams_alias_inst_7 (B1_nandC, B1P3);
cds_alias #(.width(1)) (*
integer library_binding = "basic";
integer
view_binding = "functional";
 *)
ams_alias_inst_8 (B1_Pass2, B1P3);
cds_alias #(.width(1)) (*
integer library_binding = "basic";
integer
view_binding = "functional";
 *)
ams_alias_inst_9 (B1_nandB, B1P2);
cds_alias #(.width(1)) (*
integer library_binding = "basic";
integer
view_binding = "functional";
 *)
ams_alias_inst_10 (B1_nandD, B1P4);
cds_alias #(.width(1)) (*
integer library_binding = "basic";
integer
view_binding = "functional";
 *)
ams_alias_inst_11 (B0_nandD, B0P4);
cds_alias #(.width(1)) (*
integer library_binding = "basic";
integer
view_binding = "functional";
 *)
ams_alias_inst_12 (B0_Pass1, B0P2);
cds_alias #(.width(1)) (*
integer library_binding = "basic";
integer
view_binding = "functional";
 *)
ams_alias_inst_13 (B0_nandA, B0P1);
cds_alias #(.width(1)) (*
integer library_binding = "basic";
integer
view_binding = "functional";
 *)
ams_alias_inst_14 (B0_Pass0, B0P1);
cds_alias #(.width(1)) (*
integer library_binding = "basic";
integer
view_binding = "functional";
 *)
ams_alias_inst_15 (B0_Pass3, B0P4);

\6T_32x  (*
integer library_binding = "16nm";
 *)
ISRAM3 ( .B1( B1P4 ),
.B0( B0P4 ), .A( A[31:0] ) );
\6T_32x  (*
integer library_binding = "16nm";
 *)
ISRAM1 ( .B1( B1P2 ),
.B0( B0P2 ), .A( A[31:0] ) );
\6T_32x  (*
integer library_binding = "16nm";
 *)
ISRAM2 ( .B1( B1P3 ),
.B0( B0P3 ), .A( A[31:0] ) );
\6T_32x  (*
integer library_binding = "16nm";
 *)
ISRAM0 ( .B1( B1P1 ),
.B0( B0P1 ), .A( A[31:0] ) );

nfet #(.m(1), .nf(1), .w(60n), .nfin(1), .l(20n)) (*
integer
library_binding = "NCSU_TechLib_FreePDK15";
integer passed_mfactor
 = "m";
 *)
M1 ( B0P1, B0, net67, cds_globals.\gnd!  );
nfet #(.m(1), .nf(1), .w(60n), .nfin(1), .l(20n)) (*
integer
library_binding = "NCSU_TechLib_FreePDK15";
integer passed_mfactor
 = "m";
 *)
M0 ( net67, S[0], cds_globals.\gnd! , cds_globals.\gnd!  );
nfet #(.m(1), .nf(1), .w(60n), .nfin(1), .l(20n)) (*
integer
library_binding = "NCSU_TechLib_FreePDK15";
integer passed_mfactor
 = "m";
 *)
M3 ( net66, S[0], cds_globals.\gnd! , cds_globals.\gnd!  );
nfet #(.m(1), .nf(1), .w(60n), .nfin(1), .l(20n)) (*
integer
library_binding = "NCSU_TechLib_FreePDK15";
integer passed_mfactor
 = "m";
 *)
M10 ( B1P2, B1, net65, cds_globals.\gnd!  );
nfet #(.m(1), .nf(1), .w(60n), .nfin(1), .l(20n)) (*
integer
library_binding = "NCSU_TechLib_FreePDK15";
integer passed_mfactor
 = "m";
 *)
M9 ( net65, S[1], cds_globals.\gnd! , cds_globals.\gnd!  );
nfet #(.m(1), .nf(1), .w(60n), .nfin(1), .l(20n)) (*
integer
library_binding = "NCSU_TechLib_FreePDK15";
integer passed_mfactor
 = "m";
 *)
M6 ( net64, S[1], cds_globals.\gnd! , cds_globals.\gnd!  );
nfet #(.m(1), .nf(1), .w(60n), .nfin(1), .l(20n)) (*
integer
library_binding = "NCSU_TechLib_FreePDK15";
integer passed_mfactor
 = "m";
 *)
M7 ( B0P2, B0, net64, cds_globals.\gnd!  );
nfet #(.m(1), .nf(1), .w(60n), .nfin(1), .l(20n)) (*
integer
library_binding = "NCSU_TechLib_FreePDK15";
integer passed_mfactor
 = "m";
 *)
M13 ( B0P3, B0, net63, cds_globals.\gnd!  );
nfet #(.m(1), .nf(1), .w(60n), .nfin(1), .l(20n)) (*
integer
library_binding = "NCSU_TechLib_FreePDK15";
integer passed_mfactor
 = "m";
 *)
M12 ( net63, S[2], cds_globals.\gnd! , cds_globals.\gnd!  );
nfet #(.m(1), .nf(1), .w(60n), .nfin(1), .l(20n)) (*
integer
library_binding = "NCSU_TechLib_FreePDK15";
integer passed_mfactor
 = "m";
 *)
M15 ( net62, S[2], cds_globals.\gnd! , cds_globals.\gnd!  );
nfet #(.m(1), .nf(1), .w(60n), .nfin(1), .l(20n)) (*
integer
library_binding = "NCSU_TechLib_FreePDK15";
integer passed_mfactor
 = "m";
 *)
M16 ( B1P3, B1, net62, cds_globals.\gnd!  );
nfet #(.m(1), .nf(1), .w(60n), .nfin(1), .l(20n)) (*
integer
library_binding = "NCSU_TechLib_FreePDK15";
integer passed_mfactor
 = "m";
 *)
M22 ( B1P4, B1, net61, cds_globals.\gnd!  );
nfet #(.m(1), .nf(1), .w(60n), .nfin(1), .l(20n)) (*
integer
library_binding = "NCSU_TechLib_FreePDK15";
integer passed_mfactor
 = "m";
 *)
M21 ( net61, S[3], cds_globals.\gnd! , cds_globals.\gnd!  );
nfet #(.m(1), .nf(1), .w(60n), .nfin(1), .l(20n)) (*
integer
library_binding = "NCSU_TechLib_FreePDK15";
integer passed_mfactor
 = "m";
 *)
M18 ( net60, S[3], cds_globals.\gnd! , cds_globals.\gnd!  );
nfet #(.m(1), .nf(1), .w(60n), .nfin(1), .l(20n)) (*
integer
library_binding = "NCSU_TechLib_FreePDK15";
integer passed_mfactor
 = "m";
 *)
M19 ( B0P4, B0, net60, cds_globals.\gnd!  );
nfet #(.m(1), .nf(1), .w(60n), .nfin(1), .l(20n)) (*
integer
library_binding = "NCSU_TechLib_FreePDK15";
integer passed_mfactor
 = "m";
 *)
M4 ( B1P1, B1, net66, cds_globals.\gnd!  );

\6T_32x_CTRL  (*
integer library_binding = "16nm";
 *)
I4 ( .B1( B1P1 ),
.B0( B0P1 ), .W1( W1 ), .W0( W0 ), .S( S[0] ) );
\6T_32x_CTRL  (*
integer library_binding = "16nm";
 *)
I11 ( .B1( B1P2 ),
.B0( B0P2 ), .W1( W1 ), .W0( W0 ), .S( S[1] ) );
\6T_32x_CTRL  (*
integer library_binding = "16nm";
 *)
I20 ( .B1( B1P3 ),
.B0( B0P3 ), .W1( W1 ), .W0( W0 ), .S( S[2] ) );
\6T_32x_CTRL  (*
integer library_binding = "16nm";
 *)
I27 ( .B1( B1P4 ),
.B0( B0P4 ), .W1( W1 ), .W0( W0 ), .S( S[3] ) );

nand4_1x (*
integer library_binding = "16nm";
 *)
I16 ( .Y( SM1 ), .A(
B1P1 ), .B( B1P2 ), .C( B1P3 ), .D( B1P4 ) );
nand4_1x (*
integer library_binding = "16nm";
 *)
I13 ( .Y( SM0 ), .A(
B0P1 ), .B( B0P2 ), .C( B0P3 ), .D( B0P4 ) );

pfet #(.m(1), .nf(1), .w(100n), .nfin(1), .l(20n)) (*
integer
library_binding = "NCSU_TechLib_FreePDK15";
integer passed_mfactor
 = "m";
 *)
M5 ( B1P1, S[0], cds_globals.\vdd! , cds_globals.\vdd!  );
pfet #(.m(1), .nf(1), .w(100n), .nfin(1), .l(20n)) (*
integer
library_binding = "NCSU_TechLib_FreePDK15";
integer passed_mfactor
 = "m";
 *)
M2 ( B0P1, S[0], cds_globals.\vdd! , cds_globals.\vdd!  );
pfet #(.m(1), .nf(1), .w(100n), .nfin(1), .l(20n)) (*
integer
library_binding = "NCSU_TechLib_FreePDK15";
integer passed_mfactor
 = "m";
 *)
M11 ( B1P2, S[1], cds_globals.\vdd! , cds_globals.\vdd!  );
pfet #(.m(1), .nf(1), .w(100n), .nfin(1), .l(20n)) (*
integer
library_binding = "NCSU_TechLib_FreePDK15";
integer passed_mfactor
 = "m";
 *)
M8 ( B0P2, S[1], cds_globals.\vdd! , cds_globals.\vdd!  );
pfet #(.m(1), .nf(1), .w(100n), .nfin(1), .l(20n)) (*
integer
library_binding = "NCSU_TechLib_FreePDK15";
integer passed_mfactor
 = "m";
 *)
M17 ( B1P3, S[2], cds_globals.\vdd! , cds_globals.\vdd!  );
pfet #(.m(1), .nf(1), .w(100n), .nfin(1), .l(20n)) (*
integer
library_binding = "NCSU_TechLib_FreePDK15";
integer passed_mfactor
 = "m";
 *)
M14 ( B0P3, S[2], cds_globals.\vdd! , cds_globals.\vdd!  );
pfet #(.m(1), .nf(1), .w(100n), .nfin(1), .l(20n)) (*
integer
library_binding = "NCSU_TechLib_FreePDK15";
integer passed_mfactor
 = "m";
 *)
M20 ( B0P4, S[3], cds_globals.\vdd! , cds_globals.\vdd!  );
pfet #(.m(1), .nf(1), .w(100n), .nfin(1), .l(20n)) (*
integer
library_binding = "NCSU_TechLib_FreePDK15";
integer passed_mfactor
 = "m";
 *)
M23 ( B1P4, S[3], cds_globals.\vdd! , cds_globals.\vdd!  );

capacitor #(.c(1.2822f)) (*
integer library_binding = "analogLib";

 *)
C7 ( B1P4, cds_globals.\gnd!  );
capacitor #(.c(1.2822f)) (*
integer library_binding = "analogLib";

 *)
C3 ( B1P2, cds_globals.\gnd!  );
capacitor #(.c(1.2822f)) (*
integer library_binding = "analogLib";

 *)
C5 ( B1P3, cds_globals.\gnd!  );
capacitor #(.c(1.2822f)) (*
integer library_binding = "analogLib";

 *)
C6 ( B0P4, cds_globals.\gnd!  );
capacitor #(.c(1.2822f)) (*
integer library_binding = "analogLib";

 *)
C4 ( B0P3, cds_globals.\gnd!  );
capacitor #(.c(1.2822f)) (*
integer library_binding = "analogLib";

 *)
C2 ( B0P2, cds_globals.\gnd!  );
capacitor #(.c(1.2822f)) (*
integer library_binding = "analogLib";

 *)
C1 ( B1P1, cds_globals.\gnd!  );
capacitor #(.c(1.2822f)) (*
integer library_binding = "analogLib";

 *)
C0 ( B0P1, cds_globals.\gnd!  );

endmodule
