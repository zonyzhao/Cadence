// Verilog-AMS netlist generated by the AMS netlister, version  IC6.1.6.500.10 .
// Cadence Design Systems, Inc.

`include "disciplines.vams"
`include "userDisciplines.vams"

(* cds_ams_schematic *)
module \6T_32x  ( B0,B1,A );

inout   B0;
inout   B1;
inout [31:0]  A;

parameter wp_grid=0;
parameter MinW="";
parameter pDLEcell="";
parameter \ln ="";
parameter MinL="";
parameter lp_grid=0;
parameter ModelType="system";
parameter lp="";
parameter wn="";
parameter wp="";
parameter pModel="pmos";
parameter ln_grid=0;
parameter nModel="nmos";
parameter wp_microns="";
parameter nDLEcell="";
parameter wn_microns="";
parameter bn="gnd!";
parameter wn_grid=0;
parameter bp="vdd!";

\6T_4x  (*
integer library_binding = "16nm";
 *)
I7 ( .B1( B1 ), .B0(
B0 ), .A( A[3:0] ) );
\6T_4x  (*
integer library_binding = "16nm";
 *)
I6 ( .B1( B1 ), .B0(
B0 ), .A( A[7:4] ) );
\6T_4x  (*
integer library_binding = "16nm";
 *)
I5 ( .B1( B1 ), .B0(
B0 ), .A( A[11:8] ) );
\6T_4x  (*
integer library_binding = "16nm";
 *)
I4 ( .B1( B1 ), .B0(
B0 ), .A( A[15:12] ) );
\6T_4x  (*
integer library_binding = "16nm";
 *)
I3 ( .B1( B1 ), .B0(
B0 ), .A( A[19:16] ) );
\6T_4x  (*
integer library_binding = "16nm";
 *)
I2 ( .B1( B1 ), .B0(
B0 ), .A( A[23:20] ) );
\6T_4x  (*
integer library_binding = "16nm";
 *)
I1 ( .B1( B1 ), .B0(
B0 ), .A( A[27:24] ) );
\6T_4x  (*
integer library_binding = "16nm";
 *)
I0 ( .B1( B1 ), .B0(
B0 ), .A( A[31:28] ) );

endmodule
