// Connect Rules file for connectLib/ConnRules_18V_full_fast1
// Generated by ADE.
// Cadence Design Systems, Inc.

// This is an autoGenerated file, any changes done to this file may get lost.

`include "disciplines.vams"
`include "userDisciplines.vams"

`define CONNRULES_18V_FULL_FAST
 `define CONNRULES_18V_FULL
 `define CONNRULES_18V_MID
 `define CONNRULES_18V_BASIC
 `define CONNRULES_FULL_FAST
 `define CONNRULES_FULL
 `define CONNRULES_MID
 `define CONNRULES_BASIC
 `define Vsup  1.8
 `define Vthi  1.2
 `define Vtlo  0.6
 `define Vlow  0
 `define Tr    0.2n
 `define Rlo   200
 `define Rhi   200
 `define Rx    40
 `define Rz    10M
 `define Vdelta      `Vsup/64
 `define Vdelta_tol  `Vdelta/4
 `define Tr_delta    `Tr/20
 `define rsupply     4
 `define rpull       1.5e3
 `define rlarge      9.0e3
 `define rweak       5.5e4
 `define rmedium     3.2e5
 `define rsmall      1.9e6

connectrules ConnRules_18V_full_fast1;
  connect L2E_2
      #( .vsup(0.5), .vlo(`Vlow), .tr(10p), .tf(10p), .rlo(`Rlo), .rhi(`Rhi), .rx(`Rx), .rz(`Rz), .r_SUPPLY(`rsupply), .r_PULL(`rpull), .r_LARGE(`rlarge), .r_WEAK(`rweak), .r_MEDIUM(`rmedium), .r_SMALL(`rsmall));
  connect E2L_2
      #( .vsup(0.5), .vthi(0.35), .vtlo(0.15), .tr(10p));
  connect Bidir_2
      #( .vsup(0.5), .vthi(0.35), .vtlo(0.15), .vlo(`Vlow), .tr(10p), .tf(10p), .rlo(`Rlo), .rhi(`Rhi), .rx(`Rx), .rz(`Rz), .r_SUPPLY(`rsupply), .r_PULL(`rpull), .r_LARGE(`rlarge), .r_WEAK(`rweak), .r_MEDIUM(`rmedium), .r_SMALL(`rsmall));
  connect E2R
      #( .vdelta(`Vdelta), .vtol(`Vdelta_tol), .ttol(`Tr_delta));
  connect R2E_2
      #( .vsup(0.5), .vdelta(`Vdelta), .tr(10p), .tf(10p), .rout(`Rlo));
  connect ER_bidir
      #( .vdelta(`Vdelta), .vtol(`Vdelta_tol), .ttol(`Tr_delta), .tr(10p), .tf(10p), .rout(`Rlo), .rz(`Rz));
  connect R2L
      #( .vsup(0.5), .vlo(`Vlow), .vtlo(0.15), .vthi(0.35)) logic, logic;
  connect L2R
      #( .vsup(0.5), .vlo(`Vlow)) logic, logic;
  connect RL_bidir
      #( .vsup(0.5), .vlo(`Vlow), .vtlo(0.15), .vthi(0.35)) logic, logic;
  connect L2E_2_LPS
      #( .vsup(0.5), .vlo(`Vlow), .tr(10p), .tf(10p), .rlo(`Rlo), .rhi(`Rhi), .rx(`Rx), .rz(`Rz));
  connect Bidir_2_LPS
      #( .vsup(0.5), .vthi(0.35), .vtlo(0.15), .tr(10p), .tf(10p), .rlo(`Rlo), .rhi(`Rhi), .rx(`Rx), .rz(`Rz));
  connect E2L_2_LPS
      #( .vsup(0.5), .vthi(0.35), .vtlo(0.15), .tr(10p));
  connect R2L_LPS
      #( .vsup(0.5), .vlo(`Vlow), .vtlo(0.15), .vthi(0.35)) logic, logic;
  connect L2R_LPS
      #( .vsup(0.5), .vlo(`Vlow)) logic, logic;
  connect RL_Bidir_LPS
      #( .vsup(0.5), .vlo(`Vlow), .vtlo(0.15), .vthi(0.35)) logic, logic;
  connect E2R_LPS
      #( .vdelta(`Vdelta), .vtol(`Vdelta_tol), .ttol(`Tr_delta));
  connect R2E_2_LPS
      #( .vsup(0.5), .vdelta(`Vdelta), .tr(10p), .tf(10p), .rout(`Rlo));
  connect ER_Bidir_LPS
      #( .vdelta(`Vdelta), .vtol(`Vdelta_tol), .ttol(`Tr_delta), .tr(10p), .tf(10p), .rout(`Rlo), .rz(`Rz));
endconnectrules
