simulator( 'spectre )
hostMode( 'distributed )
design(	 "/net/kafka/nfs/rstdenis/Cadence/simulation/20nm/Dual_Supply_Test/spectre/schematic/netlist/netlist")
resultsDir( "/net/kafka/nfs/rstdenis/Cadence/simulation/20nm/Dual_Supply_Test/spectre/schematic" )
modelFile(
    '("/software/cadence/ncsu-FreePDK15/hspice_16nm_hp.include" "")
)
analysis('tran ?stop "VAR(\"timeStop\")"  ?errpreset "conservative"  )
desVar(	  "nfin" 62	)
desVar(	  "VDDH" .600	)
desVar(	  "VDDL" .450	)
desVar(	  "timeStop" 32n	)
desVar(	  "period" 14n	)
desVar(	  "pulseWidth" 7n	)
desVar(	  "startDelay" 5n	)
desVar(	  "C" 596.31f	)
envOption(
	'cmd64bit  t
	'analysisOrder  list("tran")
)
option(	'multithread  "on"
)
save( 'v "/VH" "/VL" "/Vline" )
save( 'i "/ILine/src" "/IVDDH/src" "/IVDDL/dst" )
converge( 'ic "/I19/I0/I0/I7/I3/Q0" "0" )
converge( 'ic "/I19/I0/I0/I7/I3/Q1" "VDDL" )
temp( 27 )
;paramAnalysis("nfin" ?values '(12 18 24 30 36 42 48 54 60 66 72 78 84 90 96 102 108 114 120 126 132 138 144 150 156 162 168 174 180 186 192 198 204 210 216 222 228 234 240 246 252 ))
;paramRun( ?jobName "job" ?queue "c2107" )
selectResult( 'tran )

cVline = clip(v("/Vline" ?result "tran") clipStart VAR("timeStop"))
clipStart = (1.25 * VAR("period"))
vDiff = (VAR("VDDH") - VAR("VDDL"))
tFallSettleStart = cross(clip(v("/VH" ?result "tran") clipStart VAR("timeStop")) (0.5 * VAR("VDDH")) 1 "rising")
tFallSettleEnd = cross(cVline (1.005 * VAR("VDDL")) 1 "falling")
tFallStart = cross(cVline (VAR("VDDH") - (0.1 * vDiff)) 1 "falling")
tFallEnd = cross(cVline (VAR("VDDH") - (0.9 * vDiff)) 1 "falling")
tLeakageEnd = (clipStart + (0.51 * VAR("period")))
tLeakageStart = (clipStart + (0.49 * VAR("period")))
tRiseEnd = cross(cVline (VAR("VDDL") + (0.9 * vDiff)) 1 "rising")
tRiseSettleEnd = cross(cVline (0.99 * VAR("VDDH")) 1 "rising")
tRiseSettleStart = cross(clip(v("/VH" ?result "tran") clipStart VAR("timeStop")) (0.5 * VAR("VDDH")) 1 "falling")
tRiseStart = cross(cVline (VAR("VDDL") + (0.1 * vDiff)) 1 "rising")
tTPFallEnd = cross(cVline (VAR("VDDH") - (0.5 * vDiff)) 1 "falling")
tTPRiseEnd = cross(cVline (VAR("VDDL") + (0.5 * vDiff)) 1 "rising")

LeakageIntoVDDL = average(clip(i("/IVDDL/dst" ?result "tran") tLeakageStart tLeakageEnd))
LeakageLine 		= average(clip(i("/ILine/src" ?result "tran") tLeakageStart tLeakageEnd))
LeakageVDDH 		= average(clip(i("/IVDDH/src" ?result "tran") tLeakageStart tLeakageEnd))
QFall_pVDDL 		= ymax(iinteg(clip(i("/IVDDL/dst" ?result "tran") tFallSettleStart tFallSettleEnd)))
QRise_pVDDH 		= ymax(iinteg(clip(i("/IVDDH/src" ?result "tran") tRiseSettleStart tRiseSettleEnd)))
TFall 				= (tFallEnd - tFallStart)
TPFall 				= (tTPFallEnd - tFallSettleStart)
TPRise 				= (tTPRiseEnd - tRiseSettleStart)
TRise 				= (tRiseEnd - tRiseStart)
TSettleFall 		= (tFallSettleEnd - tFallSettleStart)
TSettleRise 		= (tRiseSettleEnd - tRiseSettleStart)

file  =  strcat(  "/root/Desktop/"  "DualSupplyResults.matlab"  )
out   = outfile(file, "w")
ocnPrint(?output out TSettleRise TSettleFall TFall TRise TPRise TPFall QRise_pVDDH QFall_pVDDL LeakageVDDH  LeakageLine  LeakageIntoVDDL ?precision 16  ?numSpaces 1 ?numberNotation 'scientific)
