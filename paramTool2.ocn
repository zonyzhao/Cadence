simulator( 'spectre )
hostMode( 'distributed )
design(	 "/net/kafka/nfs/rstdenis/Cadence/simulation/20nm/Dual_Supply_Test/spectre/schematic/netlist/netlist")
resultsDir( "/net/kafka/nfs/rstdenis/Cadence/simulation/20nm/Dual_Supply_Test/spectre/schematic" )
modelFile(
    '("/software/cadence/ncsu-FreePDK15/hspice_20nm_hp.include" "")
)
analysis('tran ?stop "VAR(\"timeStop\")"  ?errpreset "conservative"  )
desVar(	  "nfin" 20	)
desVar(	  "VDDH" .600	)
desVar(	  "VDDL" .450	)
desVar(	  "timeStop" 32n	)
desVar(	  "period" 14n	)
desVar(	  "pulseWidth" 7n	)
desVar(	  "startDelay" 5n	)
desVar(	  "C" 596.31f	)
envOption(
	'cmd64bit  t
	'analysisOrder  list("tran")
)
option(	'multithread  "on"
)
save( 'v "/VH" "/VL" "/Vline" )
save( 'i "/ILine/src" "/IVDDH/src" "/IVDDL/dst" )
converge( 'ic "/I19/I0/I0/I7/I3/Q0" "0" )
converge( 'ic "/I19/I0/I0/I7/I3/Q1" "VDDL" )
converge( 'ic "/net035" "0" )
converge( 'ic "/sH" "VDDH" )
converge( 'ic "/VH" "VDDH" )
converge( 'ic "/VL" "0" )
converge( 'ic "/~R1_1<0>" "VDDL" )
converge( 'ic "/~R1_1<1>" "VDDL" )
converge( 'ic "/~R1_1<2>" "VDDL" )
converge( 'ic "/~R1_1<3>" "VDDL" )
converge( 'ic "/~R0_1<0>" "VDDL" )
converge( 'ic "/~R0_1<1>" "VDDL" )
converge( 'ic "/~R0_1<2>" "VDDL" )
converge( 'ic "/~R0_1<3>" "VDDL" )
temp( 27 )
paramAnalysis("nfin" ?values '(12 22 32 42 52 62 72 82 92 102 112 122 132 142 152 162 172 )
)
paramRun( ?jobName "job" ?queue "c2107" )
selectResult( 'tran )
plot(getData("/ILine/src") getData("/IVDDH/src") getData("/IVDDL/dst") getData("/VH") getData("/VL") getData("/Vline") )
LeakageIntoVDDL = average(clip(i("/IVDDL/dst" ?result "tran") tLeakageStart tLeakageEnd))
plot( LeakageIntoVDDL ?expr '( "LeakageIntoVDDL" ) )
LeakageLine = average(clip(i("/ILine/src" ?result "tran") tLeakageStart tLeakageEnd))
plot( LeakageLine ?expr '( "LeakageLine" ) )
LeakageVDDH = average(clip(i("/IVDDH/src" ?result "tran") tLeakageStart tLeakageEnd))
plot( LeakageVDDH ?expr '( "LeakageVDDH" ) )
QFall_pVDDL = ymax(iinteg(clip(i("/IVDDL/dst" ?result "tran") tFallSettleStart tFallSettleEnd)))
plot( QFall_pVDDL ?expr '( "QFall_pVDDL" ) )
QRise_pVDDH = ymax(iinteg(clip(i("/IVDDH/src" ?result "tran") tRiseSettleStart tRiseSettleEnd)))
plot( QRise_pVDDH ?expr '( "QRise_pVDDH" ) )
TFall = (tFallEnd - tFallStart)
plot( TFall ?expr '( "TFall" ) )
TPFall = (tTPFallEnd - tFallSettleStart)
plot( TPFall ?expr '( "TPFall" ) )
TPRise = (tTPRiseEnd - tRiseSettleStart)
plot( TPRise ?expr '( "TPRise" ) )
TRise = (tRiseEnd - tRiseStart)
plot( TRise ?expr '( "TRise" ) )
TSettleFall = (tFallSettleEnd - tFallSettleStart)
plot( TSettleFall ?expr '( "TSettleFall" ) )
TSettleRise = (tRiseSettleEnd - tRiseSettleStart)
plot( TSettleRise ?expr '( "TSettleRise" ) )
cVline = clip(v("/Vline" ?result "tran") clipStart VAR("timeStop"))
plot( cVline ?expr '( "cVline" ) )
clipStart = (1.25 * VAR("period"))
plot( clipStart ?expr '( "clipStart" ) )
tFallEnd = cross(cVline (VAR("VDDH") - (0.9 * vDiff)) 1 "falling")
plot( tFallEnd ?expr '( "tFallEnd" ) )
tFallSettleEnd = cross(cVline (1.005 * VAR("VDDL")) 1 "falling")
plot( tFallSettleEnd ?expr '( "tFallSettleEnd" ) )
tFallSettleStart = cross(clip(v("/VH" ?result "tran") clipStart VAR("timeStop")) (0.5 * VAR("VDDH")) 1 "rising")
plot( tFallSettleStart ?expr '( "tFallSettleStart" ) )
tFallStart = cross(cVline (VAR("VDDH") - (0.1 * vDiff)) 1 "falling")
plot( tFallStart ?expr '( "tFallStart" ) )
tLeakageEnd = (clipStart + (0.51 * VAR("period")))
plot( tLeakageEnd ?expr '( "tLeakageEnd" ) )
tLeakageStart = (clipStart + (0.49 * VAR("period")))
plot( tLeakageStart ?expr '( "tLeakageStart" ) )
tRiseEnd = cross(cVline (VAR("VDDL") + (0.9 * vDiff)) 1 "rising")
plot( tRiseEnd ?expr '( "tRiseEnd" ) )
tRiseSettleEnd = cross(cVline (0.99 * VAR("VDDH")) 1 "rising")
plot( tRiseSettleEnd ?expr '( "tRiseSettleEnd" ) )
tRiseSettleStart = cross(clip(v("/VH" ?result "tran") clipStart VAR("timeStop")) (0.5 * VAR("VDDH")) 1 "falling")
plot( tRiseSettleStart ?expr '( "tRiseSettleStart" ) )
tRiseStart = cross(cVline (VAR("VDDL") + (0.1 * vDiff)) 1 "rising")
plot( tRiseStart ?expr '( "tRiseStart" ) )
tTPFallEnd = cross(cVline (VAR("VDDH") - (0.5 * vDiff)) 1 "falling")
plot( tTPFallEnd ?expr '( "tTPFallEnd" ) )
tTPRiseEnd = cross(cVline (VAR("VDDL") + (0.5 * vDiff)) 1 "rising")
plot( tTPRiseEnd ?expr '( "tTPRiseEnd" ) )
vDiff = (VAR("VDDH") - VAR("VDDL"))
plot( vDiff ?expr '( "vDiff" ) )
