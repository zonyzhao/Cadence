simulator( 'spectre )
hostMode( 'distributed )
design(	 "/net/kafka/nfs/rstdenis/Cadence/simulation/20nm/Dual_Supply_Test/spectre/schematic/netlist/netlist")
resultsDir( "/net/kafka/nfs/rstdenis/Cadence/simulation/20nm/Dual_Supply_Test/spectre/schematic" )
modelFile(
    '("/software/cadence/ncsu-FreePDK15/hspice_20nm_hp.include" "")
)
analysis('tran ?stop "VAR(\"timeStop\")"  ?errpreset "conservative"  )
desVar(	  "nfin" 20	)
desVar(	  "VDDH" .600	)
desVar(	  "VDDL" .450	)
desVar(	  "timeStop" 32n	)
desVar(	  "period" 14n	)
desVar(	  "pulseWidth" 7n	)
desVar(	  "startDelay" 5n	)
desVar(	  "C" 596.31f	)
envOption(
	'cmd64bit  t
	'analysisOrder  list("tran")
)
option(	'multithread  "on"
)
save( 'v "/VH" "/VL" "/Vline" )
save( 'i "/ILine/src" "/IVDDH/src" "/IVDDL/dst" )
converge( 'ic "/I19/I0/I0/I7/I3/Q0" "0" )
converge( 'ic "/I19/I0/I0/I7/I3/Q1" "VDDL" )
converge( 'ic "/net035" "0" )
converge( 'ic "/sH" "VDDH" )
converge( 'ic "/VH" "VDDH" )
converge( 'ic "/VL" "0" )
converge( 'ic "/~R1_1<0>" "VDDL" )
converge( 'ic "/~R1_1<1>" "VDDL" )
converge( 'ic "/~R1_1<2>" "VDDL" )
converge( 'ic "/~R1_1<3>" "VDDL" )
converge( 'ic "/~R0_1<0>" "VDDL" )
converge( 'ic "/~R0_1<1>" "VDDL" )
converge( 'ic "/~R0_1<2>" "VDDL" )
converge( 'ic "/~R0_1<3>" "VDDL" )
temp( 27 )
;paramAnalysis("nfin" ?values '(12 22 32 42 52 62 72 82 92 102 112 122 132 142 152 162 172 ))
;paramRun( ?jobName "job" ?queue "c2107" )

selectResult( 'tran )

vDiff 				= (VAR("VDDH") - VAR("VDDL"))
clipStart 			= (1.25 * VAR("period"))
cVline 				= clip(v("/Vline" ?result "tran") clipStart VAR("timeStop"))

tTPFallEnd 			= cross(cVline (VAR("VDDH") - (0.5 * vDiff)) 1 "falling")
tTPRiseEnd 			= cross(cVline (VAR("VDDL") + (0.5 * vDiff)) 1 "rising")

tRiseSettleStart 	= cross(clip(v("/VH" ?result "tran") clipStart VAR("timeStop")) (0.5 * VAR("VDDH")) 1 "falling")
tFallSettleStart 	= cross(clip(v("/VH" ?result "tran") clipStart VAR("timeStop")) (0.5 * VAR("VDDH")) 1 "rising")
tFallStart 			= cross(cVline (VAR("VDDH") - (0.1 * vDiff)) 1 "falling")
tFallEnd 			= cross(cVline (VAR("VDDH") - (0.9 * vDiff)) 1 "falling")
tRiseStart 			= cross(cVline (VAR("VDDL") + (0.1 * vDiff)) 1 "rising")
tRiseEnd			= cross(cVline (VAR("VDDL") + (0.9 * vDiff)) 1 "rising")

tRiseSettleEnd 		= cross(cVline (0.95 * VAR("VDDH")) 1 "rising")
tFallSettleEnd 		= cross(cVline (1.05 * VAR("VDDL")) 1 "falling")

TPRise 				= (tTPRiseEnd - tRiseSettleStart)
TPFall 				= (tTPFallEnd - tFallSettleStart)
TRise 				= (tRiseEnd - tRiseStart)
TFall 				= (tFallEnd - tFallStart)
TSettleRise 		= (tRiseSettleEnd - tRiseSettleStart)
TSettleFall 		= (tFallSettleEnd - tFallSettleStart)

tLeakageStart 		= (clipStart + (0.49 * VAR("period")))
tLeakageEnd 	    = (clipStart + (0.51 * VAR("period")))
LeakageIntoVDDL 	= average(clip(i("/IVDDL/dst" ?result "tran") tLeakageStart tLeakageEnd))
LeakageLine 		= average(clip(i("/ILine/src" ?result "tran") tLeakageStart tLeakageEnd))
LeakageVDDH 		= average(clip(i("/IVDDH/src" ?result "tran") tLeakageStart tLeakageEnd))
QRise_pVDDH 		= ymax(iinteg(clip(i("/IVDDH/src" ?result "tran") tRiseSettleStart tRiseSettleEnd)))
QFall_pVDDL 		= ymax(iinteg(clip(i("/IVDDL/dst" ?result "tran") tFallSettleStart tFallSettleEnd)))

file  =  strcat(  "/root/Desktop/"  "DualSupplyResults.matlab"  )
out   = outfile(file, "w")
ocnPrint(?output out TSettleRise TSettleFall TFall TRise TPRise TPFall QRise_pVDDH QFall_pVDDL LeakageVDDH  LeakageLine  LeakageIntoVDDL ?precision 16  ?numSpaces 1 ?numberNotation 'scientific)

file2  =  strcat(  "/root/Desktop/"  "DualSupplyWaveforms.matlab"  )
out2   = outfile(file2, "w")
ocnPrint(?output out getData("/Vline") getData("/VH") getData("/VL") ?precision 16  ?numSpaces 1 ?numberNotation 'scientific)
printf("Completed.")

;plot(getData("/ILine/src") getData("/IVDDH/src") getData("/IVDDL/dst") getData("/VH") getData("/VL") getData("/Vline") )
;plot( QFall_pVDDL ?expr '( "QFall_pVDDL" ) )
;plot( LeakageVDDH ?expr '( "LeakageVDDH" ) )
;plot( LeakageIntoVDDL ?expr '( "LeakageIntoVDDL" ) )
;plot( LeakageLine ?expr '( "LeakageLine" ) )
;plot( QRise_pVDDH ?expr '( "QRise_pVDDH" ) )
;plot( TFall ?expr '( "TFall" ) )
;plot( TPFall ?expr '( "TPFall" ) )
;plot( TPRise ?expr '( "TPRise" ) )
;plot( TRise ?expr '( "TRise" ) )
;plot( TSettleFall ?expr '( "TSettleFall" ) )
;plot( TSettleRise ?expr '( "TSettleRise" ) )
;plot( cVline ?expr '( "cVline" ) )
;plot( clipStart ?expr '( "clipStart" ) )
;plot( tFallEnd ?expr '( "tFallEnd" ) )
;plot( tFallSettleEnd ?expr '( "tFallSettleEnd" ) )
;plot( tFallSettleStart ?expr '( "tFallSettleStart" ) )
;plot( tFallStart ?expr '( "tFallStart" ) )
;plot( tLeakageEnd ?expr '( "tLeakageEnd" ) )
;plot( tLeakageStart ?expr '( "tLeakageStart" ) )
;plot( tRiseEnd ?expr '( "tRiseEnd" ) )
;plot( tRiseSettleEnd ?expr '( "tRiseSettleEnd" ) )
;plot( tRiseSettleStart ?expr '( "tRiseSettleStart" ) )
;plot( tRiseStart ?expr '( "tRiseStart" ) )
;plot( tTPFallEnd ?expr '( "tTPFallEnd" ) )
;plot( tTPRiseEnd ?expr '( "tTPRiseEnd" ) )
