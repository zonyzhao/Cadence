simulator lang=spectre

statistics {
    mismatch {
        vary ndvtshift dist=gauss std=0.03
		vary pdvtshift dist=gauss std=0.03
    }
}
