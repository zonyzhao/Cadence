simulator lang=spectre

statistics {
    mismatch {
        vary pdvtshift dist=gauss std=0.03
	vary ndvtshift dist=gauss std=0.03
    }
}
