* SPICE parameters for Free PDK technology
* spectre format

* Modified 10/11/2010 by Joseph Ryan
* Add fake Vth variation

inline subckt NMOS_VTL (d g s b)
parameters w=wmin l=lmin mismatch=1 addvth=0
//----------------------------------------------
// threshold voltage variation
// vth0eff = vth0nom + dvthglb + dvthmm + addvth
//
// vth0nom: nominal value
// dvthglb: global process variation value
// dvthmm:  mismatch value
// addvth:  additional variation (e.g. for NBTI)
//
// dvthsig_minsize: sigma of random vth variation for min size device
//
+vth0nom = 0.322
+dvthsig_minsize = 0.0505 // 50.5mV sigma for minsize mismatch
+dvthsig = dvthsig_minsize * sqrt(wmin*lmin) / sqrt(w*l)
+dvthsig_glb = 0.030 // 30mV sigma for global
+dvthglb = DVTHN_PC * dvthsig_glb
+dvthmm = DVTHN_MM*dvthsig
+vth0eff = vth0nom + dvthglb + dvthmm*mismatch + addvth + VTCORNER_N*dvthsig_glb

//----------------------------------------------
// length variation
+vl = 0
//----------------------------------------------
// width variation
+vw = 0
//----------------------------------------------
+r = 1.5
//----------------------------------------------
NMOS_VTL (d g s b) nmos w=(w+vw) l=(l+vl)
+ as=(w+vw)*r*(l+vl) ad=(w+vw)*r*(l+vl)
+ ps=2*(w+vw+r*(l+vl)) pd=2*(w+vw+r*(l+vl))
+ ld=105n ls=105n m=1
model nmos bsim4
+tnom = 27        epsrox = 3.9
+eta0 = 0.006     nfactor = 2.1    wint = 5e-09
+cgso = 1.1e-10   cgdo = 1.1e-10    xl = -2e-08
+toxe = 1.14e-09  toxp = 1e-09    toxm = 1.14e-09    toxref = 1.14e-09
+dtox = 0.14e-09  lint = 3.75e-09
+vth0 = vth0eff   k1 = 0.4   u0 = 0.045   vsat = 148000
+rdsw = 155       ndep = 3.4e+18    xj = 1.98e-08
+version = 4.0             binunit = 1               paramchk= 1               mobmod  = 0
+capmod  = 2               igcmod  = 1               igbmod  = 1               geomod  = 1
+diomod  = 1               rdsmod  = 0               rbodymod= 1               rgatemod= 1
+permod  = 1               acnqsmod= 0               trnqsmod= 0
+ll      = 0               wl      = 0               lln     = 1               wln     = 1
+lw      = 0               ww      = 0               lwn     = 1               wwn     = 1
+lwl     = 0               wwl     = 0               xpart   = 0
+k2      = 0               k3      = 0
+k3b     = 0               w0      = 2.5e-006        dvt0    = 1               dvt1    = 2
+dvt2    = 0               dvt0w   = 0               dvt1w   = 0               dvt2w   = 0
+dsub    = 0.1             minv    = 0.05            voffl   = 0               dvtp0   = 1e-010
+dvtp1   = 0.1             lpe0    = 0               lpeb    = 0
+ngate   = 3e+20           nsd     = 2e+020          phin    = 0
+cdsc    = 0               cdscb   = 0               cdscd   = 0               cit     = 0
+voff    = -0.13           etab    = 0
+vfb     = -0.55           ua      = 6e-010          ub      = 1.2e-018
+uc      = 0               a0      = 1               ags     = 0
+a1      = 0               a2      = 1               b0      = 0               b1      = 0
+keta    = 0.04            dwg     = 0               dwb     = 0               pclm    = 0.02
+pdiblc1 = 0.001           pdiblc2 = 0.001           pdiblcb = -0.005          drout   = 0.5
+pvag    = 1e-020          delta   = 0.01            pscbe1  = 8.14e+008       pscbe2  = 1e-007
+fprout  = 0.2             pdits   = 0.08            pditsd  = 0.23            pditsl  = 2300000
+rsh     = 5               rsw     = 80              rdw     = 80
+rdswmin = 0               rdwmin  = 0               rswmin  = 0               prwg    = 0
+prwb    = 0               wr      = 1               alpha0  = 0.074           alpha1  = 0.005
+beta0   = 30              agidl   = 0.0002          bgidl   = 2.1e+009        cgidl   = 0.0002
+egidl   = 0.8             aigbacc = 0.012           bigbacc = 0.0028          cigbacc = 0.002
+nigbacc = 1               aigbinv = 0.014           bigbinv = 0.004           cigbinv = 0.004
+eigbinv = 1.1             nigbinv = 3               aigc    = 0.02            bigc    = 0.0027
+cigc    = 0.002           aigsd   = 0.02            bigsd   = 0.0027          cigsd   = 0.002
+nigc    = 1               poxedge = 1               pigcd   = 1               ntox    = 1
+xrcrg1  = 12              xrcrg2  = 5
+cgbo    = 2.56e-011       cgdl    = 2.653e-010
+cgsl    = 2.653e-010      ckappas = 0.03            ckappad = 0.03            acde    = 1
+moin    = 15              noff    = 0.9             voffcv  = 0.02
+kt1     = -0.11           kt1l    = 0               kt2     = 0.022           ute     = -1.5
+ua1     = 4.31e-009       ub1     = 7.61e-018       uc1     = -5.6e-011       prt     = 0
+at      = 33000
+fnoimod = 1               tnoimod = 0
+jss     = 0.0001          jsws    = 1e-011          jswgs   = 1e-010          njs     = 1
+ijthsfwd= 0.01            ijthsrev= 0.001           bvs     = 10              xjbvs   = 1
+jsd     = 0.0001          jswd    = 1e-011          jswgd   = 1e-010          njd     = 1
+ijthdfwd= 0.01            ijthdrev= 0.001           bvd     = 10              xjbvd   = 1
+pbs     = 1               cjs     = 0.0005          mjs     = 0.5             pbsws   = 1
+cjsws   = 5e-010          mjsws   = 0.33            pbswgs  = 1               cjswgs  = 3e-010
+mjswgs  = 0.33            pbd     = 1               cjd     = 0.0005          mjd     = 0.5
+pbswd   = 1               cjswd   = 5e-010          mjswd   = 0.33            pbswgd  = 1
+cjswgd  = 5e-010          mjswgd  = 0.33            tpb     = 0.005           tcj     = 0.001
+tpbsw   = 0.005           tcjsw   = 0.001           tpbswg  = 0.005           tcjswg  = 0.001
+xtis    = 3               xtid    = 3
+dmcg    = 0               dmci    = 0               dmdg    = 0               dmcgt   = 0
+dwj     = 0               xgw     = 0               xgl     = 0
+rshg    = 0.4             gbmin   = 1e-010          rbpb    = 5               rbpd    = 15
+rbps    = 15              rbdb    = 15              rbsb    = 15              ngcon   = 1
ends NMOS_VTL
