;;;;;;;;;;;;;;;;;;;;;;;;;;;;;;;;;;;;;;;;;;;;;;;;;;;;;;;;;;;;;;;;;;;;;;;;;;;;;;;;;;;;;
;2107List = 	list( "adder" "asp" "blind" "boa" "boom" "brown" \
;		      "cobra"  "copper" "coral" "corn" "crowned" \
;		      "deathadder" "fierce" "garter" "gopher" 	 \
;		      "hognose" "indigo" "krait" "mamba" "milk"  \
;		      "python" "queen" "racer" "rainbow" "rat" 	 \
;		      "rattle" "redbelly" "ribbon" "scarlet" 	 \
;		      "swamp" "timber" "viper" )
;;;;;;;;;;;;;;;;;;;;;;;;;;;;;;;;;;;;;;;;;;;;;;;;;;;;;;;;;;;;;;;;;;;;;;;;;;;;;;;;;;;;;
;;;;;;;;;;;;;;;;;;;;;;;;;;;;;;;;;;;;;;;;;;;;;;;;;;;;;;;;;;;;;;;;;;;;;;;;;;;;;;;;;;;;;

hList = list( "asp" "boa" "boom" "brown" "cobra"  "copper" "coral" "corn" "crowned" "deathadder" "fierce" "garter" "gopher" "hognose" "indigo" "krait" "mamba" "milk" "python" "queen" "racer" "rainbow" "rat" "rattle" "redbelly" "ribbon" "scarlet" "swamp" "timber" "viper" )
vLoad = list(  .250 .325 0.45 .475 .50 .525 .675 .85 1.0 1.125 )

tLoad = list( 30 60 90 )

jobList 	= nil
mVs   		= nil
temps   	= nil
j=1
foreach( degC  tLoad
    foreach( val  vLoad
	desVar( "vdd" val )
	temp(degC)

	volt    = round( evalstring( desVar( "vdd" )) * 1000 )
	mVs     = append1( mVs sprintf( nil "%d" volt ))
	temps   = append1( temps sprintf(nil "%d" degC ))

	jobName = strcat("/net/kafka/nfs/rstdenis/Cadence/simulation/6T_SDP_BANK_Test/spectreVerilog/config/distributed/SDPBank_" sprintf( nil "%d" volt ) "mV_" sprintf( nil "%d" degC) "C/psf" )
	jobList = append1( jobList jobName )

	j = j + 1
    )
)

;;;;;;;;;;;;;;;;;;;;;;;;;;;;;;;;;;;;;;;;;;;;;;;;;;;;;;;;;;;;;;;;;;;;;;;;;;;;;;;;;;;;;
;;;;;;;;;;;;;;;;;;;;;;;;;;;;;;;;;;;;;;;;;;;;;;;;;;;;;;;;;;;;;;;;;;;;;;;;;;;;;;;;;;;;;
file      =  strcat( "/root/Desktop/Cadence/simData/CacheData/2K_BankData.csv"  )
file8K    =  strcat( "/root/Desktop/Cadence/simData/CacheData/8K_BankData.csv"  )
file16K   =  strcat( "/root/Desktop/Cadence/simData/CacheData/16K_BankData.csv" )
file32K   =  strcat( "/root/Desktop/Cadence/simData/CacheData/32K_BankData.csv" )
outF      =   outfile(file,    "w")
out8K     =   outfile(file8K,  "w")
out16K    =   outfile(file16K, "w")
out32K    =   outfile(file32K, "w")
fprintf( outF,   "Vdd [mv], Temp [C], Leakage [mA], peak Current [mA], rDelay, rEnergy, rNull, rnullEnergy, wDelay Wenergy Wnull WnullEnergy\n" )
fprintf( out8K,  "Vdd [mv], Temp [C], Leakage [mA], LeakagePw [mW], RW_Energy [pJ], RW_Energy_Null [pJ], Cycle_Energy [pJ], )\n"  )
fprintf( out16K,  "Vdd [mv], Temp [C], Leakage [mA], LeakagePw [mW], RW_Energy [pJ], RW_Energy_Null [pJ], Cycle_Energy [pJ], )\n" )
fprintf( out32K,  "Vdd [mv], Temp [C], Leakage [mA], LeakagePw [mW], RW_Energy [pJ], RW_Energy_Null [pJ], Cycle_Energy [pJ], )\n" )
close(outF)
close(out8K)
close(out16K)
close(out32K)
;;;;;;;;;;;;;;;;;;;;;;;;;;;;;;;;;;;;;;;;;;;;;;;;;;;;;;;;;;;;;;;;;;;;;;;;;;;;;;;;;;;;;
;;;;;;;;;;;;;;;;;;;;;;;;;;;;;;;;;;;;;;;;;;;;;;;;;;;;;;;;;;;;;;;;;;;;;;;;;;;;;;;;;;;;;

j = 1
foreach(job jobList
    	printf("\n%s" job )
    	unless( openResults( job ) == nil || (evalstring(nthelem(j mVs)) >= 1500)
    	selectResult( 'tran )
    	unless( i( "/V1/MINUS") == nil
	Volts       = evalstring( nthelem(j mVs) )*0.001;
        leakage     = average( clip( i( "/V1/MINUS" ) 1200p 1300p ) ) *1e3
        leakagePwr  = leakage*Volts
	peakCurrent = ymax( i( "/V1/MINUS" ))*1e3
	peakPwr     = peakCurrent*Volts

	cHost       = sprintf(nil "%s" nthelem(j hList))
        nameR       = strcat( "/root/Desktop/Cadence/simData/CacheData/logs/SDP_BANK_RLog_" nthelem(j mVs) "mV_" nthelem(j temps) "C.log" )
        nameW       = strcat( "/root/Desktop/Cadence/simData/CacheData/logs/SDP_BANK_WLog_" nthelem(j mVs) "mV_" nthelem(j temps) "C.log" )
	shellCmd1   = strcat("scp " cHost ":/tmp2/SDP_BANK_RLog.csv " nameR  )
	shellCmd2   = strcat("scp " cHost ":/tmp2/SDP_BANK_WLog.csv " nameW  )
	shell( shellCmd1 )
	shell( shellCmd2 )

        printf("Reading %s\n" nameR)
        fidR   = infile( nameR )
	gets( s fidR )
	gets( s fidR )
	gets( s fidR )
        gets( s fidR )
        fscanf( fidR "%s %s %s %s" rAddr  rData rEnd     rDelay )
        fscanf( fidR "%s %s %s %s" rAddr  rData rEndNull rNull )
        close( fidR )

        printf("Reading %s\n" nameW)
        fidW   = infile( nameW )
	gets( s fidW )
	gets( s fidW )
	gets( s fidW )
	gets( s fidW )
        fscanf( fidW "%s %s %s %s" wAddr  wData wEnd     wDelay )
        fscanf( fidW "%s %s %s %s" wAddr  wData wEndNull wNull  )
        close(fidW)
	unless( (rEnd == nil) || (rEndNull == nil) || (wEnd == nil) || (wEndNull == nil)

	rStart      = evalstring( strcat(rEnd "p")) - evalstring( strcat(rDelay "p"))
	rEnd        = evalstring( strcat(rEnd "p"))
	rEndNull    = evalstring( strcat(rEndNull "p"))
	rEnergy     = integ( i("/V1/MINUS") rStart rEnd)*1e12*Volts
	rnullEnergy = integ( i("/V1/MINUS") rEnd   rEndNull)*1e12*Volts

	rCycle       = evalstring( rDelay ) + evalstring( rNull )
	rCycleEnergy = rEnergy +  rnullEnergy
	rEDP	 = rCycle*rCycleEnergy

	wStart      = evalstring( strcat(wEnd "p") ) - evalstring( strcat(wDelay "p"))
	wEnd        = evalstring( strcat(wEnd "p") )
	wEndNull    = evalstring( strcat(wEndNull "p") )
	wEnergy     = integ( i("/V1/MINUS") wStart wEnd)*1e12*Volts
	wnullEnergy = integ( i("/V1/MINUS") wEnd   wEndNull)*1e12*Volts

	wCycle       = evalstring( wDelay) + evalstring( wNull )
	wCycleEnergy = wEnergy +  wnullEnergy
	wEDP	 = wCycle*wCycleEnergy

	outF      =   outfile(file,    "a")
        fprintf( outF "%s,\t%s,\t%g,\t%g,\t%s,\t%g,\t%s,\t%g,\t%s,\t%g,\t%s,\t%g\n" nthelem(j mVs) nthelem(j temps) leakage peakCurrent rDelay rEnergy rNull rnullEnergy wDelay wEnergy wNull wnullEnergy)
        close( outF )

;;;;;;;;;;;;;;;;;;;;;;;;;;;;;;;;;;;;;;;;;;;;;;;;;;;;;;;;;;;;;;;;;;;;;;;;;;;;;;;;;;;;;;;;;;;;;;;;;;;;;;;;;;;;;;

        leak8K    = leakage*4   ;;mA
            leak16K   = leak8K*2    ;;mA
            leak32K   = leak16K*2   ;;mA

            leak8KPwr  = leak8K*Volts  ;;mW
            leak16KPwr = leak16K*Volts ;;mW
            leak32KPwr = leak32K*Volts ;;mW

            leakageEnergy     = 1e-3*leakagePwr*2*(rEnd-rStart)*1e12         ;; read is longer than write
            leakageEnergyNull = 1e-3*leakagePwr*2*(rEndNull-rEnd)*1e12       ;; read is longer than write

            rwEnergy8K   = rEnergy+wEnergy+leakageEnergy
            rwEnergy16K  = 2*rwEnergy8K
            rwEnergy32K  = 4*rwEnergy8K

            rwEnergyNull8K  = rnullEnergy+wnullEnergy+leakageEnergyNull
            rwEnergyNull16K = 2*rwEnergyNull8K
            rwEnergyNull32K = 4*rwEnergyNull8K

            rwCycleEnergy8K  =  rwEnergy8K +   rwEnergyNull8K
            rwCycleEnergy16K =  rwEnergy16K +  rwEnergyNull16K
            rwCycleEnergy32K =  rwEnergy32K +  rwEnergyNull32K

;;;;;;;;;;;;;;;;;;;;;;;;;;;;;;;;;;;;;;;;;;;;;;;;;;;;;;;;;;;;;;;;;;;;;;;;;;;;;;;;;;;;;;;;;;;;;;;;;;;;;;;;;;;;;;

            out8K     =   outfile(file8K,  "a")
            out16K    =   outfile(file16K, "a")
            out32K    =   outfile(file32K, "a")
            fprintf( out8K  "%s,\t %s,\t %g,\t %g,\t %g,\t %g,\t %g\n" nthelem(j mVs) nthelem(j temps) leak8K leak8KPwr rwEnergy8K rwEnergyNull8K rwCycleEnergy8K)
            fprintf( out16K "%s,\t %s,\t %g,\t %g,\t %g,\t %g,\t %g\n" nthelem(j mVs) nthelem(j temps) leak16K leak16KPwr rwEnergy16K rwEnergyNull16K rwCycleEnergy16K)
            fprintf( out32K "%s,\t %s,\t %g,\t %g,\t %g,\t %g,\t %g\n" nthelem(j mVs) nthelem(j temps) leak32K leak32KPwr rwEnergy32K rwEnergyNull32K rwCycleEnergy32K)
            close( out8K)
            close( out16K)
            close( out32K)
            )
	)
    )
;;;;;;;;;;;;;;;;;;;;;;;;;;;;;;;;;;;;;;;;;;;;;;;;;;;;;;;;;;;;;;;;;;;;;;;;;;;;;;;;;;;;;;;;;;;;;;;;;;;;;;;;;;;;;;
    j     = j + 1
)
printf("\nCompleted.\n")
;;;;;;;;;;;;;;;;;;;;;;;;;;;;;;;;;;;;;;;;;;;;;;;;;;;;;;;;;;;;;;;;;;;;;;;;;;;;;;;;;;;;;;;;;;;;;;;;;;;;;;;;;;;;;;
;;;;;;;;;;;;;;;;;;;;;;;;;;;;;;;;;;;;;;;;;;;;;;;;;;;;;;;;;;;;;;;;;;;;;;;;;;;;;;;;;;;;;;;;;;;;;;;;;;;;;;;;;;;;;;
