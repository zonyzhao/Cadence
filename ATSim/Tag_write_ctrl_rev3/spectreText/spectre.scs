// "spectre" description for "ATSim", "Tag_write_ctrl_rev3", "spectre"

simulator lang=spectre

subckt Tag_write_ctrl_rev3 TagWE WriteToL1MissTagAck TagWDataSel L2DataOutTagAck TagWrRegReq WriteToL1MissReq TagWrRegAck L2DataOutReq TagWAck

  I1  (p1 WriteToL1MissReq TagWrRegAck) 				nand_1x
  I2  (p2 L2DataOutReq TagWrRegAck y2_n1) 				nand3_1x
  I3  (y2_n1 y2) 										inv_1x
  I4  (p3 TagWAck_n1 L2DataOutReq) 						nand_1x
  I5  (TagWAck_n1 TagWAck) 								inv_1x
  I6  (p4 WriteToL1MissReq WriteToL1MissReq) 			nand_1x
  I7  (p5 TagWAck_n1 y0_n1 y2_n1) 						nand3_1x
  I8  (y0_n1 y0) 										inv_1x
  I9  (p6 TagWAck_n1 TagWrRegAck y2_n1) 				nand3_1x
  I10 (p7 TagWAck L2DataOutReq_n1 y0_n1) 				nand3_1x
  I11 (L2DataOutReq_n1 L2DataOutReq) 					inv_1x
  I12 (p8 TagWrRegAck y0_n1) 							nand_1x
  I13 (p9 WriteToL1MissReq_n1 TagWAck y0) 				nand3_1x
  I14 (WriteToL1MissReq_n1 WriteToL1MissReq) 			inv_1x
  I15 (p10 TagWrRegAck y0)					   			nand_1x
  I16 (p11 TagWAck_n1 L2DataOutReq_n1 TagWrRegAck_n1) 	nand3_1x
  I17 (TagWrRegAck_n1 TagWrRegAck)					 	inv_1x
  I18 (p12 L2DataOutReq_n1 y0)					       	nand_1x
  I19 (p13 WriteToL1MissReq_n1 L2DataOutReq_n1 y2)	   	nand3_1x
  I20 (y0 p10 p11 p12) 									nand3_1x
  I21 (y1 p1 p3 p6 p7 p8)							    nand5_1x
  I22 (y2 p7 p9 p11 p13)							    nand4_1x
  I23 (TagWE p1 p2 p6)								    nand3_1x
  I24 (WriteToL1MissTagAck p9 p10)						nand_1x
  I25 (TagWDataSel p2 p3 p5)						 	nand3_1x
  I26 (L2DataOutTagAck p7 p8)							nand_1x
  I27 (TagWrRegReq p2 p3 p4 p6)						    nand4_1x

ends Tag_write_ctrl_rev3
