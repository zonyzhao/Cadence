simulator( 'spectreVerilog )
hostMode( 'distributed )
design(	 "/net/bull/apps/Cadence/simulation/6T_MultiBank_16K_Test/spectreVerilog/config/netlist/analog/netlist")
resultsDir( "/net/bull/apps/Cadence/simulation/6T_MultiBank_16K_Test/spectreVerilog/config/distributed/job009" )
modelFile(
    '("/software/cadence/ncsu-FreePDK15/hspice_16nm_hp.include" "")
)
analysis('tran ?stop "10n"  ?errpreset "conservative"  )
desVar(	  "vcc" "vdd"	)
desVar(	  "vdd" 500m	)
envOption(
	'mspSetupNetlistSimPrecisionUnit  "ps"
	'mspSetupNetlistSimTimeUnit  "ps"
	'mspSetupNetlistSwitchRC  t
	'userCmdLineOption  "+multithread"
	'analysisOrder  list("tran")
)
option(	'temp  "30.0"
)
saveOption( ?simOutputFormat "psfxl" )
save( 'i "/V0/MINUS" )
converge( 'ic "/I21/I0/I0/I0/I0/I0/I7/I3/Q0" "0" )
converge( 'ic "/I21/I1/I0/I0/I0/I0/I7/I3/Q0" "0" )
converge( 'ic "/I21/I1/I0/I0/I0/I0/I7/I3/Q1" "vdd" )
converge( 'ic "/I21/I0/I0/I0/I0/I0/I7/I3/Q1" "vdd" )
converge( 'ic "/ReadEnT" "0" )
converge( 'ic "/R_AddressT<0>" "0" )
converge( 'ic "/R_AddressT<1>" "0" )
converge( 'ic "/R_AddressT<2>" "0" )
converge( 'ic "/R_AddressT<3>" "0" )
converge( 'ic "/R_AddressT<4>" "0" )
converge( 'ic "/R_AddressT<5>" "0" )
converge( 'ic "/R_AddressT<6>" "0" )
converge( 'ic "/R_AddressT<7>" "0" )
converge( 'ic "/R_AddressT<8>" "0" )
converge( 'ic "/R_AddressT<9>" "0" )
converge( 'ic "/R_AddressT<10>" "0" )
converge( 'ic "/R_AddressT<11>" "0" )
converge( 'ic "/W_AddressT<0>" "0" )
converge( 'ic "/W_AddressT<1>" "0" )
converge( 'ic "/W_AddressT<2>" "0" )
converge( 'ic "/W_AddressT<3>" "0" )
converge( 'ic "/W_AddressT<4>" "0" )
converge( 'ic "/W_AddressT<5>" "0" )
converge( 'ic "/W_AddressT<6>" "0" )
converge( 'ic "/W_AddressT<7>" "0" )
converge( 'ic "/W_AddressT<8>" "0" )
converge( 'ic "/W_AddressT<9>" "0" )
converge( 'ic "/W_AddressT<10>" "0" )
converge( 'ic "/W_AddressT<11>" "0" )
converge( 'ic "/WriteEnT" "0" )
converge( 'ic "/WDataT<0>" "0" )
converge( 'ic "/WDataT<1>" "0" )
converge( 'ic "/WDataT<2>" "0" )
converge( 'ic "/WDataT<3>" "0" )
converge( 'ic "/WDataT<4>" "0" )
converge( 'ic "/WDataT<5>" "0" )
converge( 'ic "/WDataT<6>" "0" )
converge( 'ic "/WDataT<7>" "0" )
converge( 'ic "/WDataT<8>" "0" )
converge( 'ic "/WDataT<9>" "0" )
converge( 'ic "/WDataT<10>" "0" )
converge( 'ic "/WDataT<11>" "0" )
converge( 'ic "/WDataT<12>" "0" )
converge( 'ic "/WDataT<13>" "0" )
converge( 'ic "/WDataT<14>" "0" )
converge( 'ic "/WDataT<15>" "0" )
converge( 'ic "/WDataT<16>" "0" )
converge( 'ic "/WDataT<17>" "0" )
converge( 'ic "/WDataT<18>" "0" )
converge( 'ic "/WDataT<19>" "0" )
converge( 'ic "/WDataT<20>" "0" )
converge( 'ic "/WDataT<21>" "0" )
converge( 'ic "/WDataT<22>" "0" )
converge( 'ic "/WDataT<23>" "0" )
converge( 'ic "/WDataT<24>" "0" )
converge( 'ic "/WDataT<25>" "0" )
converge( 'ic "/WDataT<26>" "0" )
converge( 'ic "/WDataT<27>" "0" )
converge( 'ic "/WDataT<28>" "0" )
converge( 'ic "/WDataT<29>" "0" )
converge( 'ic "/WDataT<30>" "0" )
converge( 'ic "/WDataT<31>" "0" )
converge( 'ic "/~ReadEn" "vdd" )
converge( 'ic "/~R_Address<11:0>" "vdd" )
converge( 'ic "/~WriteEn" "vdd" )
converge( 'ic "/~W_Address<11:0>" "vdd" )
temp( 30.0 )
run( ?jobName "job" ?mail "rstdenis@ucdavis.edu" )
selectResult( 'tran )
plot(getData("/ReadEn") getData("/R_Address<11:0>") getData("/W_Address<11:0>") getData("/WriteEn") getData("/ReadAck") getData("/WriteAck") getData("/RAckT") getData("/WAckT") getData("/R_AddressT<11>") getData("/R_AddressT<10>") getData("/R_AddressT<9>") getData("/R_AddressT<8>") getData("/R_AddressT<7>") getData("/R_AddressT<6>") getData("/R_AddressT<5>") getData("/R_AddressT<4>") getData("/R_AddressT<3>") getData("/R_AddressT<2>") getData("/R_AddressT<1>") getData("/R_AddressT<0>") getData("/ReadEnT") getData("/W_AddressT<11>") getData("/W_AddressT<10>") getData("/W_AddressT<9>") getData("/W_AddressT<8>") getData("/W_AddressT<7>") getData("/W_AddressT<6>") getData("/W_AddressT<5>") getData("/W_AddressT<4>") getData("/W_AddressT<3>") getData("/W_AddressT<2>") getData("/W_AddressT<1>") getData("/W_AddressT<0>") getData("/WriteEnT") getData("/V0/MINUS") getData("/I21/WdBank0<31>") getData("/I21/WdBank0<30>") getData("/I21/WdBank0<29>") getData("/I21/WdBank0<28>") getData("/I21/WdBank0<27>") getData("/I21/WdBank0<26>") getData("/I21/WdBank0<25>") getData("/I21/WdBank0<24>") getData("/I21/WdBank0<23>") getData("/I21/WdBank0<22>") getData("/I21/WdBank0<21>") getData("/I21/WdBank0<20>") getData("/I21/WdBank0<19>") getData("/I21/WdBank0<18>") getData("/I21/WdBank0<17>") getData("/I21/WdBank0<16>") getData("/I21/WdBank0<15>") getData("/I21/WdBank0<14>") getData("/I21/WdBank0<13>") getData("/I21/WdBank0<12>") getData("/I21/WdBank0<11>") getData("/I21/WdBank0<10>") getData("/I21/WdBank0<9>") getData("/I21/WdBank0<8>") getData("/I21/WdBank0<7>") getData("/I21/WdBank0<6>") getData("/I21/WdBank0<5>") getData("/I21/WdBank0<4>") getData("/I21/WdBank0<3>") getData("/I21/WdBank0<2>") getData("/I21/WdBank0<1>") getData("/I21/WdBank0<0>") getData("/I21/Bank0WAck<7>") getData("/I21/Bank0WAck<6>") getData("/I21/Bank0WAck<5>") getData("/I21/Bank0WAck<4>") getData("/I21/Bank0WAck<3>") getData("/I21/Bank0WAck<2>") getData("/I21/Bank0WAck<1>") getData("/I21/Bank0WAck<0>") getData("/I21/WdBank1<31>") getData("/I21/WdBank1<30>") getData("/I21/WdBank1<29>") getData("/I21/WdBank1<28>") getData("/I21/WdBank1<27>") getData("/I21/WdBank1<26>") getData("/I21/WdBank1<25>") getData("/I21/WdBank1<24>") getData("/I21/WdBank1<23>") getData("/I21/WdBank1<22>") getData("/I21/WdBank1<21>") getData("/I21/WdBank1<20>") getData("/I21/WdBank1<19>") getData("/I21/WdBank1<18>") getData("/I21/WdBank1<17>") getData("/I21/WdBank1<16>") getData("/I21/WdBank1<15>") getData("/I21/WdBank1<14>") getData("/I21/WdBank1<13>") getData("/I21/WdBank1<12>") getData("/I21/WdBank1<11>") getData("/I21/WdBank1<10>") getData("/I21/WdBank1<9>") getData("/I21/WdBank1<8>") getData("/I21/WdBank1<7>") getData("/I21/WdBank1<6>") getData("/I21/WdBank1<5>") getData("/I21/WdBank1<4>") getData("/I21/WdBank1<3>") getData("/I21/WdBank1<2>") getData("/I21/WdBank1<1>") getData("/I21/WdBank1<0>") getData("/I21/Bank1WAck<7>") getData("/I21/Bank1WAck<6>") getData("/I21/Bank1WAck<5>") getData("/I21/Bank1WAck<4>") getData("/I21/Bank1WAck<3>") getData("/I21/Bank1WAck<2>") getData("/I21/Bank1WAck<1>") getData("/I21/Bank1WAck<0>") getData("/I21/WdBank2<31>") getData("/I21/WdBank2<30>") getData("/I21/WdBank2<29>") getData("/I21/WdBank2<28>") getData("/I21/WdBank2<27>") getData("/I21/WdBank2<26>") getData("/I21/WdBank2<25>") getData("/I21/WdBank2<24>") getData("/I21/WdBank2<23>") getData("/I21/WdBank2<22>") getData("/I21/WdBank2<21>") getData("/I21/WdBank2<20>") getData("/I21/WdBank2<19>") getData("/I21/WdBank2<18>") getData("/I21/WdBank2<17>") getData("/I21/WdBank2<16>") getData("/I21/WdBank2<15>") getData("/I21/WdBank2<14>") getData("/I21/WdBank2<13>") getData("/I21/WdBank2<12>") getData("/I21/WdBank2<11>") getData("/I21/WdBank2<10>") getData("/I21/WdBank2<9>") getData("/I21/WdBank2<8>") getData("/I21/WdBank2<7>") getData("/I21/WdBank2<6>") getData("/I21/WdBank2<5>") getData("/I21/WdBank2<4>") getData("/I21/WdBank2<3>") getData("/I21/WdBank2<2>") getData("/I21/WdBank2<1>") getData("/I21/WdBank2<0>") getData("/I21/Bank2WAck<7>") getData("/I21/Bank2WAck<6>") getData("/I21/Bank2WAck<5>") getData("/I21/Bank2WAck<4>") getData("/I21/Bank2WAck<3>") getData("/I21/Bank2WAck<2>") getData("/I21/Bank2WAck<1>") getData("/I21/Bank2WAck<0>") getData("/I21/WdBank3<31>") getData("/I21/WdBank3<30>") getData("/I21/WdBank3<29>") getData("/I21/WdBank3<28>") getData("/I21/WdBank3<27>") getData("/I21/WdBank3<26>") getData("/I21/WdBank3<25>") getData("/I21/WdBank3<24>") getData("/I21/WdBank3<23>") getData("/I21/WdBank3<22>") getData("/I21/WdBank3<21>") getData("/I21/WdBank3<20>") getData("/I21/WdBank3<19>") getData("/I21/WdBank3<18>") getData("/I21/WdBank3<17>") getData("/I21/WdBank3<16>") getData("/I21/WdBank3<15>") getData("/I21/WdBank3<14>") getData("/I21/WdBank3<13>") getData("/I21/WdBank3<12>") getData("/I21/WdBank3<11>") getData("/I21/WdBank3<10>") getData("/I21/WdBank3<9>") getData("/I21/WdBank3<8>") getData("/I21/WdBank3<7>") getData("/I21/WdBank3<6>") getData("/I21/WdBank3<5>") getData("/I21/WdBank3<4>") getData("/I21/WdBank3<3>") getData("/I21/WdBank3<2>") getData("/I21/WdBank3<1>") getData("/I21/WdBank3<0>") getData("/I21/Bank3WAck<7>") getData("/I21/Bank3WAck<6>") getData("/I21/Bank3WAck<5>") getData("/I21/Bank3WAck<4>") getData("/I21/Bank3WAck<3>") getData("/I21/Bank3WAck<2>") getData("/I21/Bank3WAck<1>") getData("/I21/Bank3WAck<0>") getData("/I21/RdBank0<31>") getData("/I21/RdBank0<30>") getData("/I21/RdBank0<29>") getData("/I21/RdBank0<28>") getData("/I21/RdBank0<27>") getData("/I21/RdBank0<26>") getData("/I21/RdBank0<25>") getData("/I21/RdBank0<24>") getData("/I21/RdBank0<23>") getData("/I21/RdBank0<22>") getData("/I21/RdBank0<21>") getData("/I21/RdBank0<20>") getData("/I21/RdBank0<19>") getData("/I21/RdBank0<18>") getData("/I21/RdBank0<17>") getData("/I21/RdBank0<16>") getData("/I21/RdBank0<15>") getData("/I21/RdBank0<14>") getData("/I21/RdBank0<13>") getData("/I21/RdBank0<12>") getData("/I21/RdBank0<11>") getData("/I21/RdBank0<10>") getData("/I21/RdBank0<9>") getData("/I21/RdBank0<8>") getData("/I21/RdBank0<7>") getData("/I21/RdBank0<6>") getData("/I21/RdBank0<5>") getData("/I21/RdBank0<4>") getData("/I21/RdBank0<3>") getData("/I21/RdBank0<2>") getData("/I21/RdBank0<1>") getData("/I21/RdBank0<0>") getData("/I21/RdBank0Ack<7>") getData("/I21/RdBank0Ack<6>") getData("/I21/RdBank0Ack<5>") getData("/I21/RdBank0Ack<4>") getData("/I21/RdBank0Ack<3>") getData("/I21/RdBank0Ack<2>") getData("/I21/RdBank0Ack<1>") getData("/I21/RdBank0Ack<0>") getData("/I21/RdBank1<31>") getData("/I21/RdBank1<30>") getData("/I21/RdBank1<29>") getData("/I21/RdBank1<28>") getData("/I21/RdBank1<27>") getData("/I21/RdBank1<26>") getData("/I21/RdBank1<25>") getData("/I21/RdBank1<24>") getData("/I21/RdBank1<23>") getData("/I21/RdBank1<22>") getData("/I21/RdBank1<21>") getData("/I21/RdBank1<20>") getData("/I21/RdBank1<19>") getData("/I21/RdBank1<18>") getData("/I21/RdBank1<17>") getData("/I21/RdBank1<16>") getData("/I21/RdBank1<15>") getData("/I21/RdBank1<14>") getData("/I21/RdBank1<13>") getData("/I21/RdBank1<12>") getData("/I21/RdBank1<11>") getData("/I21/RdBank1<10>") getData("/I21/RdBank1<9>") getData("/I21/RdBank1<8>") getData("/I21/RdBank1<7>") getData("/I21/RdBank1<6>") getData("/I21/RdBank1<5>") getData("/I21/RdBank1<4>") getData("/I21/RdBank1<3>") getData("/I21/RdBank1<2>") getData("/I21/RdBank1<1>") getData("/I21/RdBank1<0>") getData("/I21/RdBank1Ack<7>") getData("/I21/RdBank1Ack<6>") getData("/I21/RdBank1Ack<5>") getData("/I21/RdBank1Ack<4>") getData("/I21/RdBank1Ack<3>") getData("/I21/RdBank1Ack<2>") getData("/I21/RdBank1Ack<1>") getData("/I21/RdBank1Ack<0>") getData("/WDataAckT<15>") getData("/WDataAckT<14>") getData("/WDataAckT<13>") getData("/WDataAckT<12>") getData("/WDataAckT<11>") getData("/WDataAckT<10>") getData("/WDataAckT<9>") getData("/WDataAckT<8>") getData("/WDataT<31>") getData("/WDataT<30>") getData("/WDataT<29>") getData("/WDataT<28>") getData("/WDataT<27>") getData("/WDataT<26>") getData("/WDataT<25>") getData("/WDataT<24>") getData("/WDataT<23>") getData("/WDataT<22>") getData("/WDataT<21>") getData("/WDataT<20>") getData("/WDataT<19>") getData("/WDataT<18>") getData("/WDataT<17>") getData("/WDataT<16>") getData("/WDataT<15>") getData("/WDataT<14>") getData("/WDataT<13>") getData("/WDataT<12>") getData("/WDataT<11>") getData("/WDataT<10>") getData("/WDataT<9>") getData("/WDataT<8>") getData("/WDataT<7>") getData("/WDataT<6>") getData("/WDataT<5>") getData("/WDataT<4>") getData("/WDataT<3>") getData("/WDataT<2>") getData("/WDataT<1>") getData("/WDataT<0>") getData("/Data1<31:0>") getData("/WDataAck<15:0>") getData("/RData<31:0>") getData("/RDataT<31>") getData("/RDataT<30>") getData("/RDataT<29>") getData("/RDataT<28>") getData("/RDataT<27>") getData("/RDataT<26>") getData("/RDataT<25>") getData("/RDataT<24>") getData("/RDataT<23>") getData("/RDataT<22>") getData("/RDataT<21>") getData("/RDataT<20>") getData("/RDataT<19>") getData("/RDataT<18>") getData("/RDataT<17>") getData("/RDataT<16>") getData("/RDataT<15>") getData("/RDataT<14>") getData("/RDataT<13>") getData("/RDataT<12>") getData("/RDataT<11>") getData("/RDataT<10>") getData("/RDataT<9>") getData("/RDataT<8>") getData("/RDataT<7>") getData("/RDataT<6>") getData("/RDataT<5>") getData("/RDataT<4>") getData("/RDataT<3>") getData("/RDataT<2>") getData("/RDataT<1>") getData("/RDataT<0>") )
resultsDir( "/net/bull/apps/Cadence/simulation/6T_MultiBank_16K_Test/spectreVerilog/config/distributed/job010" )
modelFile(
    '("/software/cadence/ncsu-FreePDK15/hspice_16nm_hp.include" "")
)
desVar(	  "vdd" .675	)
run( ?jobName "job" ?mail "rstdenis@ucdavis.edu" )
selectResult( 'tran )
plot(getData("/ReadEn") getData("/R_Address<11:0>") getData("/W_Address<11:0>") getData("/WriteEn") getData("/ReadAck") getData("/WriteAck") getData("/RAckT") getData("/WAckT") getData("/R_AddressT<11>") getData("/R_AddressT<10>") getData("/R_AddressT<9>") getData("/R_AddressT<8>") getData("/R_AddressT<7>") getData("/R_AddressT<6>") getData("/R_AddressT<5>") getData("/R_AddressT<4>") getData("/R_AddressT<3>") getData("/R_AddressT<2>") getData("/R_AddressT<1>") getData("/R_AddressT<0>") getData("/ReadEnT") getData("/W_AddressT<11>") getData("/W_AddressT<10>") getData("/W_AddressT<9>") getData("/W_AddressT<8>") getData("/W_AddressT<7>") getData("/W_AddressT<6>") getData("/W_AddressT<5>") getData("/W_AddressT<4>") getData("/W_AddressT<3>") getData("/W_AddressT<2>") getData("/W_AddressT<1>") getData("/W_AddressT<0>") getData("/WriteEnT") getData("/V0/MINUS") getData("/I21/WdBank0<31>") getData("/I21/WdBank0<30>") getData("/I21/WdBank0<29>") getData("/I21/WdBank0<28>") getData("/I21/WdBank0<27>") getData("/I21/WdBank0<26>") getData("/I21/WdBank0<25>") getData("/I21/WdBank0<24>") getData("/I21/WdBank0<23>") getData("/I21/WdBank0<22>") getData("/I21/WdBank0<21>") getData("/I21/WdBank0<20>") getData("/I21/WdBank0<19>") getData("/I21/WdBank0<18>") getData("/I21/WdBank0<17>") getData("/I21/WdBank0<16>") getData("/I21/WdBank0<15>") getData("/I21/WdBank0<14>") getData("/I21/WdBank0<13>") getData("/I21/WdBank0<12>") getData("/I21/WdBank0<11>") getData("/I21/WdBank0<10>") getData("/I21/WdBank0<9>") getData("/I21/WdBank0<8>") getData("/I21/WdBank0<7>") getData("/I21/WdBank0<6>") getData("/I21/WdBank0<5>") getData("/I21/WdBank0<4>") getData("/I21/WdBank0<3>") getData("/I21/WdBank0<2>") getData("/I21/WdBank0<1>") getData("/I21/WdBank0<0>") getData("/I21/Bank0WAck<7>") getData("/I21/Bank0WAck<6>") getData("/I21/Bank0WAck<5>") getData("/I21/Bank0WAck<4>") getData("/I21/Bank0WAck<3>") getData("/I21/Bank0WAck<2>") getData("/I21/Bank0WAck<1>") getData("/I21/Bank0WAck<0>") getData("/I21/WdBank1<31>") getData("/I21/WdBank1<30>") getData("/I21/WdBank1<29>") getData("/I21/WdBank1<28>") getData("/I21/WdBank1<27>") getData("/I21/WdBank1<26>") getData("/I21/WdBank1<25>") getData("/I21/WdBank1<24>") getData("/I21/WdBank1<23>") getData("/I21/WdBank1<22>") getData("/I21/WdBank1<21>") getData("/I21/WdBank1<20>") getData("/I21/WdBank1<19>") getData("/I21/WdBank1<18>") getData("/I21/WdBank1<17>") getData("/I21/WdBank1<16>") getData("/I21/WdBank1<15>") getData("/I21/WdBank1<14>") getData("/I21/WdBank1<13>") getData("/I21/WdBank1<12>") getData("/I21/WdBank1<11>") getData("/I21/WdBank1<10>") getData("/I21/WdBank1<9>") getData("/I21/WdBank1<8>") getData("/I21/WdBank1<7>") getData("/I21/WdBank1<6>") getData("/I21/WdBank1<5>") getData("/I21/WdBank1<4>") getData("/I21/WdBank1<3>") getData("/I21/WdBank1<2>") getData("/I21/WdBank1<1>") getData("/I21/WdBank1<0>") getData("/I21/Bank1WAck<7>") getData("/I21/Bank1WAck<6>") getData("/I21/Bank1WAck<5>") getData("/I21/Bank1WAck<4>") getData("/I21/Bank1WAck<3>") getData("/I21/Bank1WAck<2>") getData("/I21/Bank1WAck<1>") getData("/I21/Bank1WAck<0>") getData("/I21/WdBank2<31>") getData("/I21/WdBank2<30>") getData("/I21/WdBank2<29>") getData("/I21/WdBank2<28>") getData("/I21/WdBank2<27>") getData("/I21/WdBank2<26>") getData("/I21/WdBank2<25>") getData("/I21/WdBank2<24>") getData("/I21/WdBank2<23>") getData("/I21/WdBank2<22>") getData("/I21/WdBank2<21>") getData("/I21/WdBank2<20>") getData("/I21/WdBank2<19>") getData("/I21/WdBank2<18>") getData("/I21/WdBank2<17>") getData("/I21/WdBank2<16>") getData("/I21/WdBank2<15>") getData("/I21/WdBank2<14>") getData("/I21/WdBank2<13>") getData("/I21/WdBank2<12>") getData("/I21/WdBank2<11>") getData("/I21/WdBank2<10>") getData("/I21/WdBank2<9>") getData("/I21/WdBank2<8>") getData("/I21/WdBank2<7>") getData("/I21/WdBank2<6>") getData("/I21/WdBank2<5>") getData("/I21/WdBank2<4>") getData("/I21/WdBank2<3>") getData("/I21/WdBank2<2>") getData("/I21/WdBank2<1>") getData("/I21/WdBank2<0>") getData("/I21/Bank2WAck<7>") getData("/I21/Bank2WAck<6>") getData("/I21/Bank2WAck<5>") getData("/I21/Bank2WAck<4>") getData("/I21/Bank2WAck<3>") getData("/I21/Bank2WAck<2>") getData("/I21/Bank2WAck<1>") getData("/I21/Bank2WAck<0>") getData("/I21/WdBank3<31>") getData("/I21/WdBank3<30>") getData("/I21/WdBank3<29>") getData("/I21/WdBank3<28>") getData("/I21/WdBank3<27>") getData("/I21/WdBank3<26>") getData("/I21/WdBank3<25>") getData("/I21/WdBank3<24>") getData("/I21/WdBank3<23>") getData("/I21/WdBank3<22>") getData("/I21/WdBank3<21>") getData("/I21/WdBank3<20>") getData("/I21/WdBank3<19>") getData("/I21/WdBank3<18>") getData("/I21/WdBank3<17>") getData("/I21/WdBank3<16>") getData("/I21/WdBank3<15>") getData("/I21/WdBank3<14>") getData("/I21/WdBank3<13>") getData("/I21/WdBank3<12>") getData("/I21/WdBank3<11>") getData("/I21/WdBank3<10>") getData("/I21/WdBank3<9>") getData("/I21/WdBank3<8>") getData("/I21/WdBank3<7>") getData("/I21/WdBank3<6>") getData("/I21/WdBank3<5>") getData("/I21/WdBank3<4>") getData("/I21/WdBank3<3>") getData("/I21/WdBank3<2>") getData("/I21/WdBank3<1>") getData("/I21/WdBank3<0>") getData("/I21/Bank3WAck<7>") getData("/I21/Bank3WAck<6>") getData("/I21/Bank3WAck<5>") getData("/I21/Bank3WAck<4>") getData("/I21/Bank3WAck<3>") getData("/I21/Bank3WAck<2>") getData("/I21/Bank3WAck<1>") getData("/I21/Bank3WAck<0>") getData("/I21/RdBank0<31>") getData("/I21/RdBank0<30>") getData("/I21/RdBank0<29>") getData("/I21/RdBank0<28>") getData("/I21/RdBank0<27>") getData("/I21/RdBank0<26>") getData("/I21/RdBank0<25>") getData("/I21/RdBank0<24>") getData("/I21/RdBank0<23>") getData("/I21/RdBank0<22>") getData("/I21/RdBank0<21>") getData("/I21/RdBank0<20>") getData("/I21/RdBank0<19>") getData("/I21/RdBank0<18>") getData("/I21/RdBank0<17>") getData("/I21/RdBank0<16>") getData("/I21/RdBank0<15>") getData("/I21/RdBank0<14>") getData("/I21/RdBank0<13>") getData("/I21/RdBank0<12>") getData("/I21/RdBank0<11>") getData("/I21/RdBank0<10>") getData("/I21/RdBank0<9>") getData("/I21/RdBank0<8>") getData("/I21/RdBank0<7>") getData("/I21/RdBank0<6>") getData("/I21/RdBank0<5>") getData("/I21/RdBank0<4>") getData("/I21/RdBank0<3>") getData("/I21/RdBank0<2>") getData("/I21/RdBank0<1>") getData("/I21/RdBank0<0>") getData("/I21/RdBank0Ack<7>") getData("/I21/RdBank0Ack<6>") getData("/I21/RdBank0Ack<5>") getData("/I21/RdBank0Ack<4>") getData("/I21/RdBank0Ack<3>") getData("/I21/RdBank0Ack<2>") getData("/I21/RdBank0Ack<1>") getData("/I21/RdBank0Ack<0>") getData("/I21/RdBank1<31>") getData("/I21/RdBank1<30>") getData("/I21/RdBank1<29>") getData("/I21/RdBank1<28>") getData("/I21/RdBank1<27>") getData("/I21/RdBank1<26>") getData("/I21/RdBank1<25>") getData("/I21/RdBank1<24>") getData("/I21/RdBank1<23>") getData("/I21/RdBank1<22>") getData("/I21/RdBank1<21>") getData("/I21/RdBank1<20>") getData("/I21/RdBank1<19>") getData("/I21/RdBank1<18>") getData("/I21/RdBank1<17>") getData("/I21/RdBank1<16>") getData("/I21/RdBank1<15>") getData("/I21/RdBank1<14>") getData("/I21/RdBank1<13>") getData("/I21/RdBank1<12>") getData("/I21/RdBank1<11>") getData("/I21/RdBank1<10>") getData("/I21/RdBank1<9>") getData("/I21/RdBank1<8>") getData("/I21/RdBank1<7>") getData("/I21/RdBank1<6>") getData("/I21/RdBank1<5>") getData("/I21/RdBank1<4>") getData("/I21/RdBank1<3>") getData("/I21/RdBank1<2>") getData("/I21/RdBank1<1>") getData("/I21/RdBank1<0>") getData("/I21/RdBank1Ack<7>") getData("/I21/RdBank1Ack<6>") getData("/I21/RdBank1Ack<5>") getData("/I21/RdBank1Ack<4>") getData("/I21/RdBank1Ack<3>") getData("/I21/RdBank1Ack<2>") getData("/I21/RdBank1Ack<1>") getData("/I21/RdBank1Ack<0>") getData("/WDataAckT<15>") getData("/WDataAckT<14>") getData("/WDataAckT<13>") getData("/WDataAckT<12>") getData("/WDataAckT<11>") getData("/WDataAckT<10>") getData("/WDataAckT<9>") getData("/WDataAckT<8>") getData("/WDataT<31>") getData("/WDataT<30>") getData("/WDataT<29>") getData("/WDataT<28>") getData("/WDataT<27>") getData("/WDataT<26>") getData("/WDataT<25>") getData("/WDataT<24>") getData("/WDataT<23>") getData("/WDataT<22>") getData("/WDataT<21>") getData("/WDataT<20>") getData("/WDataT<19>") getData("/WDataT<18>") getData("/WDataT<17>") getData("/WDataT<16>") getData("/WDataT<15>") getData("/WDataT<14>") getData("/WDataT<13>") getData("/WDataT<12>") getData("/WDataT<11>") getData("/WDataT<10>") getData("/WDataT<9>") getData("/WDataT<8>") getData("/WDataT<7>") getData("/WDataT<6>") getData("/WDataT<5>") getData("/WDataT<4>") getData("/WDataT<3>") getData("/WDataT<2>") getData("/WDataT<1>") getData("/WDataT<0>") getData("/Data1<31:0>") getData("/WDataAck<15:0>") getData("/RData<31:0>") getData("/RDataT<31>") getData("/RDataT<30>") getData("/RDataT<29>") getData("/RDataT<28>") getData("/RDataT<27>") getData("/RDataT<26>") getData("/RDataT<25>") getData("/RDataT<24>") getData("/RDataT<23>") getData("/RDataT<22>") getData("/RDataT<21>") getData("/RDataT<20>") getData("/RDataT<19>") getData("/RDataT<18>") getData("/RDataT<17>") getData("/RDataT<16>") getData("/RDataT<15>") getData("/RDataT<14>") getData("/RDataT<13>") getData("/RDataT<12>") getData("/RDataT<11>") getData("/RDataT<10>") getData("/RDataT<9>") getData("/RDataT<8>") getData("/RDataT<7>") getData("/RDataT<6>") getData("/RDataT<5>") getData("/RDataT<4>") getData("/RDataT<3>") getData("/RDataT<2>") getData("/RDataT<1>") getData("/RDataT<0>") )
resultsDir( "/net/bull/apps/Cadence/simulation/6T_MultiBank_16K_Test/spectreVerilog/config/distributed/job011" )
modelFile(
    '("/software/cadence/ncsu-FreePDK15/hspice_16nm_hp.include" "")
)
desVar(	  "vdd" .850	)
run( ?jobName "job" ?mail "rstdenis@ucdavis.edu" )
selectResult( 'tran )
plot(getData("/ReadEn") getData("/R_Address<11:0>") getData("/W_Address<11:0>") getData("/WriteEn") getData("/ReadAck") getData("/WriteAck") getData("/RAckT") getData("/WAckT") getData("/R_AddressT<11>") getData("/R_AddressT<10>") getData("/R_AddressT<9>") getData("/R_AddressT<8>") getData("/R_AddressT<7>") getData("/R_AddressT<6>") getData("/R_AddressT<5>") getData("/R_AddressT<4>") getData("/R_AddressT<3>") getData("/R_AddressT<2>") getData("/R_AddressT<1>") getData("/R_AddressT<0>") getData("/ReadEnT") getData("/W_AddressT<11>") getData("/W_AddressT<10>") getData("/W_AddressT<9>") getData("/W_AddressT<8>") getData("/W_AddressT<7>") getData("/W_AddressT<6>") getData("/W_AddressT<5>") getData("/W_AddressT<4>") getData("/W_AddressT<3>") getData("/W_AddressT<2>") getData("/W_AddressT<1>") getData("/W_AddressT<0>") getData("/WriteEnT") getData("/V0/MINUS") getData("/I21/WdBank0<31>") getData("/I21/WdBank0<30>") getData("/I21/WdBank0<29>") getData("/I21/WdBank0<28>") getData("/I21/WdBank0<27>") getData("/I21/WdBank0<26>") getData("/I21/WdBank0<25>") getData("/I21/WdBank0<24>") getData("/I21/WdBank0<23>") getData("/I21/WdBank0<22>") getData("/I21/WdBank0<21>") getData("/I21/WdBank0<20>") getData("/I21/WdBank0<19>") getData("/I21/WdBank0<18>") getData("/I21/WdBank0<17>") getData("/I21/WdBank0<16>") getData("/I21/WdBank0<15>") getData("/I21/WdBank0<14>") getData("/I21/WdBank0<13>") getData("/I21/WdBank0<12>") getData("/I21/WdBank0<11>") getData("/I21/WdBank0<10>") getData("/I21/WdBank0<9>") getData("/I21/WdBank0<8>") getData("/I21/WdBank0<7>") getData("/I21/WdBank0<6>") getData("/I21/WdBank0<5>") getData("/I21/WdBank0<4>") getData("/I21/WdBank0<3>") getData("/I21/WdBank0<2>") getData("/I21/WdBank0<1>") getData("/I21/WdBank0<0>") getData("/I21/Bank0WAck<7>") getData("/I21/Bank0WAck<6>") getData("/I21/Bank0WAck<5>") getData("/I21/Bank0WAck<4>") getData("/I21/Bank0WAck<3>") getData("/I21/Bank0WAck<2>") getData("/I21/Bank0WAck<1>") getData("/I21/Bank0WAck<0>") getData("/I21/WdBank1<31>") getData("/I21/WdBank1<30>") getData("/I21/WdBank1<29>") getData("/I21/WdBank1<28>") getData("/I21/WdBank1<27>") getData("/I21/WdBank1<26>") getData("/I21/WdBank1<25>") getData("/I21/WdBank1<24>") getData("/I21/WdBank1<23>") getData("/I21/WdBank1<22>") getData("/I21/WdBank1<21>") getData("/I21/WdBank1<20>") getData("/I21/WdBank1<19>") getData("/I21/WdBank1<18>") getData("/I21/WdBank1<17>") getData("/I21/WdBank1<16>") getData("/I21/WdBank1<15>") getData("/I21/WdBank1<14>") getData("/I21/WdBank1<13>") getData("/I21/WdBank1<12>") getData("/I21/WdBank1<11>") getData("/I21/WdBank1<10>") getData("/I21/WdBank1<9>") getData("/I21/WdBank1<8>") getData("/I21/WdBank1<7>") getData("/I21/WdBank1<6>") getData("/I21/WdBank1<5>") getData("/I21/WdBank1<4>") getData("/I21/WdBank1<3>") getData("/I21/WdBank1<2>") getData("/I21/WdBank1<1>") getData("/I21/WdBank1<0>") getData("/I21/Bank1WAck<7>") getData("/I21/Bank1WAck<6>") getData("/I21/Bank1WAck<5>") getData("/I21/Bank1WAck<4>") getData("/I21/Bank1WAck<3>") getData("/I21/Bank1WAck<2>") getData("/I21/Bank1WAck<1>") getData("/I21/Bank1WAck<0>") getData("/I21/WdBank2<31>") getData("/I21/WdBank2<30>") getData("/I21/WdBank2<29>") getData("/I21/WdBank2<28>") getData("/I21/WdBank2<27>") getData("/I21/WdBank2<26>") getData("/I21/WdBank2<25>") getData("/I21/WdBank2<24>") getData("/I21/WdBank2<23>") getData("/I21/WdBank2<22>") getData("/I21/WdBank2<21>") getData("/I21/WdBank2<20>") getData("/I21/WdBank2<19>") getData("/I21/WdBank2<18>") getData("/I21/WdBank2<17>") getData("/I21/WdBank2<16>") getData("/I21/WdBank2<15>") getData("/I21/WdBank2<14>") getData("/I21/WdBank2<13>") getData("/I21/WdBank2<12>") getData("/I21/WdBank2<11>") getData("/I21/WdBank2<10>") getData("/I21/WdBank2<9>") getData("/I21/WdBank2<8>") getData("/I21/WdBank2<7>") getData("/I21/WdBank2<6>") getData("/I21/WdBank2<5>") getData("/I21/WdBank2<4>") getData("/I21/WdBank2<3>") getData("/I21/WdBank2<2>") getData("/I21/WdBank2<1>") getData("/I21/WdBank2<0>") getData("/I21/Bank2WAck<7>") getData("/I21/Bank2WAck<6>") getData("/I21/Bank2WAck<5>") getData("/I21/Bank2WAck<4>") getData("/I21/Bank2WAck<3>") getData("/I21/Bank2WAck<2>") getData("/I21/Bank2WAck<1>") getData("/I21/Bank2WAck<0>") getData("/I21/WdBank3<31>") getData("/I21/WdBank3<30>") getData("/I21/WdBank3<29>") getData("/I21/WdBank3<28>") getData("/I21/WdBank3<27>") getData("/I21/WdBank3<26>") getData("/I21/WdBank3<25>") getData("/I21/WdBank3<24>") getData("/I21/WdBank3<23>") getData("/I21/WdBank3<22>") getData("/I21/WdBank3<21>") getData("/I21/WdBank3<20>") getData("/I21/WdBank3<19>") getData("/I21/WdBank3<18>") getData("/I21/WdBank3<17>") getData("/I21/WdBank3<16>") getData("/I21/WdBank3<15>") getData("/I21/WdBank3<14>") getData("/I21/WdBank3<13>") getData("/I21/WdBank3<12>") getData("/I21/WdBank3<11>") getData("/I21/WdBank3<10>") getData("/I21/WdBank3<9>") getData("/I21/WdBank3<8>") getData("/I21/WdBank3<7>") getData("/I21/WdBank3<6>") getData("/I21/WdBank3<5>") getData("/I21/WdBank3<4>") getData("/I21/WdBank3<3>") getData("/I21/WdBank3<2>") getData("/I21/WdBank3<1>") getData("/I21/WdBank3<0>") getData("/I21/Bank3WAck<7>") getData("/I21/Bank3WAck<6>") getData("/I21/Bank3WAck<5>") getData("/I21/Bank3WAck<4>") getData("/I21/Bank3WAck<3>") getData("/I21/Bank3WAck<2>") getData("/I21/Bank3WAck<1>") getData("/I21/Bank3WAck<0>") getData("/I21/RdBank0<31>") getData("/I21/RdBank0<30>") getData("/I21/RdBank0<29>") getData("/I21/RdBank0<28>") getData("/I21/RdBank0<27>") getData("/I21/RdBank0<26>") getData("/I21/RdBank0<25>") getData("/I21/RdBank0<24>") getData("/I21/RdBank0<23>") getData("/I21/RdBank0<22>") getData("/I21/RdBank0<21>") getData("/I21/RdBank0<20>") getData("/I21/RdBank0<19>") getData("/I21/RdBank0<18>") getData("/I21/RdBank0<17>") getData("/I21/RdBank0<16>") getData("/I21/RdBank0<15>") getData("/I21/RdBank0<14>") getData("/I21/RdBank0<13>") getData("/I21/RdBank0<12>") getData("/I21/RdBank0<11>") getData("/I21/RdBank0<10>") getData("/I21/RdBank0<9>") getData("/I21/RdBank0<8>") getData("/I21/RdBank0<7>") getData("/I21/RdBank0<6>") getData("/I21/RdBank0<5>") getData("/I21/RdBank0<4>") getData("/I21/RdBank0<3>") getData("/I21/RdBank0<2>") getData("/I21/RdBank0<1>") getData("/I21/RdBank0<0>") getData("/I21/RdBank0Ack<7>") getData("/I21/RdBank0Ack<6>") getData("/I21/RdBank0Ack<5>") getData("/I21/RdBank0Ack<4>") getData("/I21/RdBank0Ack<3>") getData("/I21/RdBank0Ack<2>") getData("/I21/RdBank0Ack<1>") getData("/I21/RdBank0Ack<0>") getData("/I21/RdBank1<31>") getData("/I21/RdBank1<30>") getData("/I21/RdBank1<29>") getData("/I21/RdBank1<28>") getData("/I21/RdBank1<27>") getData("/I21/RdBank1<26>") getData("/I21/RdBank1<25>") getData("/I21/RdBank1<24>") getData("/I21/RdBank1<23>") getData("/I21/RdBank1<22>") getData("/I21/RdBank1<21>") getData("/I21/RdBank1<20>") getData("/I21/RdBank1<19>") getData("/I21/RdBank1<18>") getData("/I21/RdBank1<17>") getData("/I21/RdBank1<16>") getData("/I21/RdBank1<15>") getData("/I21/RdBank1<14>") getData("/I21/RdBank1<13>") getData("/I21/RdBank1<12>") getData("/I21/RdBank1<11>") getData("/I21/RdBank1<10>") getData("/I21/RdBank1<9>") getData("/I21/RdBank1<8>") getData("/I21/RdBank1<7>") getData("/I21/RdBank1<6>") getData("/I21/RdBank1<5>") getData("/I21/RdBank1<4>") getData("/I21/RdBank1<3>") getData("/I21/RdBank1<2>") getData("/I21/RdBank1<1>") getData("/I21/RdBank1<0>") getData("/I21/RdBank1Ack<7>") getData("/I21/RdBank1Ack<6>") getData("/I21/RdBank1Ack<5>") getData("/I21/RdBank1Ack<4>") getData("/I21/RdBank1Ack<3>") getData("/I21/RdBank1Ack<2>") getData("/I21/RdBank1Ack<1>") getData("/I21/RdBank1Ack<0>") getData("/WDataAckT<15>") getData("/WDataAckT<14>") getData("/WDataAckT<13>") getData("/WDataAckT<12>") getData("/WDataAckT<11>") getData("/WDataAckT<10>") getData("/WDataAckT<9>") getData("/WDataAckT<8>") getData("/WDataT<31>") getData("/WDataT<30>") getData("/WDataT<29>") getData("/WDataT<28>") getData("/WDataT<27>") getData("/WDataT<26>") getData("/WDataT<25>") getData("/WDataT<24>") getData("/WDataT<23>") getData("/WDataT<22>") getData("/WDataT<21>") getData("/WDataT<20>") getData("/WDataT<19>") getData("/WDataT<18>") getData("/WDataT<17>") getData("/WDataT<16>") getData("/WDataT<15>") getData("/WDataT<14>") getData("/WDataT<13>") getData("/WDataT<12>") getData("/WDataT<11>") getData("/WDataT<10>") getData("/WDataT<9>") getData("/WDataT<8>") getData("/WDataT<7>") getData("/WDataT<6>") getData("/WDataT<5>") getData("/WDataT<4>") getData("/WDataT<3>") getData("/WDataT<2>") getData("/WDataT<1>") getData("/WDataT<0>") getData("/Data1<31:0>") getData("/WDataAck<15:0>") getData("/RData<31:0>") getData("/RDataT<31>") getData("/RDataT<30>") getData("/RDataT<29>") getData("/RDataT<28>") getData("/RDataT<27>") getData("/RDataT<26>") getData("/RDataT<25>") getData("/RDataT<24>") getData("/RDataT<23>") getData("/RDataT<22>") getData("/RDataT<21>") getData("/RDataT<20>") getData("/RDataT<19>") getData("/RDataT<18>") getData("/RDataT<17>") getData("/RDataT<16>") getData("/RDataT<15>") getData("/RDataT<14>") getData("/RDataT<13>") getData("/RDataT<12>") getData("/RDataT<11>") getData("/RDataT<10>") getData("/RDataT<9>") getData("/RDataT<8>") getData("/RDataT<7>") getData("/RDataT<6>") getData("/RDataT<5>") getData("/RDataT<4>") getData("/RDataT<3>") getData("/RDataT<2>") getData("/RDataT<1>") getData("/RDataT<0>") )
resultsDir( "/net/bull/apps/Cadence/simulation/6T_MultiBank_16K_Test/spectreVerilog/config/distributed/job012" )
modelFile(
    '("/software/cadence/ncsu-FreePDK15/hspice_16nm_hp.include" "")
)
desVar(	  "vdd" .5	)
option(	'temp  "85.0"
)
temp( 85.0 )
run( ?jobName "job" ?mail "rstdenis@ucdavis.edu" )
selectResult( 'tran )
plot(getData("/ReadEn") getData("/R_Address<11:0>") getData("/W_Address<11:0>") getData("/WriteEn") getData("/ReadAck") getData("/WriteAck") getData("/RAckT") getData("/WAckT") getData("/R_AddressT<11>") getData("/R_AddressT<10>") getData("/R_AddressT<9>") getData("/R_AddressT<8>") getData("/R_AddressT<7>") getData("/R_AddressT<6>") getData("/R_AddressT<5>") getData("/R_AddressT<4>") getData("/R_AddressT<3>") getData("/R_AddressT<2>") getData("/R_AddressT<1>") getData("/R_AddressT<0>") getData("/ReadEnT") getData("/W_AddressT<11>") getData("/W_AddressT<10>") getData("/W_AddressT<9>") getData("/W_AddressT<8>") getData("/W_AddressT<7>") getData("/W_AddressT<6>") getData("/W_AddressT<5>") getData("/W_AddressT<4>") getData("/W_AddressT<3>") getData("/W_AddressT<2>") getData("/W_AddressT<1>") getData("/W_AddressT<0>") getData("/WriteEnT") getData("/V0/MINUS") getData("/I21/WdBank0<31>") getData("/I21/WdBank0<30>") getData("/I21/WdBank0<29>") getData("/I21/WdBank0<28>") getData("/I21/WdBank0<27>") getData("/I21/WdBank0<26>") getData("/I21/WdBank0<25>") getData("/I21/WdBank0<24>") getData("/I21/WdBank0<23>") getData("/I21/WdBank0<22>") getData("/I21/WdBank0<21>") getData("/I21/WdBank0<20>") getData("/I21/WdBank0<19>") getData("/I21/WdBank0<18>") getData("/I21/WdBank0<17>") getData("/I21/WdBank0<16>") getData("/I21/WdBank0<15>") getData("/I21/WdBank0<14>") getData("/I21/WdBank0<13>") getData("/I21/WdBank0<12>") getData("/I21/WdBank0<11>") getData("/I21/WdBank0<10>") getData("/I21/WdBank0<9>") getData("/I21/WdBank0<8>") getData("/I21/WdBank0<7>") getData("/I21/WdBank0<6>") getData("/I21/WdBank0<5>") getData("/I21/WdBank0<4>") getData("/I21/WdBank0<3>") getData("/I21/WdBank0<2>") getData("/I21/WdBank0<1>") getData("/I21/WdBank0<0>") getData("/I21/Bank0WAck<7>") getData("/I21/Bank0WAck<6>") getData("/I21/Bank0WAck<5>") getData("/I21/Bank0WAck<4>") getData("/I21/Bank0WAck<3>") getData("/I21/Bank0WAck<2>") getData("/I21/Bank0WAck<1>") getData("/I21/Bank0WAck<0>") getData("/I21/WdBank1<31>") getData("/I21/WdBank1<30>") getData("/I21/WdBank1<29>") getData("/I21/WdBank1<28>") getData("/I21/WdBank1<27>") getData("/I21/WdBank1<26>") getData("/I21/WdBank1<25>") getData("/I21/WdBank1<24>") getData("/I21/WdBank1<23>") getData("/I21/WdBank1<22>") getData("/I21/WdBank1<21>") getData("/I21/WdBank1<20>") getData("/I21/WdBank1<19>") getData("/I21/WdBank1<18>") getData("/I21/WdBank1<17>") getData("/I21/WdBank1<16>") getData("/I21/WdBank1<15>") getData("/I21/WdBank1<14>") getData("/I21/WdBank1<13>") getData("/I21/WdBank1<12>") getData("/I21/WdBank1<11>") getData("/I21/WdBank1<10>") getData("/I21/WdBank1<9>") getData("/I21/WdBank1<8>") getData("/I21/WdBank1<7>") getData("/I21/WdBank1<6>") getData("/I21/WdBank1<5>") getData("/I21/WdBank1<4>") getData("/I21/WdBank1<3>") getData("/I21/WdBank1<2>") getData("/I21/WdBank1<1>") getData("/I21/WdBank1<0>") getData("/I21/Bank1WAck<7>") getData("/I21/Bank1WAck<6>") getData("/I21/Bank1WAck<5>") getData("/I21/Bank1WAck<4>") getData("/I21/Bank1WAck<3>") getData("/I21/Bank1WAck<2>") getData("/I21/Bank1WAck<1>") getData("/I21/Bank1WAck<0>") getData("/I21/WdBank2<31>") getData("/I21/WdBank2<30>") getData("/I21/WdBank2<29>") getData("/I21/WdBank2<28>") getData("/I21/WdBank2<27>") getData("/I21/WdBank2<26>") getData("/I21/WdBank2<25>") getData("/I21/WdBank2<24>") getData("/I21/WdBank2<23>") getData("/I21/WdBank2<22>") getData("/I21/WdBank2<21>") getData("/I21/WdBank2<20>") getData("/I21/WdBank2<19>") getData("/I21/WdBank2<18>") getData("/I21/WdBank2<17>") getData("/I21/WdBank2<16>") getData("/I21/WdBank2<15>") getData("/I21/WdBank2<14>") getData("/I21/WdBank2<13>") getData("/I21/WdBank2<12>") getData("/I21/WdBank2<11>") getData("/I21/WdBank2<10>") getData("/I21/WdBank2<9>") getData("/I21/WdBank2<8>") getData("/I21/WdBank2<7>") getData("/I21/WdBank2<6>") getData("/I21/WdBank2<5>") getData("/I21/WdBank2<4>") getData("/I21/WdBank2<3>") getData("/I21/WdBank2<2>") getData("/I21/WdBank2<1>") getData("/I21/WdBank2<0>") getData("/I21/Bank2WAck<7>") getData("/I21/Bank2WAck<6>") getData("/I21/Bank2WAck<5>") getData("/I21/Bank2WAck<4>") getData("/I21/Bank2WAck<3>") getData("/I21/Bank2WAck<2>") getData("/I21/Bank2WAck<1>") getData("/I21/Bank2WAck<0>") getData("/I21/WdBank3<31>") getData("/I21/WdBank3<30>") getData("/I21/WdBank3<29>") getData("/I21/WdBank3<28>") getData("/I21/WdBank3<27>") getData("/I21/WdBank3<26>") getData("/I21/WdBank3<25>") getData("/I21/WdBank3<24>") getData("/I21/WdBank3<23>") getData("/I21/WdBank3<22>") getData("/I21/WdBank3<21>") getData("/I21/WdBank3<20>") getData("/I21/WdBank3<19>") getData("/I21/WdBank3<18>") getData("/I21/WdBank3<17>") getData("/I21/WdBank3<16>") getData("/I21/WdBank3<15>") getData("/I21/WdBank3<14>") getData("/I21/WdBank3<13>") getData("/I21/WdBank3<12>") getData("/I21/WdBank3<11>") getData("/I21/WdBank3<10>") getData("/I21/WdBank3<9>") getData("/I21/WdBank3<8>") getData("/I21/WdBank3<7>") getData("/I21/WdBank3<6>") getData("/I21/WdBank3<5>") getData("/I21/WdBank3<4>") getData("/I21/WdBank3<3>") getData("/I21/WdBank3<2>") getData("/I21/WdBank3<1>") getData("/I21/WdBank3<0>") getData("/I21/Bank3WAck<7>") getData("/I21/Bank3WAck<6>") getData("/I21/Bank3WAck<5>") getData("/I21/Bank3WAck<4>") getData("/I21/Bank3WAck<3>") getData("/I21/Bank3WAck<2>") getData("/I21/Bank3WAck<1>") getData("/I21/Bank3WAck<0>") getData("/I21/RdBank0<31>") getData("/I21/RdBank0<30>") getData("/I21/RdBank0<29>") getData("/I21/RdBank0<28>") getData("/I21/RdBank0<27>") getData("/I21/RdBank0<26>") getData("/I21/RdBank0<25>") getData("/I21/RdBank0<24>") getData("/I21/RdBank0<23>") getData("/I21/RdBank0<22>") getData("/I21/RdBank0<21>") getData("/I21/RdBank0<20>") getData("/I21/RdBank0<19>") getData("/I21/RdBank0<18>") getData("/I21/RdBank0<17>") getData("/I21/RdBank0<16>") getData("/I21/RdBank0<15>") getData("/I21/RdBank0<14>") getData("/I21/RdBank0<13>") getData("/I21/RdBank0<12>") getData("/I21/RdBank0<11>") getData("/I21/RdBank0<10>") getData("/I21/RdBank0<9>") getData("/I21/RdBank0<8>") getData("/I21/RdBank0<7>") getData("/I21/RdBank0<6>") getData("/I21/RdBank0<5>") getData("/I21/RdBank0<4>") getData("/I21/RdBank0<3>") getData("/I21/RdBank0<2>") getData("/I21/RdBank0<1>") getData("/I21/RdBank0<0>") getData("/I21/RdBank0Ack<7>") getData("/I21/RdBank0Ack<6>") getData("/I21/RdBank0Ack<5>") getData("/I21/RdBank0Ack<4>") getData("/I21/RdBank0Ack<3>") getData("/I21/RdBank0Ack<2>") getData("/I21/RdBank0Ack<1>") getData("/I21/RdBank0Ack<0>") getData("/I21/RdBank1<31>") getData("/I21/RdBank1<30>") getData("/I21/RdBank1<29>") getData("/I21/RdBank1<28>") getData("/I21/RdBank1<27>") getData("/I21/RdBank1<26>") getData("/I21/RdBank1<25>") getData("/I21/RdBank1<24>") getData("/I21/RdBank1<23>") getData("/I21/RdBank1<22>") getData("/I21/RdBank1<21>") getData("/I21/RdBank1<20>") getData("/I21/RdBank1<19>") getData("/I21/RdBank1<18>") getData("/I21/RdBank1<17>") getData("/I21/RdBank1<16>") getData("/I21/RdBank1<15>") getData("/I21/RdBank1<14>") getData("/I21/RdBank1<13>") getData("/I21/RdBank1<12>") getData("/I21/RdBank1<11>") getData("/I21/RdBank1<10>") getData("/I21/RdBank1<9>") getData("/I21/RdBank1<8>") getData("/I21/RdBank1<7>") getData("/I21/RdBank1<6>") getData("/I21/RdBank1<5>") getData("/I21/RdBank1<4>") getData("/I21/RdBank1<3>") getData("/I21/RdBank1<2>") getData("/I21/RdBank1<1>") getData("/I21/RdBank1<0>") getData("/I21/RdBank1Ack<7>") getData("/I21/RdBank1Ack<6>") getData("/I21/RdBank1Ack<5>") getData("/I21/RdBank1Ack<4>") getData("/I21/RdBank1Ack<3>") getData("/I21/RdBank1Ack<2>") getData("/I21/RdBank1Ack<1>") getData("/I21/RdBank1Ack<0>") getData("/WDataAckT<15>") getData("/WDataAckT<14>") getData("/WDataAckT<13>") getData("/WDataAckT<12>") getData("/WDataAckT<11>") getData("/WDataAckT<10>") getData("/WDataAckT<9>") getData("/WDataAckT<8>") getData("/WDataT<31>") getData("/WDataT<30>") getData("/WDataT<29>") getData("/WDataT<28>") getData("/WDataT<27>") getData("/WDataT<26>") getData("/WDataT<25>") getData("/WDataT<24>") getData("/WDataT<23>") getData("/WDataT<22>") getData("/WDataT<21>") getData("/WDataT<20>") getData("/WDataT<19>") getData("/WDataT<18>") getData("/WDataT<17>") getData("/WDataT<16>") getData("/WDataT<15>") getData("/WDataT<14>") getData("/WDataT<13>") getData("/WDataT<12>") getData("/WDataT<11>") getData("/WDataT<10>") getData("/WDataT<9>") getData("/WDataT<8>") getData("/WDataT<7>") getData("/WDataT<6>") getData("/WDataT<5>") getData("/WDataT<4>") getData("/WDataT<3>") getData("/WDataT<2>") getData("/WDataT<1>") getData("/WDataT<0>") getData("/Data1<31:0>") getData("/WDataAck<15:0>") getData("/RData<31:0>") getData("/RDataT<31>") getData("/RDataT<30>") getData("/RDataT<29>") getData("/RDataT<28>") getData("/RDataT<27>") getData("/RDataT<26>") getData("/RDataT<25>") getData("/RDataT<24>") getData("/RDataT<23>") getData("/RDataT<22>") getData("/RDataT<21>") getData("/RDataT<20>") getData("/RDataT<19>") getData("/RDataT<18>") getData("/RDataT<17>") getData("/RDataT<16>") getData("/RDataT<15>") getData("/RDataT<14>") getData("/RDataT<13>") getData("/RDataT<12>") getData("/RDataT<11>") getData("/RDataT<10>") getData("/RDataT<9>") getData("/RDataT<8>") getData("/RDataT<7>") getData("/RDataT<6>") getData("/RDataT<5>") getData("/RDataT<4>") getData("/RDataT<3>") getData("/RDataT<2>") getData("/RDataT<1>") getData("/RDataT<0>") )
resultsDir( "/net/bull/apps/Cadence/simulation/6T_MultiBank_16K_Test/spectreVerilog/config/distributed/job013" )
modelFile(
    '("/software/cadence/ncsu-FreePDK15/hspice_16nm_hp.include" "")
)
desVar(	  "vdd" .675	)
run( ?jobName "job" ?mail "rstdenis@ucdavis.edu" )
selectResult( 'tran )
plot(getData("/ReadEn") getData("/R_Address<11:0>") getData("/W_Address<11:0>") getData("/WriteEn") getData("/ReadAck") getData("/WriteAck") getData("/RAckT") getData("/WAckT") getData("/R_AddressT<11>") getData("/R_AddressT<10>") getData("/R_AddressT<9>") getData("/R_AddressT<8>") getData("/R_AddressT<7>") getData("/R_AddressT<6>") getData("/R_AddressT<5>") getData("/R_AddressT<4>") getData("/R_AddressT<3>") getData("/R_AddressT<2>") getData("/R_AddressT<1>") getData("/R_AddressT<0>") getData("/ReadEnT") getData("/W_AddressT<11>") getData("/W_AddressT<10>") getData("/W_AddressT<9>") getData("/W_AddressT<8>") getData("/W_AddressT<7>") getData("/W_AddressT<6>") getData("/W_AddressT<5>") getData("/W_AddressT<4>") getData("/W_AddressT<3>") getData("/W_AddressT<2>") getData("/W_AddressT<1>") getData("/W_AddressT<0>") getData("/WriteEnT") getData("/V0/MINUS") getData("/I21/WdBank0<31>") getData("/I21/WdBank0<30>") getData("/I21/WdBank0<29>") getData("/I21/WdBank0<28>") getData("/I21/WdBank0<27>") getData("/I21/WdBank0<26>") getData("/I21/WdBank0<25>") getData("/I21/WdBank0<24>") getData("/I21/WdBank0<23>") getData("/I21/WdBank0<22>") getData("/I21/WdBank0<21>") getData("/I21/WdBank0<20>") getData("/I21/WdBank0<19>") getData("/I21/WdBank0<18>") getData("/I21/WdBank0<17>") getData("/I21/WdBank0<16>") getData("/I21/WdBank0<15>") getData("/I21/WdBank0<14>") getData("/I21/WdBank0<13>") getData("/I21/WdBank0<12>") getData("/I21/WdBank0<11>") getData("/I21/WdBank0<10>") getData("/I21/WdBank0<9>") getData("/I21/WdBank0<8>") getData("/I21/WdBank0<7>") getData("/I21/WdBank0<6>") getData("/I21/WdBank0<5>") getData("/I21/WdBank0<4>") getData("/I21/WdBank0<3>") getData("/I21/WdBank0<2>") getData("/I21/WdBank0<1>") getData("/I21/WdBank0<0>") getData("/I21/Bank0WAck<7>") getData("/I21/Bank0WAck<6>") getData("/I21/Bank0WAck<5>") getData("/I21/Bank0WAck<4>") getData("/I21/Bank0WAck<3>") getData("/I21/Bank0WAck<2>") getData("/I21/Bank0WAck<1>") getData("/I21/Bank0WAck<0>") getData("/I21/WdBank1<31>") getData("/I21/WdBank1<30>") getData("/I21/WdBank1<29>") getData("/I21/WdBank1<28>") getData("/I21/WdBank1<27>") getData("/I21/WdBank1<26>") getData("/I21/WdBank1<25>") getData("/I21/WdBank1<24>") getData("/I21/WdBank1<23>") getData("/I21/WdBank1<22>") getData("/I21/WdBank1<21>") getData("/I21/WdBank1<20>") getData("/I21/WdBank1<19>") getData("/I21/WdBank1<18>") getData("/I21/WdBank1<17>") getData("/I21/WdBank1<16>") getData("/I21/WdBank1<15>") getData("/I21/WdBank1<14>") getData("/I21/WdBank1<13>") getData("/I21/WdBank1<12>") getData("/I21/WdBank1<11>") getData("/I21/WdBank1<10>") getData("/I21/WdBank1<9>") getData("/I21/WdBank1<8>") getData("/I21/WdBank1<7>") getData("/I21/WdBank1<6>") getData("/I21/WdBank1<5>") getData("/I21/WdBank1<4>") getData("/I21/WdBank1<3>") getData("/I21/WdBank1<2>") getData("/I21/WdBank1<1>") getData("/I21/WdBank1<0>") getData("/I21/Bank1WAck<7>") getData("/I21/Bank1WAck<6>") getData("/I21/Bank1WAck<5>") getData("/I21/Bank1WAck<4>") getData("/I21/Bank1WAck<3>") getData("/I21/Bank1WAck<2>") getData("/I21/Bank1WAck<1>") getData("/I21/Bank1WAck<0>") getData("/I21/WdBank2<31>") getData("/I21/WdBank2<30>") getData("/I21/WdBank2<29>") getData("/I21/WdBank2<28>") getData("/I21/WdBank2<27>") getData("/I21/WdBank2<26>") getData("/I21/WdBank2<25>") getData("/I21/WdBank2<24>") getData("/I21/WdBank2<23>") getData("/I21/WdBank2<22>") getData("/I21/WdBank2<21>") getData("/I21/WdBank2<20>") getData("/I21/WdBank2<19>") getData("/I21/WdBank2<18>") getData("/I21/WdBank2<17>") getData("/I21/WdBank2<16>") getData("/I21/WdBank2<15>") getData("/I21/WdBank2<14>") getData("/I21/WdBank2<13>") getData("/I21/WdBank2<12>") getData("/I21/WdBank2<11>") getData("/I21/WdBank2<10>") getData("/I21/WdBank2<9>") getData("/I21/WdBank2<8>") getData("/I21/WdBank2<7>") getData("/I21/WdBank2<6>") getData("/I21/WdBank2<5>") getData("/I21/WdBank2<4>") getData("/I21/WdBank2<3>") getData("/I21/WdBank2<2>") getData("/I21/WdBank2<1>") getData("/I21/WdBank2<0>") getData("/I21/Bank2WAck<7>") getData("/I21/Bank2WAck<6>") getData("/I21/Bank2WAck<5>") getData("/I21/Bank2WAck<4>") getData("/I21/Bank2WAck<3>") getData("/I21/Bank2WAck<2>") getData("/I21/Bank2WAck<1>") getData("/I21/Bank2WAck<0>") getData("/I21/WdBank3<31>") getData("/I21/WdBank3<30>") getData("/I21/WdBank3<29>") getData("/I21/WdBank3<28>") getData("/I21/WdBank3<27>") getData("/I21/WdBank3<26>") getData("/I21/WdBank3<25>") getData("/I21/WdBank3<24>") getData("/I21/WdBank3<23>") getData("/I21/WdBank3<22>") getData("/I21/WdBank3<21>") getData("/I21/WdBank3<20>") getData("/I21/WdBank3<19>") getData("/I21/WdBank3<18>") getData("/I21/WdBank3<17>") getData("/I21/WdBank3<16>") getData("/I21/WdBank3<15>") getData("/I21/WdBank3<14>") getData("/I21/WdBank3<13>") getData("/I21/WdBank3<12>") getData("/I21/WdBank3<11>") getData("/I21/WdBank3<10>") getData("/I21/WdBank3<9>") getData("/I21/WdBank3<8>") getData("/I21/WdBank3<7>") getData("/I21/WdBank3<6>") getData("/I21/WdBank3<5>") getData("/I21/WdBank3<4>") getData("/I21/WdBank3<3>") getData("/I21/WdBank3<2>") getData("/I21/WdBank3<1>") getData("/I21/WdBank3<0>") getData("/I21/Bank3WAck<7>") getData("/I21/Bank3WAck<6>") getData("/I21/Bank3WAck<5>") getData("/I21/Bank3WAck<4>") getData("/I21/Bank3WAck<3>") getData("/I21/Bank3WAck<2>") getData("/I21/Bank3WAck<1>") getData("/I21/Bank3WAck<0>") getData("/I21/RdBank0<31>") getData("/I21/RdBank0<30>") getData("/I21/RdBank0<29>") getData("/I21/RdBank0<28>") getData("/I21/RdBank0<27>") getData("/I21/RdBank0<26>") getData("/I21/RdBank0<25>") getData("/I21/RdBank0<24>") getData("/I21/RdBank0<23>") getData("/I21/RdBank0<22>") getData("/I21/RdBank0<21>") getData("/I21/RdBank0<20>") getData("/I21/RdBank0<19>") getData("/I21/RdBank0<18>") getData("/I21/RdBank0<17>") getData("/I21/RdBank0<16>") getData("/I21/RdBank0<15>") getData("/I21/RdBank0<14>") getData("/I21/RdBank0<13>") getData("/I21/RdBank0<12>") getData("/I21/RdBank0<11>") getData("/I21/RdBank0<10>") getData("/I21/RdBank0<9>") getData("/I21/RdBank0<8>") getData("/I21/RdBank0<7>") getData("/I21/RdBank0<6>") getData("/I21/RdBank0<5>") getData("/I21/RdBank0<4>") getData("/I21/RdBank0<3>") getData("/I21/RdBank0<2>") getData("/I21/RdBank0<1>") getData("/I21/RdBank0<0>") getData("/I21/RdBank0Ack<7>") getData("/I21/RdBank0Ack<6>") getData("/I21/RdBank0Ack<5>") getData("/I21/RdBank0Ack<4>") getData("/I21/RdBank0Ack<3>") getData("/I21/RdBank0Ack<2>") getData("/I21/RdBank0Ack<1>") getData("/I21/RdBank0Ack<0>") getData("/I21/RdBank1<31>") getData("/I21/RdBank1<30>") getData("/I21/RdBank1<29>") getData("/I21/RdBank1<28>") getData("/I21/RdBank1<27>") getData("/I21/RdBank1<26>") getData("/I21/RdBank1<25>") getData("/I21/RdBank1<24>") getData("/I21/RdBank1<23>") getData("/I21/RdBank1<22>") getData("/I21/RdBank1<21>") getData("/I21/RdBank1<20>") getData("/I21/RdBank1<19>") getData("/I21/RdBank1<18>") getData("/I21/RdBank1<17>") getData("/I21/RdBank1<16>") getData("/I21/RdBank1<15>") getData("/I21/RdBank1<14>") getData("/I21/RdBank1<13>") getData("/I21/RdBank1<12>") getData("/I21/RdBank1<11>") getData("/I21/RdBank1<10>") getData("/I21/RdBank1<9>") getData("/I21/RdBank1<8>") getData("/I21/RdBank1<7>") getData("/I21/RdBank1<6>") getData("/I21/RdBank1<5>") getData("/I21/RdBank1<4>") getData("/I21/RdBank1<3>") getData("/I21/RdBank1<2>") getData("/I21/RdBank1<1>") getData("/I21/RdBank1<0>") getData("/I21/RdBank1Ack<7>") getData("/I21/RdBank1Ack<6>") getData("/I21/RdBank1Ack<5>") getData("/I21/RdBank1Ack<4>") getData("/I21/RdBank1Ack<3>") getData("/I21/RdBank1Ack<2>") getData("/I21/RdBank1Ack<1>") getData("/I21/RdBank1Ack<0>") getData("/WDataAckT<15>") getData("/WDataAckT<14>") getData("/WDataAckT<13>") getData("/WDataAckT<12>") getData("/WDataAckT<11>") getData("/WDataAckT<10>") getData("/WDataAckT<9>") getData("/WDataAckT<8>") getData("/WDataT<31>") getData("/WDataT<30>") getData("/WDataT<29>") getData("/WDataT<28>") getData("/WDataT<27>") getData("/WDataT<26>") getData("/WDataT<25>") getData("/WDataT<24>") getData("/WDataT<23>") getData("/WDataT<22>") getData("/WDataT<21>") getData("/WDataT<20>") getData("/WDataT<19>") getData("/WDataT<18>") getData("/WDataT<17>") getData("/WDataT<16>") getData("/WDataT<15>") getData("/WDataT<14>") getData("/WDataT<13>") getData("/WDataT<12>") getData("/WDataT<11>") getData("/WDataT<10>") getData("/WDataT<9>") getData("/WDataT<8>") getData("/WDataT<7>") getData("/WDataT<6>") getData("/WDataT<5>") getData("/WDataT<4>") getData("/WDataT<3>") getData("/WDataT<2>") getData("/WDataT<1>") getData("/WDataT<0>") getData("/Data1<31:0>") getData("/WDataAck<15:0>") getData("/RData<31:0>") getData("/RDataT<31>") getData("/RDataT<30>") getData("/RDataT<29>") getData("/RDataT<28>") getData("/RDataT<27>") getData("/RDataT<26>") getData("/RDataT<25>") getData("/RDataT<24>") getData("/RDataT<23>") getData("/RDataT<22>") getData("/RDataT<21>") getData("/RDataT<20>") getData("/RDataT<19>") getData("/RDataT<18>") getData("/RDataT<17>") getData("/RDataT<16>") getData("/RDataT<15>") getData("/RDataT<14>") getData("/RDataT<13>") getData("/RDataT<12>") getData("/RDataT<11>") getData("/RDataT<10>") getData("/RDataT<9>") getData("/RDataT<8>") getData("/RDataT<7>") getData("/RDataT<6>") getData("/RDataT<5>") getData("/RDataT<4>") getData("/RDataT<3>") getData("/RDataT<2>") getData("/RDataT<1>") getData("/RDataT<0>") )
resultsDir( "/net/bull/apps/Cadence/simulation/6T_MultiBank_16K_Test/spectreVerilog/config/distributed/job014" )
modelFile(
    '("/software/cadence/ncsu-FreePDK15/hspice_16nm_hp.include" "")
)
desVar(	  "vdd" .850	)
run( ?jobName "job" ?mail "rstdenis@ucdavis.edu" )
selectResult( 'tran )
plot(getData("/ReadEn") getData("/R_Address<11:0>") getData("/W_Address<11:0>") getData("/WriteEn") getData("/ReadAck") getData("/WriteAck") getData("/RAckT") getData("/WAckT") getData("/R_AddressT<11>") getData("/R_AddressT<10>") getData("/R_AddressT<9>") getData("/R_AddressT<8>") getData("/R_AddressT<7>") getData("/R_AddressT<6>") getData("/R_AddressT<5>") getData("/R_AddressT<4>") getData("/R_AddressT<3>") getData("/R_AddressT<2>") getData("/R_AddressT<1>") getData("/R_AddressT<0>") getData("/ReadEnT") getData("/W_AddressT<11>") getData("/W_AddressT<10>") getData("/W_AddressT<9>") getData("/W_AddressT<8>") getData("/W_AddressT<7>") getData("/W_AddressT<6>") getData("/W_AddressT<5>") getData("/W_AddressT<4>") getData("/W_AddressT<3>") getData("/W_AddressT<2>") getData("/W_AddressT<1>") getData("/W_AddressT<0>") getData("/WriteEnT") getData("/V0/MINUS") getData("/I21/WdBank0<31>") getData("/I21/WdBank0<30>") getData("/I21/WdBank0<29>") getData("/I21/WdBank0<28>") getData("/I21/WdBank0<27>") getData("/I21/WdBank0<26>") getData("/I21/WdBank0<25>") getData("/I21/WdBank0<24>") getData("/I21/WdBank0<23>") getData("/I21/WdBank0<22>") getData("/I21/WdBank0<21>") getData("/I21/WdBank0<20>") getData("/I21/WdBank0<19>") getData("/I21/WdBank0<18>") getData("/I21/WdBank0<17>") getData("/I21/WdBank0<16>") getData("/I21/WdBank0<15>") getData("/I21/WdBank0<14>") getData("/I21/WdBank0<13>") getData("/I21/WdBank0<12>") getData("/I21/WdBank0<11>") getData("/I21/WdBank0<10>") getData("/I21/WdBank0<9>") getData("/I21/WdBank0<8>") getData("/I21/WdBank0<7>") getData("/I21/WdBank0<6>") getData("/I21/WdBank0<5>") getData("/I21/WdBank0<4>") getData("/I21/WdBank0<3>") getData("/I21/WdBank0<2>") getData("/I21/WdBank0<1>") getData("/I21/WdBank0<0>") getData("/I21/Bank0WAck<7>") getData("/I21/Bank0WAck<6>") getData("/I21/Bank0WAck<5>") getData("/I21/Bank0WAck<4>") getData("/I21/Bank0WAck<3>") getData("/I21/Bank0WAck<2>") getData("/I21/Bank0WAck<1>") getData("/I21/Bank0WAck<0>") getData("/I21/WdBank1<31>") getData("/I21/WdBank1<30>") getData("/I21/WdBank1<29>") getData("/I21/WdBank1<28>") getData("/I21/WdBank1<27>") getData("/I21/WdBank1<26>") getData("/I21/WdBank1<25>") getData("/I21/WdBank1<24>") getData("/I21/WdBank1<23>") getData("/I21/WdBank1<22>") getData("/I21/WdBank1<21>") getData("/I21/WdBank1<20>") getData("/I21/WdBank1<19>") getData("/I21/WdBank1<18>") getData("/I21/WdBank1<17>") getData("/I21/WdBank1<16>") getData("/I21/WdBank1<15>") getData("/I21/WdBank1<14>") getData("/I21/WdBank1<13>") getData("/I21/WdBank1<12>") getData("/I21/WdBank1<11>") getData("/I21/WdBank1<10>") getData("/I21/WdBank1<9>") getData("/I21/WdBank1<8>") getData("/I21/WdBank1<7>") getData("/I21/WdBank1<6>") getData("/I21/WdBank1<5>") getData("/I21/WdBank1<4>") getData("/I21/WdBank1<3>") getData("/I21/WdBank1<2>") getData("/I21/WdBank1<1>") getData("/I21/WdBank1<0>") getData("/I21/Bank1WAck<7>") getData("/I21/Bank1WAck<6>") getData("/I21/Bank1WAck<5>") getData("/I21/Bank1WAck<4>") getData("/I21/Bank1WAck<3>") getData("/I21/Bank1WAck<2>") getData("/I21/Bank1WAck<1>") getData("/I21/Bank1WAck<0>") getData("/I21/WdBank2<31>") getData("/I21/WdBank2<30>") getData("/I21/WdBank2<29>") getData("/I21/WdBank2<28>") getData("/I21/WdBank2<27>") getData("/I21/WdBank2<26>") getData("/I21/WdBank2<25>") getData("/I21/WdBank2<24>") getData("/I21/WdBank2<23>") getData("/I21/WdBank2<22>") getData("/I21/WdBank2<21>") getData("/I21/WdBank2<20>") getData("/I21/WdBank2<19>") getData("/I21/WdBank2<18>") getData("/I21/WdBank2<17>") getData("/I21/WdBank2<16>") getData("/I21/WdBank2<15>") getData("/I21/WdBank2<14>") getData("/I21/WdBank2<13>") getData("/I21/WdBank2<12>") getData("/I21/WdBank2<11>") getData("/I21/WdBank2<10>") getData("/I21/WdBank2<9>") getData("/I21/WdBank2<8>") getData("/I21/WdBank2<7>") getData("/I21/WdBank2<6>") getData("/I21/WdBank2<5>") getData("/I21/WdBank2<4>") getData("/I21/WdBank2<3>") getData("/I21/WdBank2<2>") getData("/I21/WdBank2<1>") getData("/I21/WdBank2<0>") getData("/I21/Bank2WAck<7>") getData("/I21/Bank2WAck<6>") getData("/I21/Bank2WAck<5>") getData("/I21/Bank2WAck<4>") getData("/I21/Bank2WAck<3>") getData("/I21/Bank2WAck<2>") getData("/I21/Bank2WAck<1>") getData("/I21/Bank2WAck<0>") getData("/I21/WdBank3<31>") getData("/I21/WdBank3<30>") getData("/I21/WdBank3<29>") getData("/I21/WdBank3<28>") getData("/I21/WdBank3<27>") getData("/I21/WdBank3<26>") getData("/I21/WdBank3<25>") getData("/I21/WdBank3<24>") getData("/I21/WdBank3<23>") getData("/I21/WdBank3<22>") getData("/I21/WdBank3<21>") getData("/I21/WdBank3<20>") getData("/I21/WdBank3<19>") getData("/I21/WdBank3<18>") getData("/I21/WdBank3<17>") getData("/I21/WdBank3<16>") getData("/I21/WdBank3<15>") getData("/I21/WdBank3<14>") getData("/I21/WdBank3<13>") getData("/I21/WdBank3<12>") getData("/I21/WdBank3<11>") getData("/I21/WdBank3<10>") getData("/I21/WdBank3<9>") getData("/I21/WdBank3<8>") getData("/I21/WdBank3<7>") getData("/I21/WdBank3<6>") getData("/I21/WdBank3<5>") getData("/I21/WdBank3<4>") getData("/I21/WdBank3<3>") getData("/I21/WdBank3<2>") getData("/I21/WdBank3<1>") getData("/I21/WdBank3<0>") getData("/I21/Bank3WAck<7>") getData("/I21/Bank3WAck<6>") getData("/I21/Bank3WAck<5>") getData("/I21/Bank3WAck<4>") getData("/I21/Bank3WAck<3>") getData("/I21/Bank3WAck<2>") getData("/I21/Bank3WAck<1>") getData("/I21/Bank3WAck<0>") getData("/I21/RdBank0<31>") getData("/I21/RdBank0<30>") getData("/I21/RdBank0<29>") getData("/I21/RdBank0<28>") getData("/I21/RdBank0<27>") getData("/I21/RdBank0<26>") getData("/I21/RdBank0<25>") getData("/I21/RdBank0<24>") getData("/I21/RdBank0<23>") getData("/I21/RdBank0<22>") getData("/I21/RdBank0<21>") getData("/I21/RdBank0<20>") getData("/I21/RdBank0<19>") getData("/I21/RdBank0<18>") getData("/I21/RdBank0<17>") getData("/I21/RdBank0<16>") getData("/I21/RdBank0<15>") getData("/I21/RdBank0<14>") getData("/I21/RdBank0<13>") getData("/I21/RdBank0<12>") getData("/I21/RdBank0<11>") getData("/I21/RdBank0<10>") getData("/I21/RdBank0<9>") getData("/I21/RdBank0<8>") getData("/I21/RdBank0<7>") getData("/I21/RdBank0<6>") getData("/I21/RdBank0<5>") getData("/I21/RdBank0<4>") getData("/I21/RdBank0<3>") getData("/I21/RdBank0<2>") getData("/I21/RdBank0<1>") getData("/I21/RdBank0<0>") getData("/I21/RdBank0Ack<7>") getData("/I21/RdBank0Ack<6>") getData("/I21/RdBank0Ack<5>") getData("/I21/RdBank0Ack<4>") getData("/I21/RdBank0Ack<3>") getData("/I21/RdBank0Ack<2>") getData("/I21/RdBank0Ack<1>") getData("/I21/RdBank0Ack<0>") getData("/I21/RdBank1<31>") getData("/I21/RdBank1<30>") getData("/I21/RdBank1<29>") getData("/I21/RdBank1<28>") getData("/I21/RdBank1<27>") getData("/I21/RdBank1<26>") getData("/I21/RdBank1<25>") getData("/I21/RdBank1<24>") getData("/I21/RdBank1<23>") getData("/I21/RdBank1<22>") getData("/I21/RdBank1<21>") getData("/I21/RdBank1<20>") getData("/I21/RdBank1<19>") getData("/I21/RdBank1<18>") getData("/I21/RdBank1<17>") getData("/I21/RdBank1<16>") getData("/I21/RdBank1<15>") getData("/I21/RdBank1<14>") getData("/I21/RdBank1<13>") getData("/I21/RdBank1<12>") getData("/I21/RdBank1<11>") getData("/I21/RdBank1<10>") getData("/I21/RdBank1<9>") getData("/I21/RdBank1<8>") getData("/I21/RdBank1<7>") getData("/I21/RdBank1<6>") getData("/I21/RdBank1<5>") getData("/I21/RdBank1<4>") getData("/I21/RdBank1<3>") getData("/I21/RdBank1<2>") getData("/I21/RdBank1<1>") getData("/I21/RdBank1<0>") getData("/I21/RdBank1Ack<7>") getData("/I21/RdBank1Ack<6>") getData("/I21/RdBank1Ack<5>") getData("/I21/RdBank1Ack<4>") getData("/I21/RdBank1Ack<3>") getData("/I21/RdBank1Ack<2>") getData("/I21/RdBank1Ack<1>") getData("/I21/RdBank1Ack<0>") getData("/WDataAckT<15>") getData("/WDataAckT<14>") getData("/WDataAckT<13>") getData("/WDataAckT<12>") getData("/WDataAckT<11>") getData("/WDataAckT<10>") getData("/WDataAckT<9>") getData("/WDataAckT<8>") getData("/WDataT<31>") getData("/WDataT<30>") getData("/WDataT<29>") getData("/WDataT<28>") getData("/WDataT<27>") getData("/WDataT<26>") getData("/WDataT<25>") getData("/WDataT<24>") getData("/WDataT<23>") getData("/WDataT<22>") getData("/WDataT<21>") getData("/WDataT<20>") getData("/WDataT<19>") getData("/WDataT<18>") getData("/WDataT<17>") getData("/WDataT<16>") getData("/WDataT<15>") getData("/WDataT<14>") getData("/WDataT<13>") getData("/WDataT<12>") getData("/WDataT<11>") getData("/WDataT<10>") getData("/WDataT<9>") getData("/WDataT<8>") getData("/WDataT<7>") getData("/WDataT<6>") getData("/WDataT<5>") getData("/WDataT<4>") getData("/WDataT<3>") getData("/WDataT<2>") getData("/WDataT<1>") getData("/WDataT<0>") getData("/Data1<31:0>") getData("/WDataAck<15:0>") getData("/RData<31:0>") getData("/RDataT<31>") getData("/RDataT<30>") getData("/RDataT<29>") getData("/RDataT<28>") getData("/RDataT<27>") getData("/RDataT<26>") getData("/RDataT<25>") getData("/RDataT<24>") getData("/RDataT<23>") getData("/RDataT<22>") getData("/RDataT<21>") getData("/RDataT<20>") getData("/RDataT<19>") getData("/RDataT<18>") getData("/RDataT<17>") getData("/RDataT<16>") getData("/RDataT<15>") getData("/RDataT<14>") getData("/RDataT<13>") getData("/RDataT<12>") getData("/RDataT<11>") getData("/RDataT<10>") getData("/RDataT<9>") getData("/RDataT<8>") getData("/RDataT<7>") getData("/RDataT<6>") getData("/RDataT<5>") getData("/RDataT<4>") getData("/RDataT<3>") getData("/RDataT<2>") getData("/RDataT<1>") getData("/RDataT<0>") )
resultsDir( "/net/bull/apps/Cadence/simulation/6T_MultiBank_16K_Test/spectreVerilog/config/distributed/job015" )
modelFile(
    '("/software/cadence/ncsu-FreePDK15/hspice_16nm_hp.include" "")
)
desVar(	  "vdd" .500	)
option(	'temp  "57.5"
)
temp( 57.5 )
run( ?jobName "job" ?mail "rstdenis@ucdavis.edu" )
selectResult( 'tran )
plot(getData("/ReadEn") getData("/R_Address<11:0>") getData("/W_Address<11:0>") getData("/WriteEn") getData("/ReadAck") getData("/WriteAck") getData("/RAckT") getData("/WAckT") getData("/R_AddressT<11>") getData("/R_AddressT<10>") getData("/R_AddressT<9>") getData("/R_AddressT<8>") getData("/R_AddressT<7>") getData("/R_AddressT<6>") getData("/R_AddressT<5>") getData("/R_AddressT<4>") getData("/R_AddressT<3>") getData("/R_AddressT<2>") getData("/R_AddressT<1>") getData("/R_AddressT<0>") getData("/ReadEnT") getData("/W_AddressT<11>") getData("/W_AddressT<10>") getData("/W_AddressT<9>") getData("/W_AddressT<8>") getData("/W_AddressT<7>") getData("/W_AddressT<6>") getData("/W_AddressT<5>") getData("/W_AddressT<4>") getData("/W_AddressT<3>") getData("/W_AddressT<2>") getData("/W_AddressT<1>") getData("/W_AddressT<0>") getData("/WriteEnT") getData("/V0/MINUS") getData("/I21/WdBank0<31>") getData("/I21/WdBank0<30>") getData("/I21/WdBank0<29>") getData("/I21/WdBank0<28>") getData("/I21/WdBank0<27>") getData("/I21/WdBank0<26>") getData("/I21/WdBank0<25>") getData("/I21/WdBank0<24>") getData("/I21/WdBank0<23>") getData("/I21/WdBank0<22>") getData("/I21/WdBank0<21>") getData("/I21/WdBank0<20>") getData("/I21/WdBank0<19>") getData("/I21/WdBank0<18>") getData("/I21/WdBank0<17>") getData("/I21/WdBank0<16>") getData("/I21/WdBank0<15>") getData("/I21/WdBank0<14>") getData("/I21/WdBank0<13>") getData("/I21/WdBank0<12>") getData("/I21/WdBank0<11>") getData("/I21/WdBank0<10>") getData("/I21/WdBank0<9>") getData("/I21/WdBank0<8>") getData("/I21/WdBank0<7>") getData("/I21/WdBank0<6>") getData("/I21/WdBank0<5>") getData("/I21/WdBank0<4>") getData("/I21/WdBank0<3>") getData("/I21/WdBank0<2>") getData("/I21/WdBank0<1>") getData("/I21/WdBank0<0>") getData("/I21/Bank0WAck<7>") getData("/I21/Bank0WAck<6>") getData("/I21/Bank0WAck<5>") getData("/I21/Bank0WAck<4>") getData("/I21/Bank0WAck<3>") getData("/I21/Bank0WAck<2>") getData("/I21/Bank0WAck<1>") getData("/I21/Bank0WAck<0>") getData("/I21/WdBank1<31>") getData("/I21/WdBank1<30>") getData("/I21/WdBank1<29>") getData("/I21/WdBank1<28>") getData("/I21/WdBank1<27>") getData("/I21/WdBank1<26>") getData("/I21/WdBank1<25>") getData("/I21/WdBank1<24>") getData("/I21/WdBank1<23>") getData("/I21/WdBank1<22>") getData("/I21/WdBank1<21>") getData("/I21/WdBank1<20>") getData("/I21/WdBank1<19>") getData("/I21/WdBank1<18>") getData("/I21/WdBank1<17>") getData("/I21/WdBank1<16>") getData("/I21/WdBank1<15>") getData("/I21/WdBank1<14>") getData("/I21/WdBank1<13>") getData("/I21/WdBank1<12>") getData("/I21/WdBank1<11>") getData("/I21/WdBank1<10>") getData("/I21/WdBank1<9>") getData("/I21/WdBank1<8>") getData("/I21/WdBank1<7>") getData("/I21/WdBank1<6>") getData("/I21/WdBank1<5>") getData("/I21/WdBank1<4>") getData("/I21/WdBank1<3>") getData("/I21/WdBank1<2>") getData("/I21/WdBank1<1>") getData("/I21/WdBank1<0>") getData("/I21/Bank1WAck<7>") getData("/I21/Bank1WAck<6>") getData("/I21/Bank1WAck<5>") getData("/I21/Bank1WAck<4>") getData("/I21/Bank1WAck<3>") getData("/I21/Bank1WAck<2>") getData("/I21/Bank1WAck<1>") getData("/I21/Bank1WAck<0>") getData("/I21/WdBank2<31>") getData("/I21/WdBank2<30>") getData("/I21/WdBank2<29>") getData("/I21/WdBank2<28>") getData("/I21/WdBank2<27>") getData("/I21/WdBank2<26>") getData("/I21/WdBank2<25>") getData("/I21/WdBank2<24>") getData("/I21/WdBank2<23>") getData("/I21/WdBank2<22>") getData("/I21/WdBank2<21>") getData("/I21/WdBank2<20>") getData("/I21/WdBank2<19>") getData("/I21/WdBank2<18>") getData("/I21/WdBank2<17>") getData("/I21/WdBank2<16>") getData("/I21/WdBank2<15>") getData("/I21/WdBank2<14>") getData("/I21/WdBank2<13>") getData("/I21/WdBank2<12>") getData("/I21/WdBank2<11>") getData("/I21/WdBank2<10>") getData("/I21/WdBank2<9>") getData("/I21/WdBank2<8>") getData("/I21/WdBank2<7>") getData("/I21/WdBank2<6>") getData("/I21/WdBank2<5>") getData("/I21/WdBank2<4>") getData("/I21/WdBank2<3>") getData("/I21/WdBank2<2>") getData("/I21/WdBank2<1>") getData("/I21/WdBank2<0>") getData("/I21/Bank2WAck<7>") getData("/I21/Bank2WAck<6>") getData("/I21/Bank2WAck<5>") getData("/I21/Bank2WAck<4>") getData("/I21/Bank2WAck<3>") getData("/I21/Bank2WAck<2>") getData("/I21/Bank2WAck<1>") getData("/I21/Bank2WAck<0>") getData("/I21/WdBank3<31>") getData("/I21/WdBank3<30>") getData("/I21/WdBank3<29>") getData("/I21/WdBank3<28>") getData("/I21/WdBank3<27>") getData("/I21/WdBank3<26>") getData("/I21/WdBank3<25>") getData("/I21/WdBank3<24>") getData("/I21/WdBank3<23>") getData("/I21/WdBank3<22>") getData("/I21/WdBank3<21>") getData("/I21/WdBank3<20>") getData("/I21/WdBank3<19>") getData("/I21/WdBank3<18>") getData("/I21/WdBank3<17>") getData("/I21/WdBank3<16>") getData("/I21/WdBank3<15>") getData("/I21/WdBank3<14>") getData("/I21/WdBank3<13>") getData("/I21/WdBank3<12>") getData("/I21/WdBank3<11>") getData("/I21/WdBank3<10>") getData("/I21/WdBank3<9>") getData("/I21/WdBank3<8>") getData("/I21/WdBank3<7>") getData("/I21/WdBank3<6>") getData("/I21/WdBank3<5>") getData("/I21/WdBank3<4>") getData("/I21/WdBank3<3>") getData("/I21/WdBank3<2>") getData("/I21/WdBank3<1>") getData("/I21/WdBank3<0>") getData("/I21/Bank3WAck<7>") getData("/I21/Bank3WAck<6>") getData("/I21/Bank3WAck<5>") getData("/I21/Bank3WAck<4>") getData("/I21/Bank3WAck<3>") getData("/I21/Bank3WAck<2>") getData("/I21/Bank3WAck<1>") getData("/I21/Bank3WAck<0>") getData("/I21/RdBank0<31>") getData("/I21/RdBank0<30>") getData("/I21/RdBank0<29>") getData("/I21/RdBank0<28>") getData("/I21/RdBank0<27>") getData("/I21/RdBank0<26>") getData("/I21/RdBank0<25>") getData("/I21/RdBank0<24>") getData("/I21/RdBank0<23>") getData("/I21/RdBank0<22>") getData("/I21/RdBank0<21>") getData("/I21/RdBank0<20>") getData("/I21/RdBank0<19>") getData("/I21/RdBank0<18>") getData("/I21/RdBank0<17>") getData("/I21/RdBank0<16>") getData("/I21/RdBank0<15>") getData("/I21/RdBank0<14>") getData("/I21/RdBank0<13>") getData("/I21/RdBank0<12>") getData("/I21/RdBank0<11>") getData("/I21/RdBank0<10>") getData("/I21/RdBank0<9>") getData("/I21/RdBank0<8>") getData("/I21/RdBank0<7>") getData("/I21/RdBank0<6>") getData("/I21/RdBank0<5>") getData("/I21/RdBank0<4>") getData("/I21/RdBank0<3>") getData("/I21/RdBank0<2>") getData("/I21/RdBank0<1>") getData("/I21/RdBank0<0>") getData("/I21/RdBank0Ack<7>") getData("/I21/RdBank0Ack<6>") getData("/I21/RdBank0Ack<5>") getData("/I21/RdBank0Ack<4>") getData("/I21/RdBank0Ack<3>") getData("/I21/RdBank0Ack<2>") getData("/I21/RdBank0Ack<1>") getData("/I21/RdBank0Ack<0>") getData("/I21/RdBank1<31>") getData("/I21/RdBank1<30>") getData("/I21/RdBank1<29>") getData("/I21/RdBank1<28>") getData("/I21/RdBank1<27>") getData("/I21/RdBank1<26>") getData("/I21/RdBank1<25>") getData("/I21/RdBank1<24>") getData("/I21/RdBank1<23>") getData("/I21/RdBank1<22>") getData("/I21/RdBank1<21>") getData("/I21/RdBank1<20>") getData("/I21/RdBank1<19>") getData("/I21/RdBank1<18>") getData("/I21/RdBank1<17>") getData("/I21/RdBank1<16>") getData("/I21/RdBank1<15>") getData("/I21/RdBank1<14>") getData("/I21/RdBank1<13>") getData("/I21/RdBank1<12>") getData("/I21/RdBank1<11>") getData("/I21/RdBank1<10>") getData("/I21/RdBank1<9>") getData("/I21/RdBank1<8>") getData("/I21/RdBank1<7>") getData("/I21/RdBank1<6>") getData("/I21/RdBank1<5>") getData("/I21/RdBank1<4>") getData("/I21/RdBank1<3>") getData("/I21/RdBank1<2>") getData("/I21/RdBank1<1>") getData("/I21/RdBank1<0>") getData("/I21/RdBank1Ack<7>") getData("/I21/RdBank1Ack<6>") getData("/I21/RdBank1Ack<5>") getData("/I21/RdBank1Ack<4>") getData("/I21/RdBank1Ack<3>") getData("/I21/RdBank1Ack<2>") getData("/I21/RdBank1Ack<1>") getData("/I21/RdBank1Ack<0>") getData("/WDataAckT<15>") getData("/WDataAckT<14>") getData("/WDataAckT<13>") getData("/WDataAckT<12>") getData("/WDataAckT<11>") getData("/WDataAckT<10>") getData("/WDataAckT<9>") getData("/WDataAckT<8>") getData("/WDataT<31>") getData("/WDataT<30>") getData("/WDataT<29>") getData("/WDataT<28>") getData("/WDataT<27>") getData("/WDataT<26>") getData("/WDataT<25>") getData("/WDataT<24>") getData("/WDataT<23>") getData("/WDataT<22>") getData("/WDataT<21>") getData("/WDataT<20>") getData("/WDataT<19>") getData("/WDataT<18>") getData("/WDataT<17>") getData("/WDataT<16>") getData("/WDataT<15>") getData("/WDataT<14>") getData("/WDataT<13>") getData("/WDataT<12>") getData("/WDataT<11>") getData("/WDataT<10>") getData("/WDataT<9>") getData("/WDataT<8>") getData("/WDataT<7>") getData("/WDataT<6>") getData("/WDataT<5>") getData("/WDataT<4>") getData("/WDataT<3>") getData("/WDataT<2>") getData("/WDataT<1>") getData("/WDataT<0>") getData("/Data1<31:0>") getData("/WDataAck<15:0>") getData("/RData<31:0>") getData("/RDataT<31>") getData("/RDataT<30>") getData("/RDataT<29>") getData("/RDataT<28>") getData("/RDataT<27>") getData("/RDataT<26>") getData("/RDataT<25>") getData("/RDataT<24>") getData("/RDataT<23>") getData("/RDataT<22>") getData("/RDataT<21>") getData("/RDataT<20>") getData("/RDataT<19>") getData("/RDataT<18>") getData("/RDataT<17>") getData("/RDataT<16>") getData("/RDataT<15>") getData("/RDataT<14>") getData("/RDataT<13>") getData("/RDataT<12>") getData("/RDataT<11>") getData("/RDataT<10>") getData("/RDataT<9>") getData("/RDataT<8>") getData("/RDataT<7>") getData("/RDataT<6>") getData("/RDataT<5>") getData("/RDataT<4>") getData("/RDataT<3>") getData("/RDataT<2>") getData("/RDataT<1>") getData("/RDataT<0>") )
resultsDir( "/net/bull/apps/Cadence/simulation/6T_MultiBank_16K_Test/spectreVerilog/config/distributed/job016" )
modelFile(
    '("/software/cadence/ncsu-FreePDK15/hspice_16nm_hp.include" "")
)
desVar(	  "vdd" .675	)
run( ?jobName "job" ?mail "rstdenis@ucdavis.edu" )
selectResult( 'tran )
plot(getData("/ReadEn") getData("/R_Address<11:0>") getData("/W_Address<11:0>") getData("/WriteEn") getData("/ReadAck") getData("/WriteAck") getData("/RAckT") getData("/WAckT") getData("/R_AddressT<11>") getData("/R_AddressT<10>") getData("/R_AddressT<9>") getData("/R_AddressT<8>") getData("/R_AddressT<7>") getData("/R_AddressT<6>") getData("/R_AddressT<5>") getData("/R_AddressT<4>") getData("/R_AddressT<3>") getData("/R_AddressT<2>") getData("/R_AddressT<1>") getData("/R_AddressT<0>") getData("/ReadEnT") getData("/W_AddressT<11>") getData("/W_AddressT<10>") getData("/W_AddressT<9>") getData("/W_AddressT<8>") getData("/W_AddressT<7>") getData("/W_AddressT<6>") getData("/W_AddressT<5>") getData("/W_AddressT<4>") getData("/W_AddressT<3>") getData("/W_AddressT<2>") getData("/W_AddressT<1>") getData("/W_AddressT<0>") getData("/WriteEnT") getData("/V0/MINUS") getData("/I21/WdBank0<31>") getData("/I21/WdBank0<30>") getData("/I21/WdBank0<29>") getData("/I21/WdBank0<28>") getData("/I21/WdBank0<27>") getData("/I21/WdBank0<26>") getData("/I21/WdBank0<25>") getData("/I21/WdBank0<24>") getData("/I21/WdBank0<23>") getData("/I21/WdBank0<22>") getData("/I21/WdBank0<21>") getData("/I21/WdBank0<20>") getData("/I21/WdBank0<19>") getData("/I21/WdBank0<18>") getData("/I21/WdBank0<17>") getData("/I21/WdBank0<16>") getData("/I21/WdBank0<15>") getData("/I21/WdBank0<14>") getData("/I21/WdBank0<13>") getData("/I21/WdBank0<12>") getData("/I21/WdBank0<11>") getData("/I21/WdBank0<10>") getData("/I21/WdBank0<9>") getData("/I21/WdBank0<8>") getData("/I21/WdBank0<7>") getData("/I21/WdBank0<6>") getData("/I21/WdBank0<5>") getData("/I21/WdBank0<4>") getData("/I21/WdBank0<3>") getData("/I21/WdBank0<2>") getData("/I21/WdBank0<1>") getData("/I21/WdBank0<0>") getData("/I21/Bank0WAck<7>") getData("/I21/Bank0WAck<6>") getData("/I21/Bank0WAck<5>") getData("/I21/Bank0WAck<4>") getData("/I21/Bank0WAck<3>") getData("/I21/Bank0WAck<2>") getData("/I21/Bank0WAck<1>") getData("/I21/Bank0WAck<0>") getData("/I21/WdBank1<31>") getData("/I21/WdBank1<30>") getData("/I21/WdBank1<29>") getData("/I21/WdBank1<28>") getData("/I21/WdBank1<27>") getData("/I21/WdBank1<26>") getData("/I21/WdBank1<25>") getData("/I21/WdBank1<24>") getData("/I21/WdBank1<23>") getData("/I21/WdBank1<22>") getData("/I21/WdBank1<21>") getData("/I21/WdBank1<20>") getData("/I21/WdBank1<19>") getData("/I21/WdBank1<18>") getData("/I21/WdBank1<17>") getData("/I21/WdBank1<16>") getData("/I21/WdBank1<15>") getData("/I21/WdBank1<14>") getData("/I21/WdBank1<13>") getData("/I21/WdBank1<12>") getData("/I21/WdBank1<11>") getData("/I21/WdBank1<10>") getData("/I21/WdBank1<9>") getData("/I21/WdBank1<8>") getData("/I21/WdBank1<7>") getData("/I21/WdBank1<6>") getData("/I21/WdBank1<5>") getData("/I21/WdBank1<4>") getData("/I21/WdBank1<3>") getData("/I21/WdBank1<2>") getData("/I21/WdBank1<1>") getData("/I21/WdBank1<0>") getData("/I21/Bank1WAck<7>") getData("/I21/Bank1WAck<6>") getData("/I21/Bank1WAck<5>") getData("/I21/Bank1WAck<4>") getData("/I21/Bank1WAck<3>") getData("/I21/Bank1WAck<2>") getData("/I21/Bank1WAck<1>") getData("/I21/Bank1WAck<0>") getData("/I21/WdBank2<31>") getData("/I21/WdBank2<30>") getData("/I21/WdBank2<29>") getData("/I21/WdBank2<28>") getData("/I21/WdBank2<27>") getData("/I21/WdBank2<26>") getData("/I21/WdBank2<25>") getData("/I21/WdBank2<24>") getData("/I21/WdBank2<23>") getData("/I21/WdBank2<22>") getData("/I21/WdBank2<21>") getData("/I21/WdBank2<20>") getData("/I21/WdBank2<19>") getData("/I21/WdBank2<18>") getData("/I21/WdBank2<17>") getData("/I21/WdBank2<16>") getData("/I21/WdBank2<15>") getData("/I21/WdBank2<14>") getData("/I21/WdBank2<13>") getData("/I21/WdBank2<12>") getData("/I21/WdBank2<11>") getData("/I21/WdBank2<10>") getData("/I21/WdBank2<9>") getData("/I21/WdBank2<8>") getData("/I21/WdBank2<7>") getData("/I21/WdBank2<6>") getData("/I21/WdBank2<5>") getData("/I21/WdBank2<4>") getData("/I21/WdBank2<3>") getData("/I21/WdBank2<2>") getData("/I21/WdBank2<1>") getData("/I21/WdBank2<0>") getData("/I21/Bank2WAck<7>") getData("/I21/Bank2WAck<6>") getData("/I21/Bank2WAck<5>") getData("/I21/Bank2WAck<4>") getData("/I21/Bank2WAck<3>") getData("/I21/Bank2WAck<2>") getData("/I21/Bank2WAck<1>") getData("/I21/Bank2WAck<0>") getData("/I21/WdBank3<31>") getData("/I21/WdBank3<30>") getData("/I21/WdBank3<29>") getData("/I21/WdBank3<28>") getData("/I21/WdBank3<27>") getData("/I21/WdBank3<26>") getData("/I21/WdBank3<25>") getData("/I21/WdBank3<24>") getData("/I21/WdBank3<23>") getData("/I21/WdBank3<22>") getData("/I21/WdBank3<21>") getData("/I21/WdBank3<20>") getData("/I21/WdBank3<19>") getData("/I21/WdBank3<18>") getData("/I21/WdBank3<17>") getData("/I21/WdBank3<16>") getData("/I21/WdBank3<15>") getData("/I21/WdBank3<14>") getData("/I21/WdBank3<13>") getData("/I21/WdBank3<12>") getData("/I21/WdBank3<11>") getData("/I21/WdBank3<10>") getData("/I21/WdBank3<9>") getData("/I21/WdBank3<8>") getData("/I21/WdBank3<7>") getData("/I21/WdBank3<6>") getData("/I21/WdBank3<5>") getData("/I21/WdBank3<4>") getData("/I21/WdBank3<3>") getData("/I21/WdBank3<2>") getData("/I21/WdBank3<1>") getData("/I21/WdBank3<0>") getData("/I21/Bank3WAck<7>") getData("/I21/Bank3WAck<6>") getData("/I21/Bank3WAck<5>") getData("/I21/Bank3WAck<4>") getData("/I21/Bank3WAck<3>") getData("/I21/Bank3WAck<2>") getData("/I21/Bank3WAck<1>") getData("/I21/Bank3WAck<0>") getData("/I21/RdBank0<31>") getData("/I21/RdBank0<30>") getData("/I21/RdBank0<29>") getData("/I21/RdBank0<28>") getData("/I21/RdBank0<27>") getData("/I21/RdBank0<26>") getData("/I21/RdBank0<25>") getData("/I21/RdBank0<24>") getData("/I21/RdBank0<23>") getData("/I21/RdBank0<22>") getData("/I21/RdBank0<21>") getData("/I21/RdBank0<20>") getData("/I21/RdBank0<19>") getData("/I21/RdBank0<18>") getData("/I21/RdBank0<17>") getData("/I21/RdBank0<16>") getData("/I21/RdBank0<15>") getData("/I21/RdBank0<14>") getData("/I21/RdBank0<13>") getData("/I21/RdBank0<12>") getData("/I21/RdBank0<11>") getData("/I21/RdBank0<10>") getData("/I21/RdBank0<9>") getData("/I21/RdBank0<8>") getData("/I21/RdBank0<7>") getData("/I21/RdBank0<6>") getData("/I21/RdBank0<5>") getData("/I21/RdBank0<4>") getData("/I21/RdBank0<3>") getData("/I21/RdBank0<2>") getData("/I21/RdBank0<1>") getData("/I21/RdBank0<0>") getData("/I21/RdBank0Ack<7>") getData("/I21/RdBank0Ack<6>") getData("/I21/RdBank0Ack<5>") getData("/I21/RdBank0Ack<4>") getData("/I21/RdBank0Ack<3>") getData("/I21/RdBank0Ack<2>") getData("/I21/RdBank0Ack<1>") getData("/I21/RdBank0Ack<0>") getData("/I21/RdBank1<31>") getData("/I21/RdBank1<30>") getData("/I21/RdBank1<29>") getData("/I21/RdBank1<28>") getData("/I21/RdBank1<27>") getData("/I21/RdBank1<26>") getData("/I21/RdBank1<25>") getData("/I21/RdBank1<24>") getData("/I21/RdBank1<23>") getData("/I21/RdBank1<22>") getData("/I21/RdBank1<21>") getData("/I21/RdBank1<20>") getData("/I21/RdBank1<19>") getData("/I21/RdBank1<18>") getData("/I21/RdBank1<17>") getData("/I21/RdBank1<16>") getData("/I21/RdBank1<15>") getData("/I21/RdBank1<14>") getData("/I21/RdBank1<13>") getData("/I21/RdBank1<12>") getData("/I21/RdBank1<11>") getData("/I21/RdBank1<10>") getData("/I21/RdBank1<9>") getData("/I21/RdBank1<8>") getData("/I21/RdBank1<7>") getData("/I21/RdBank1<6>") getData("/I21/RdBank1<5>") getData("/I21/RdBank1<4>") getData("/I21/RdBank1<3>") getData("/I21/RdBank1<2>") getData("/I21/RdBank1<1>") getData("/I21/RdBank1<0>") getData("/I21/RdBank1Ack<7>") getData("/I21/RdBank1Ack<6>") getData("/I21/RdBank1Ack<5>") getData("/I21/RdBank1Ack<4>") getData("/I21/RdBank1Ack<3>") getData("/I21/RdBank1Ack<2>") getData("/I21/RdBank1Ack<1>") getData("/I21/RdBank1Ack<0>") getData("/WDataAckT<15>") getData("/WDataAckT<14>") getData("/WDataAckT<13>") getData("/WDataAckT<12>") getData("/WDataAckT<11>") getData("/WDataAckT<10>") getData("/WDataAckT<9>") getData("/WDataAckT<8>") getData("/WDataT<31>") getData("/WDataT<30>") getData("/WDataT<29>") getData("/WDataT<28>") getData("/WDataT<27>") getData("/WDataT<26>") getData("/WDataT<25>") getData("/WDataT<24>") getData("/WDataT<23>") getData("/WDataT<22>") getData("/WDataT<21>") getData("/WDataT<20>") getData("/WDataT<19>") getData("/WDataT<18>") getData("/WDataT<17>") getData("/WDataT<16>") getData("/WDataT<15>") getData("/WDataT<14>") getData("/WDataT<13>") getData("/WDataT<12>") getData("/WDataT<11>") getData("/WDataT<10>") getData("/WDataT<9>") getData("/WDataT<8>") getData("/WDataT<7>") getData("/WDataT<6>") getData("/WDataT<5>") getData("/WDataT<4>") getData("/WDataT<3>") getData("/WDataT<2>") getData("/WDataT<1>") getData("/WDataT<0>") getData("/Data1<31:0>") getData("/WDataAck<15:0>") getData("/RData<31:0>") getData("/RDataT<31>") getData("/RDataT<30>") getData("/RDataT<29>") getData("/RDataT<28>") getData("/RDataT<27>") getData("/RDataT<26>") getData("/RDataT<25>") getData("/RDataT<24>") getData("/RDataT<23>") getData("/RDataT<22>") getData("/RDataT<21>") getData("/RDataT<20>") getData("/RDataT<19>") getData("/RDataT<18>") getData("/RDataT<17>") getData("/RDataT<16>") getData("/RDataT<15>") getData("/RDataT<14>") getData("/RDataT<13>") getData("/RDataT<12>") getData("/RDataT<11>") getData("/RDataT<10>") getData("/RDataT<9>") getData("/RDataT<8>") getData("/RDataT<7>") getData("/RDataT<6>") getData("/RDataT<5>") getData("/RDataT<4>") getData("/RDataT<3>") getData("/RDataT<2>") getData("/RDataT<1>") getData("/RDataT<0>") )
resultsDir( "/net/bull/apps/Cadence/simulation/6T_MultiBank_16K_Test/spectreVerilog/config/distributed/job017" )
modelFile(
    '("/software/cadence/ncsu-FreePDK15/hspice_16nm_hp.include" "")
)
desVar(	  "vdd" .850	)
run( ?jobName "job" ?mail "rstdenis@ucdavis.edu" )
selectResult( 'tran )
plot(getData("/ReadEn") getData("/R_Address<11:0>") getData("/W_Address<11:0>") getData("/WriteEn") getData("/ReadAck") getData("/WriteAck") getData("/RAckT") getData("/WAckT") getData("/R_AddressT<11>") getData("/R_AddressT<10>") getData("/R_AddressT<9>") getData("/R_AddressT<8>") getData("/R_AddressT<7>") getData("/R_AddressT<6>") getData("/R_AddressT<5>") getData("/R_AddressT<4>") getData("/R_AddressT<3>") getData("/R_AddressT<2>") getData("/R_AddressT<1>") getData("/R_AddressT<0>") getData("/ReadEnT") getData("/W_AddressT<11>") getData("/W_AddressT<10>") getData("/W_AddressT<9>") getData("/W_AddressT<8>") getData("/W_AddressT<7>") getData("/W_AddressT<6>") getData("/W_AddressT<5>") getData("/W_AddressT<4>") getData("/W_AddressT<3>") getData("/W_AddressT<2>") getData("/W_AddressT<1>") getData("/W_AddressT<0>") getData("/WriteEnT") getData("/V0/MINUS") getData("/I21/WdBank0<31>") getData("/I21/WdBank0<30>") getData("/I21/WdBank0<29>") getData("/I21/WdBank0<28>") getData("/I21/WdBank0<27>") getData("/I21/WdBank0<26>") getData("/I21/WdBank0<25>") getData("/I21/WdBank0<24>") getData("/I21/WdBank0<23>") getData("/I21/WdBank0<22>") getData("/I21/WdBank0<21>") getData("/I21/WdBank0<20>") getData("/I21/WdBank0<19>") getData("/I21/WdBank0<18>") getData("/I21/WdBank0<17>") getData("/I21/WdBank0<16>") getData("/I21/WdBank0<15>") getData("/I21/WdBank0<14>") getData("/I21/WdBank0<13>") getData("/I21/WdBank0<12>") getData("/I21/WdBank0<11>") getData("/I21/WdBank0<10>") getData("/I21/WdBank0<9>") getData("/I21/WdBank0<8>") getData("/I21/WdBank0<7>") getData("/I21/WdBank0<6>") getData("/I21/WdBank0<5>") getData("/I21/WdBank0<4>") getData("/I21/WdBank0<3>") getData("/I21/WdBank0<2>") getData("/I21/WdBank0<1>") getData("/I21/WdBank0<0>") getData("/I21/Bank0WAck<7>") getData("/I21/Bank0WAck<6>") getData("/I21/Bank0WAck<5>") getData("/I21/Bank0WAck<4>") getData("/I21/Bank0WAck<3>") getData("/I21/Bank0WAck<2>") getData("/I21/Bank0WAck<1>") getData("/I21/Bank0WAck<0>") getData("/I21/WdBank1<31>") getData("/I21/WdBank1<30>") getData("/I21/WdBank1<29>") getData("/I21/WdBank1<28>") getData("/I21/WdBank1<27>") getData("/I21/WdBank1<26>") getData("/I21/WdBank1<25>") getData("/I21/WdBank1<24>") getData("/I21/WdBank1<23>") getData("/I21/WdBank1<22>") getData("/I21/WdBank1<21>") getData("/I21/WdBank1<20>") getData("/I21/WdBank1<19>") getData("/I21/WdBank1<18>") getData("/I21/WdBank1<17>") getData("/I21/WdBank1<16>") getData("/I21/WdBank1<15>") getData("/I21/WdBank1<14>") getData("/I21/WdBank1<13>") getData("/I21/WdBank1<12>") getData("/I21/WdBank1<11>") getData("/I21/WdBank1<10>") getData("/I21/WdBank1<9>") getData("/I21/WdBank1<8>") getData("/I21/WdBank1<7>") getData("/I21/WdBank1<6>") getData("/I21/WdBank1<5>") getData("/I21/WdBank1<4>") getData("/I21/WdBank1<3>") getData("/I21/WdBank1<2>") getData("/I21/WdBank1<1>") getData("/I21/WdBank1<0>") getData("/I21/Bank1WAck<7>") getData("/I21/Bank1WAck<6>") getData("/I21/Bank1WAck<5>") getData("/I21/Bank1WAck<4>") getData("/I21/Bank1WAck<3>") getData("/I21/Bank1WAck<2>") getData("/I21/Bank1WAck<1>") getData("/I21/Bank1WAck<0>") getData("/I21/WdBank2<31>") getData("/I21/WdBank2<30>") getData("/I21/WdBank2<29>") getData("/I21/WdBank2<28>") getData("/I21/WdBank2<27>") getData("/I21/WdBank2<26>") getData("/I21/WdBank2<25>") getData("/I21/WdBank2<24>") getData("/I21/WdBank2<23>") getData("/I21/WdBank2<22>") getData("/I21/WdBank2<21>") getData("/I21/WdBank2<20>") getData("/I21/WdBank2<19>") getData("/I21/WdBank2<18>") getData("/I21/WdBank2<17>") getData("/I21/WdBank2<16>") getData("/I21/WdBank2<15>") getData("/I21/WdBank2<14>") getData("/I21/WdBank2<13>") getData("/I21/WdBank2<12>") getData("/I21/WdBank2<11>") getData("/I21/WdBank2<10>") getData("/I21/WdBank2<9>") getData("/I21/WdBank2<8>") getData("/I21/WdBank2<7>") getData("/I21/WdBank2<6>") getData("/I21/WdBank2<5>") getData("/I21/WdBank2<4>") getData("/I21/WdBank2<3>") getData("/I21/WdBank2<2>") getData("/I21/WdBank2<1>") getData("/I21/WdBank2<0>") getData("/I21/Bank2WAck<7>") getData("/I21/Bank2WAck<6>") getData("/I21/Bank2WAck<5>") getData("/I21/Bank2WAck<4>") getData("/I21/Bank2WAck<3>") getData("/I21/Bank2WAck<2>") getData("/I21/Bank2WAck<1>") getData("/I21/Bank2WAck<0>") getData("/I21/WdBank3<31>") getData("/I21/WdBank3<30>") getData("/I21/WdBank3<29>") getData("/I21/WdBank3<28>") getData("/I21/WdBank3<27>") getData("/I21/WdBank3<26>") getData("/I21/WdBank3<25>") getData("/I21/WdBank3<24>") getData("/I21/WdBank3<23>") getData("/I21/WdBank3<22>") getData("/I21/WdBank3<21>") getData("/I21/WdBank3<20>") getData("/I21/WdBank3<19>") getData("/I21/WdBank3<18>") getData("/I21/WdBank3<17>") getData("/I21/WdBank3<16>") getData("/I21/WdBank3<15>") getData("/I21/WdBank3<14>") getData("/I21/WdBank3<13>") getData("/I21/WdBank3<12>") getData("/I21/WdBank3<11>") getData("/I21/WdBank3<10>") getData("/I21/WdBank3<9>") getData("/I21/WdBank3<8>") getData("/I21/WdBank3<7>") getData("/I21/WdBank3<6>") getData("/I21/WdBank3<5>") getData("/I21/WdBank3<4>") getData("/I21/WdBank3<3>") getData("/I21/WdBank3<2>") getData("/I21/WdBank3<1>") getData("/I21/WdBank3<0>") getData("/I21/Bank3WAck<7>") getData("/I21/Bank3WAck<6>") getData("/I21/Bank3WAck<5>") getData("/I21/Bank3WAck<4>") getData("/I21/Bank3WAck<3>") getData("/I21/Bank3WAck<2>") getData("/I21/Bank3WAck<1>") getData("/I21/Bank3WAck<0>") getData("/I21/RdBank0<31>") getData("/I21/RdBank0<30>") getData("/I21/RdBank0<29>") getData("/I21/RdBank0<28>") getData("/I21/RdBank0<27>") getData("/I21/RdBank0<26>") getData("/I21/RdBank0<25>") getData("/I21/RdBank0<24>") getData("/I21/RdBank0<23>") getData("/I21/RdBank0<22>") getData("/I21/RdBank0<21>") getData("/I21/RdBank0<20>") getData("/I21/RdBank0<19>") getData("/I21/RdBank0<18>") getData("/I21/RdBank0<17>") getData("/I21/RdBank0<16>") getData("/I21/RdBank0<15>") getData("/I21/RdBank0<14>") getData("/I21/RdBank0<13>") getData("/I21/RdBank0<12>") getData("/I21/RdBank0<11>") getData("/I21/RdBank0<10>") getData("/I21/RdBank0<9>") getData("/I21/RdBank0<8>") getData("/I21/RdBank0<7>") getData("/I21/RdBank0<6>") getData("/I21/RdBank0<5>") getData("/I21/RdBank0<4>") getData("/I21/RdBank0<3>") getData("/I21/RdBank0<2>") getData("/I21/RdBank0<1>") getData("/I21/RdBank0<0>") getData("/I21/RdBank0Ack<7>") getData("/I21/RdBank0Ack<6>") getData("/I21/RdBank0Ack<5>") getData("/I21/RdBank0Ack<4>") getData("/I21/RdBank0Ack<3>") getData("/I21/RdBank0Ack<2>") getData("/I21/RdBank0Ack<1>") getData("/I21/RdBank0Ack<0>") getData("/I21/RdBank1<31>") getData("/I21/RdBank1<30>") getData("/I21/RdBank1<29>") getData("/I21/RdBank1<28>") getData("/I21/RdBank1<27>") getData("/I21/RdBank1<26>") getData("/I21/RdBank1<25>") getData("/I21/RdBank1<24>") getData("/I21/RdBank1<23>") getData("/I21/RdBank1<22>") getData("/I21/RdBank1<21>") getData("/I21/RdBank1<20>") getData("/I21/RdBank1<19>") getData("/I21/RdBank1<18>") getData("/I21/RdBank1<17>") getData("/I21/RdBank1<16>") getData("/I21/RdBank1<15>") getData("/I21/RdBank1<14>") getData("/I21/RdBank1<13>") getData("/I21/RdBank1<12>") getData("/I21/RdBank1<11>") getData("/I21/RdBank1<10>") getData("/I21/RdBank1<9>") getData("/I21/RdBank1<8>") getData("/I21/RdBank1<7>") getData("/I21/RdBank1<6>") getData("/I21/RdBank1<5>") getData("/I21/RdBank1<4>") getData("/I21/RdBank1<3>") getData("/I21/RdBank1<2>") getData("/I21/RdBank1<1>") getData("/I21/RdBank1<0>") getData("/I21/RdBank1Ack<7>") getData("/I21/RdBank1Ack<6>") getData("/I21/RdBank1Ack<5>") getData("/I21/RdBank1Ack<4>") getData("/I21/RdBank1Ack<3>") getData("/I21/RdBank1Ack<2>") getData("/I21/RdBank1Ack<1>") getData("/I21/RdBank1Ack<0>") getData("/WDataAckT<15>") getData("/WDataAckT<14>") getData("/WDataAckT<13>") getData("/WDataAckT<12>") getData("/WDataAckT<11>") getData("/WDataAckT<10>") getData("/WDataAckT<9>") getData("/WDataAckT<8>") getData("/WDataT<31>") getData("/WDataT<30>") getData("/WDataT<29>") getData("/WDataT<28>") getData("/WDataT<27>") getData("/WDataT<26>") getData("/WDataT<25>") getData("/WDataT<24>") getData("/WDataT<23>") getData("/WDataT<22>") getData("/WDataT<21>") getData("/WDataT<20>") getData("/WDataT<19>") getData("/WDataT<18>") getData("/WDataT<17>") getData("/WDataT<16>") getData("/WDataT<15>") getData("/WDataT<14>") getData("/WDataT<13>") getData("/WDataT<12>") getData("/WDataT<11>") getData("/WDataT<10>") getData("/WDataT<9>") getData("/WDataT<8>") getData("/WDataT<7>") getData("/WDataT<6>") getData("/WDataT<5>") getData("/WDataT<4>") getData("/WDataT<3>") getData("/WDataT<2>") getData("/WDataT<1>") getData("/WDataT<0>") getData("/Data1<31:0>") getData("/WDataAck<15:0>") getData("/RData<31:0>") getData("/RDataT<31>") getData("/RDataT<30>") getData("/RDataT<29>") getData("/RDataT<28>") getData("/RDataT<27>") getData("/RDataT<26>") getData("/RDataT<25>") getData("/RDataT<24>") getData("/RDataT<23>") getData("/RDataT<22>") getData("/RDataT<21>") getData("/RDataT<20>") getData("/RDataT<19>") getData("/RDataT<18>") getData("/RDataT<17>") getData("/RDataT<16>") getData("/RDataT<15>") getData("/RDataT<14>") getData("/RDataT<13>") getData("/RDataT<12>") getData("/RDataT<11>") getData("/RDataT<10>") getData("/RDataT<9>") getData("/RDataT<8>") getData("/RDataT<7>") getData("/RDataT<6>") getData("/RDataT<5>") getData("/RDataT<4>") getData("/RDataT<3>") getData("/RDataT<2>") getData("/RDataT<1>") getData("/RDataT<0>") )
hostMode( 'local )
resultsDir( "/net/bull/apps/Cadence/simulation/6T_MultiBank_16K_Test/spectreVerilog/config" )
modelFile(
    '("/software/cadence/ncsu-FreePDK15/hspice_16nm_hp.include" "")
)
desVar(	  "vdd" .675	)
option(	'temp  "30.0"
)
temp( 30.0 )
run()
selectResult( 'tran )
plot(getData("/ReadEn") getData("/R_Address<11:0>") getData("/W_Address<11:0>") getData("/WriteEn") getData("/ReadAck") getData("/WriteAck") getData("/RAckT") getData("/WAckT") getData("/R_AddressT<11>") getData("/R_AddressT<10>") getData("/R_AddressT<9>") getData("/R_AddressT<8>") getData("/R_AddressT<7>") getData("/R_AddressT<6>") getData("/R_AddressT<5>") getData("/R_AddressT<4>") getData("/R_AddressT<3>") getData("/R_AddressT<2>") getData("/R_AddressT<1>") getData("/R_AddressT<0>") getData("/ReadEnT") getData("/W_AddressT<11>") getData("/W_AddressT<10>") getData("/W_AddressT<9>") getData("/W_AddressT<8>") getData("/W_AddressT<7>") getData("/W_AddressT<6>") getData("/W_AddressT<5>") getData("/W_AddressT<4>") getData("/W_AddressT<3>") getData("/W_AddressT<2>") getData("/W_AddressT<1>") getData("/W_AddressT<0>") getData("/WriteEnT") getData("/V0/MINUS") getData("/I21/WdBank0<31>") getData("/I21/WdBank0<30>") getData("/I21/WdBank0<29>") getData("/I21/WdBank0<28>") getData("/I21/WdBank0<27>") getData("/I21/WdBank0<26>") getData("/I21/WdBank0<25>") getData("/I21/WdBank0<24>") getData("/I21/WdBank0<23>") getData("/I21/WdBank0<22>") getData("/I21/WdBank0<21>") getData("/I21/WdBank0<20>") getData("/I21/WdBank0<19>") getData("/I21/WdBank0<18>") getData("/I21/WdBank0<17>") getData("/I21/WdBank0<16>") getData("/I21/WdBank0<15>") getData("/I21/WdBank0<14>") getData("/I21/WdBank0<13>") getData("/I21/WdBank0<12>") getData("/I21/WdBank0<11>") getData("/I21/WdBank0<10>") getData("/I21/WdBank0<9>") getData("/I21/WdBank0<8>") getData("/I21/WdBank0<7>") getData("/I21/WdBank0<6>") getData("/I21/WdBank0<5>") getData("/I21/WdBank0<4>") getData("/I21/WdBank0<3>") getData("/I21/WdBank0<2>") getData("/I21/WdBank0<1>") getData("/I21/WdBank0<0>") getData("/I21/Bank0WAck<7>") getData("/I21/Bank0WAck<6>") getData("/I21/Bank0WAck<5>") getData("/I21/Bank0WAck<4>") getData("/I21/Bank0WAck<3>") getData("/I21/Bank0WAck<2>") getData("/I21/Bank0WAck<1>") getData("/I21/Bank0WAck<0>") getData("/I21/WdBank1<31>") getData("/I21/WdBank1<30>") getData("/I21/WdBank1<29>") getData("/I21/WdBank1<28>") getData("/I21/WdBank1<27>") getData("/I21/WdBank1<26>") getData("/I21/WdBank1<25>") getData("/I21/WdBank1<24>") getData("/I21/WdBank1<23>") getData("/I21/WdBank1<22>") getData("/I21/WdBank1<21>") getData("/I21/WdBank1<20>") getData("/I21/WdBank1<19>") getData("/I21/WdBank1<18>") getData("/I21/WdBank1<17>") getData("/I21/WdBank1<16>") getData("/I21/WdBank1<15>") getData("/I21/WdBank1<14>") getData("/I21/WdBank1<13>") getData("/I21/WdBank1<12>") getData("/I21/WdBank1<11>") getData("/I21/WdBank1<10>") getData("/I21/WdBank1<9>") getData("/I21/WdBank1<8>") getData("/I21/WdBank1<7>") getData("/I21/WdBank1<6>") getData("/I21/WdBank1<5>") getData("/I21/WdBank1<4>") getData("/I21/WdBank1<3>") getData("/I21/WdBank1<2>") getData("/I21/WdBank1<1>") getData("/I21/WdBank1<0>") getData("/I21/Bank1WAck<7>") getData("/I21/Bank1WAck<6>") getData("/I21/Bank1WAck<5>") getData("/I21/Bank1WAck<4>") getData("/I21/Bank1WAck<3>") getData("/I21/Bank1WAck<2>") getData("/I21/Bank1WAck<1>") getData("/I21/Bank1WAck<0>") getData("/I21/WdBank2<31>") getData("/I21/WdBank2<30>") getData("/I21/WdBank2<29>") getData("/I21/WdBank2<28>") getData("/I21/WdBank2<27>") getData("/I21/WdBank2<26>") getData("/I21/WdBank2<25>") getData("/I21/WdBank2<24>") getData("/I21/WdBank2<23>") getData("/I21/WdBank2<22>") getData("/I21/WdBank2<21>") getData("/I21/WdBank2<20>") getData("/I21/WdBank2<19>") getData("/I21/WdBank2<18>") getData("/I21/WdBank2<17>") getData("/I21/WdBank2<16>") getData("/I21/WdBank2<15>") getData("/I21/WdBank2<14>") getData("/I21/WdBank2<13>") getData("/I21/WdBank2<12>") getData("/I21/WdBank2<11>") getData("/I21/WdBank2<10>") getData("/I21/WdBank2<9>") getData("/I21/WdBank2<8>") getData("/I21/WdBank2<7>") getData("/I21/WdBank2<6>") getData("/I21/WdBank2<5>") getData("/I21/WdBank2<4>") getData("/I21/WdBank2<3>") getData("/I21/WdBank2<2>") getData("/I21/WdBank2<1>") getData("/I21/WdBank2<0>") getData("/I21/Bank2WAck<7>") getData("/I21/Bank2WAck<6>") getData("/I21/Bank2WAck<5>") getData("/I21/Bank2WAck<4>") getData("/I21/Bank2WAck<3>") getData("/I21/Bank2WAck<2>") getData("/I21/Bank2WAck<1>") getData("/I21/Bank2WAck<0>") getData("/I21/WdBank3<31>") getData("/I21/WdBank3<30>") getData("/I21/WdBank3<29>") getData("/I21/WdBank3<28>") getData("/I21/WdBank3<27>") getData("/I21/WdBank3<26>") getData("/I21/WdBank3<25>") getData("/I21/WdBank3<24>") getData("/I21/WdBank3<23>") getData("/I21/WdBank3<22>") getData("/I21/WdBank3<21>") getData("/I21/WdBank3<20>") getData("/I21/WdBank3<19>") getData("/I21/WdBank3<18>") getData("/I21/WdBank3<17>") getData("/I21/WdBank3<16>") getData("/I21/WdBank3<15>") getData("/I21/WdBank3<14>") getData("/I21/WdBank3<13>") getData("/I21/WdBank3<12>") getData("/I21/WdBank3<11>") getData("/I21/WdBank3<10>") getData("/I21/WdBank3<9>") getData("/I21/WdBank3<8>") getData("/I21/WdBank3<7>") getData("/I21/WdBank3<6>") getData("/I21/WdBank3<5>") getData("/I21/WdBank3<4>") getData("/I21/WdBank3<3>") getData("/I21/WdBank3<2>") getData("/I21/WdBank3<1>") getData("/I21/WdBank3<0>") getData("/I21/Bank3WAck<7>") getData("/I21/Bank3WAck<6>") getData("/I21/Bank3WAck<5>") getData("/I21/Bank3WAck<4>") getData("/I21/Bank3WAck<3>") getData("/I21/Bank3WAck<2>") getData("/I21/Bank3WAck<1>") getData("/I21/Bank3WAck<0>") getData("/I21/RdBank0<31>") getData("/I21/RdBank0<30>") getData("/I21/RdBank0<29>") getData("/I21/RdBank0<28>") getData("/I21/RdBank0<27>") getData("/I21/RdBank0<26>") getData("/I21/RdBank0<25>") getData("/I21/RdBank0<24>") getData("/I21/RdBank0<23>") getData("/I21/RdBank0<22>") getData("/I21/RdBank0<21>") getData("/I21/RdBank0<20>") getData("/I21/RdBank0<19>") getData("/I21/RdBank0<18>") getData("/I21/RdBank0<17>") getData("/I21/RdBank0<16>") getData("/I21/RdBank0<15>") getData("/I21/RdBank0<14>") getData("/I21/RdBank0<13>") getData("/I21/RdBank0<12>") getData("/I21/RdBank0<11>") getData("/I21/RdBank0<10>") getData("/I21/RdBank0<9>") getData("/I21/RdBank0<8>") getData("/I21/RdBank0<7>") getData("/I21/RdBank0<6>") getData("/I21/RdBank0<5>") getData("/I21/RdBank0<4>") getData("/I21/RdBank0<3>") getData("/I21/RdBank0<2>") getData("/I21/RdBank0<1>") getData("/I21/RdBank0<0>") getData("/I21/RdBank0Ack<7>") getData("/I21/RdBank0Ack<6>") getData("/I21/RdBank0Ack<5>") getData("/I21/RdBank0Ack<4>") getData("/I21/RdBank0Ack<3>") getData("/I21/RdBank0Ack<2>") getData("/I21/RdBank0Ack<1>") getData("/I21/RdBank0Ack<0>") getData("/I21/RdBank1<31>") getData("/I21/RdBank1<30>") getData("/I21/RdBank1<29>") getData("/I21/RdBank1<28>") getData("/I21/RdBank1<27>") getData("/I21/RdBank1<26>") getData("/I21/RdBank1<25>") getData("/I21/RdBank1<24>") getData("/I21/RdBank1<23>") getData("/I21/RdBank1<22>") getData("/I21/RdBank1<21>") getData("/I21/RdBank1<20>") getData("/I21/RdBank1<19>") getData("/I21/RdBank1<18>") getData("/I21/RdBank1<17>") getData("/I21/RdBank1<16>") getData("/I21/RdBank1<15>") getData("/I21/RdBank1<14>") getData("/I21/RdBank1<13>") getData("/I21/RdBank1<12>") getData("/I21/RdBank1<11>") getData("/I21/RdBank1<10>") getData("/I21/RdBank1<9>") getData("/I21/RdBank1<8>") getData("/I21/RdBank1<7>") getData("/I21/RdBank1<6>") getData("/I21/RdBank1<5>") getData("/I21/RdBank1<4>") getData("/I21/RdBank1<3>") getData("/I21/RdBank1<2>") getData("/I21/RdBank1<1>") getData("/I21/RdBank1<0>") getData("/I21/RdBank1Ack<7>") getData("/I21/RdBank1Ack<6>") getData("/I21/RdBank1Ack<5>") getData("/I21/RdBank1Ack<4>") getData("/I21/RdBank1Ack<3>") getData("/I21/RdBank1Ack<2>") getData("/I21/RdBank1Ack<1>") getData("/I21/RdBank1Ack<0>") getData("/WDataAckT<15>") getData("/WDataAckT<14>") getData("/WDataAckT<13>") getData("/WDataAckT<12>") getData("/WDataAckT<11>") getData("/WDataAckT<10>") getData("/WDataAckT<9>") getData("/WDataAckT<8>") getData("/WDataT<31>") getData("/WDataT<30>") getData("/WDataT<29>") getData("/WDataT<28>") getData("/WDataT<27>") getData("/WDataT<26>") getData("/WDataT<25>") getData("/WDataT<24>") getData("/WDataT<23>") getData("/WDataT<22>") getData("/WDataT<21>") getData("/WDataT<20>") getData("/WDataT<19>") getData("/WDataT<18>") getData("/WDataT<17>") getData("/WDataT<16>") getData("/WDataT<15>") getData("/WDataT<14>") getData("/WDataT<13>") getData("/WDataT<12>") getData("/WDataT<11>") getData("/WDataT<10>") getData("/WDataT<9>") getData("/WDataT<8>") getData("/WDataT<7>") getData("/WDataT<6>") getData("/WDataT<5>") getData("/WDataT<4>") getData("/WDataT<3>") getData("/WDataT<2>") getData("/WDataT<1>") getData("/WDataT<0>") getData("/Data1<31:0>") getData("/WDataAck<15:0>") getData("/RData<31:0>") getData("/RDataT<31>") getData("/RDataT<30>") getData("/RDataT<29>") getData("/RDataT<28>") getData("/RDataT<27>") getData("/RDataT<26>") getData("/RDataT<25>") getData("/RDataT<24>") getData("/RDataT<23>") getData("/RDataT<22>") getData("/RDataT<21>") getData("/RDataT<20>") getData("/RDataT<19>") getData("/RDataT<18>") getData("/RDataT<17>") getData("/RDataT<16>") getData("/RDataT<15>") getData("/RDataT<14>") getData("/RDataT<13>") getData("/RDataT<12>") getData("/RDataT<11>") getData("/RDataT<10>") getData("/RDataT<9>") getData("/RDataT<8>") getData("/RDataT<7>") getData("/RDataT<6>") getData("/RDataT<5>") getData("/RDataT<4>") getData("/RDataT<3>") getData("/RDataT<2>") getData("/RDataT<1>") getData("/RDataT<0>") )
