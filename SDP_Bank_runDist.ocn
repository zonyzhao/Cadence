simulator( 'spectreVerilog )
hostMode( 'distributed )
design(	 "/net/kafka/nfs/rstdenis/Cadence/simulation/6T_SDP_BANK_Test/spectreVerilog/config/netlist/analog/netlist")
resultsDir( "/net/kafka/nfs/rstdenis/Cadence/simulation/6T_SDP_BANK_Test/spectreVerilog/config" )
modelFile(
    '("/software/cadence/ncsu-FreePDK15/hspice_16nm_hp.include" "")
)
analysis('tran ?stop "50n"  ?errpreset "conservative"  )
desVar(	  "vdd" .650	)
desVar(	  "vcc" "vdd"	)
envOption(
	'mspSetupNetlistSimPrecisionUnit  "ps"
	'mspSetupNetlistSimTimeUnit  "ps"
	'mspSetupNetlistSwitchRC  t
	'analysisOrder  list("tran")
)
option(	'multithread  "on"
	'temp  "30.0"
)
saveOption( ?simOutputFormat "psfxl" )
save( 'v "/vdd!" )
save( 'i "/V1/MINUS" "/IBank/Write_Ack" "/IBank/Read_Ack" "/V0/MINUS" "/V0/PLUS" "/V1/PLUS" )
converge( 'ic "/IBank/I0/I0/I0/I0/I7/I3/Q0" "0" )
converge( 'ic "/IBank/I0/I0/I0/I0/I7/I3/Q1" "vdd" )
converge( 'ic "/WriteDataT<0>" "0" )
converge( 'ic "/WriteDataT<1>" "0" )
converge( 'ic "/WriteDataT<2>" "0" )
converge( 'ic "/WriteDataT<3>" "0" )
converge( 'ic "/WriteDataT<4>" "0" )
converge( 'ic "/WriteDataT<5>" "0" )
converge( 'ic "/WriteDataT<6>" "0" )
converge( 'ic "/WriteDataT<7>" "0" )
converge( 'ic "/WriteDataT<8>" "0" )
converge( 'ic "/WriteDataT<9>" "0" )
converge( 'ic "/WriteDataT<10>" "0" )
converge( 'ic "/WriteDataT<11>" "0" )
converge( 'ic "/WriteDataT<12>" "0" )
converge( 'ic "/WriteDataT<13>" "0" )
converge( 'ic "/WriteDataT<14>" "0" )
converge( 'ic "/WriteDataT<15>" "0" )
converge( 'ic "/WriteDataT<16>" "0" )
converge( 'ic "/WriteDataT<17>" "0" )
converge( 'ic "/WriteDataT<18>" "0" )
converge( 'ic "/WriteDataT<19>" "0" )
converge( 'ic "/WriteDataT<20>" "0" )
converge( 'ic "/WriteDataT<21>" "0" )
converge( 'ic "/WriteDataT<22>" "0" )
converge( 'ic "/WriteDataT<23>" "0" )
converge( 'ic "/WriteDataT<24>" "0" )
converge( 'ic "/WriteDataT<25>" "0" )
converge( 'ic "/WriteDataT<26>" "0" )
converge( 'ic "/WriteDataT<27>" "0" )
converge( 'ic "/WriteDataT<28>" "0" )
converge( 'ic "/WriteDataT<29>" "0" )
converge( 'ic "/WriteDataT<30>" "0" )
converge( 'ic "/WriteDataT<31>" "0" )
converge( 'ic "/W_AddressT<0>" "0" )
converge( 'ic "/W_AddressT<1>" "0" )
converge( 'ic "/W_AddressT<2>" "0" )
converge( 'ic "/W_AddressT<3>" "0" )
converge( 'ic "/W_AddressT<4>" "0" )
converge( 'ic "/W_AddressT<5>" "0" )
converge( 'ic "/W_AddressT<6>" "0" )
converge( 'ic "/W_AddressT<7>" "0" )
converge( 'ic "/W_AddressT<8>" "0" )
converge( 'ic "/W_AddressT<9>" "0" )
converge( 'ic "/W_AddressT<10>" "0" )
converge( 'ic "/W_AddressT<11>" "0" )
converge( 'ic "/W_AddressT<12>" "0" )
converge( 'ic "/W_AddressT<13>" "0" )
converge( 'ic "/W_AddressT<14>" "0" )
converge( 'ic "/W_AddressT<15>" "0" )
converge( 'ic "/W_AddressT<16>" "0" )
converge( 'ic "/W_AddressT<17>" "0" )
converge( 'ic "/W_AddressT<18>" "0" )
converge( 'ic "/W_AddressT<19>" "0" )
converge( 'ic "/WRWT<0>" "0" )
converge( 'ic "/WRWT<1>" "0" )
converge( 'ic "/RRWT<0>" "0" )
converge( 'ic "/RRWT<1>" "0" )
converge( 'ic "/R_AddressT<0>" "0" )
converge( 'ic "/R_AddressT<1>" "0" )
converge( 'ic "/R_AddressT<2>" "0" )
converge( 'ic "/R_AddressT<3>" "0" )
converge( 'ic "/R_AddressT<4>" "0" )
converge( 'ic "/R_AddressT<5>" "0" )
converge( 'ic "/R_AddressT<6>" "0" )
converge( 'ic "/R_AddressT<7>" "0" )
converge( 'ic "/R_AddressT<8>" "0" )
converge( 'ic "/R_AddressT<9>" "0" )
converge( 'ic "/R_AddressT<10>" "0" )
converge( 'ic "/R_AddressT<11>" "0" )
converge( 'ic "/R_AddressT<12>" "0" )
converge( 'ic "/R_AddressT<13>" "0" )
converge( 'ic "/R_AddressT<14>" "0" )
converge( 'ic "/R_AddressT<15>" "0" )
converge( 'ic "/R_AddressT<16>" "0" )
converge( 'ic "/R_AddressT<17>" "0" )
converge( 'ic "/R_AddressT<18>" "0" )
converge( 'ic "/R_AddressT<19>" "0" )
converge( 'ic "/RD_AckT<0>" "0" )
converge( 'ic "/RD_AckT<1>" "0" )
converge( 'ic "/RD_AckT<2>" "0" )
converge( 'ic "/RD_AckT<3>" "0" )
converge( 'ic "/RD_AckT<4>" "0" )
converge( 'ic "/RD_AckT<5>" "0" )
converge( 'ic "/RD_AckT<6>" "0" )
converge( 'ic "/RD_AckT<7>" "0" )
converge( 'ic "/~RD_Ack<7:0>" "vdd" )
converge( 'ic "/WD_AckT<0>" "0" )
converge( 'ic "/WD_AckT<1>" "0" )
converge( 'ic "/WD_AckT<2>" "0" )
converge( 'ic "/WD_AckT<3>" "0" )
converge( 'ic "/WD_AckT<4>" "0" )
converge( 'ic "/WD_AckT<5>" "0" )
converge( 'ic "/WD_AckT<6>" "0" )
converge( 'ic "/WD_AckT<7>" "0" )
converge( 'ic "/IBank/Ap<16>" "0" )
converge( 'ic "/IBank/Ap<17>" "0" )
converge( 'ic "/IBank/Ap<18>" "0" )
converge( 'ic "/IBank/Ap<19>" "0" )
converge( 'ic "/IBank/I1/I1/amid<0>" "0" )
converge( 'ic "/IBank/I1/I1/amid<1>" "0" )
converge( 'ic "/IBank/I1/I1/amid<2>" "0" )
converge( 'ic "/IBank/I1/I1/amid<3>" "0" )
converge( 'ic "/IBank/I1/I1/bmid<0>" "0" )
converge( 'ic "/IBank/I1/I1/bmid<1>" "0" )
converge( 'ic "/IBank/I1/I1/bmid<3>" "0" )
converge( 'ic "/IBank/I1/I1/bmid<2>" "0" )
converge( 'ic "/IBank/I1/I1/Vpass<3>" "0" )
converge( 'ic "/IBank/I1/I1/Vpass<2>" "0" )
converge( 'ic "/IBank/I1/I1/Vpass<1>" "0" )
converge( 'ic "/IBank/I1/I1/Vpass<0>" "0" )
converge( 'ic "/IBank/I1/I3/net26" "0" )
converge( 'ic "/IBank/I1/I3/net28" "0" )
converge( 'ic "/IBank/I1/I3/net29" "0" )
converge( 'ic "/IBank/I1/I3/net31" "0" )
converge( 'ic "/IBank/WRWp<0>" "0" )
converge( 'ic "/IBank/WRWp<1>" "0" )
converge( 'ic "/IBank/Ap<0>" "0" )
converge( 'ic "/IBank/Ap<1>" "0" )
converge( 'ic "/IBank/Ap<2>" "0" )
converge( 'ic "/IBank/Ap<3>" "0" )
converge( 'ic "/IBank/Ap<4>" "0" )
converge( 'ic "/IBank/Ap<5>" "0" )
converge( 'ic "/IBank/Ap<6>" "0" )
converge( 'ic "/IBank/Ap<7>" "0" )
converge( 'ic "/IBank/Ap<8>" "0" )
converge( 'ic "/IBank/Ap<9>" "0" )
converge( 'ic "/IBank/Ap<10>" "0" )
converge( 'ic "/IBank/Ap<11>" "0" )
converge( 'ic "/IBank/Ap<12>" "0" )
converge( 'ic "/IBank/Ap<13>" "0" )
converge( 'ic "/IBank/Ap<14>" "0" )
converge( 'ic "/IBank/Ap<15>" "0" )
temp( 30.0 )
;;;;;;;;;;;;;;;;;;;;;;;;;;;;;;;;;;;;;;;;;;;;;;;;;;;;;;;;;;
;hList = 	list( "adder" "asp" "blind" "boa" "boom" "brown" \
;		      "cobra"  "copper" "coral" "corn" "crowned" \
;		      "deathadder" "fierce" "garter" "gopher" 	 \
;		      "hognose" "indigo" "krait" "mamba" "milk"  \
;		      "python" "queen" "racer" "rainbow" "rat" 	 \
;		      "rattle" "redbelly" "ribbon" "scarlet" 	 \
;		      "swamp" "timber" "viper" )

hList = list( "asp" "boa" "boom" "brown" "cobra"  "copper" "coral" "corn" "crowned" "deathadder" "fierce" "garter" "gopher" "hognose" "indigo" "krait" "mamba" "milk" "python" "queen" "racer" "rainbow" "rat" "rattle" "redbelly" "ribbon" "scarlet" "swamp" "timber" "viper" )

vLoad = list(  .250 .325 0.45 .475 .50 .525 .675 .85 1.0 1.125 )
tLoad = list( 30 60 90 )

jobList 	= nil
mVs   		= nil
temps   	= nil
j=1
foreach( degC  tLoad
    foreach( val  vLoad
	desVar( "vdd" val )
	temp(degC)

	volt    = round( evalstring( desVar( "vdd" )) * 1000 )
	mVs     = append1( mVs sprintf( nil "%d" volt ))
	temps   = append1( temps sprintf(nil "%d" degC ))

;;;;;;;;;;;;;;;;;;;;;;;;;;;;;;;;;;;;;;;;;;;;;;;;;;;;;;;;;;;;;;;;;;;;;;;;;;;;;;;;;;;;;
jobName = strcat("SDPBank_"  sprintf( nil "%d" volt ) "mV_" sprintf( nil "%d" degC) "C" )
jobList = append1( jobList run( ?jobName jobName ?queue "c2107" ?host nthelem(j hList) ) )
;;;;;;;;;;;;;;;;;;;;;;;;;;;;;;;;;;;;;;;;;;;;;;;;;;;;;;;;;;;;;;;;;;;;;;;;;;;;;;;;;;;;;

	j = j + 1
    )
)
printf("Completed.")
