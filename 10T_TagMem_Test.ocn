simulator( 'spectreVerilog )
hostMode( 'distributed )
design(	 "/net/kafka/nfs/rstdenis/Cadence/simulation/10T_TagMem_Test/spectreVerilog/config/netlist/analog/netlist")
resultsDir( "/net/kafka/nfs/rstdenis/Cadence/simulation/10T_TagMem_Test/spectreVerilog/config" )
modelFile(
    '("/software/cadence/ncsu-FreePDK15/hspice_16nm_hp.include" "")
)
analysis('tran ?stop "5n"  ?errpreset "conservative"  )
desVar(	  "vdd" .850	)
desVar(	  "vcc" "vdd"	)
envOption(
	'mspSetupNetlistSimPrecisionUnit  "ps"
	'mspSetupNetlistSimTimeUnit  "ps"
	'mspSetupNetlistSwitchRC  t
	'userCmdLineOption  "+multithread"
	'analysisOrder  list("tran")
)
option(	'temp  "85.0"
)
saveOption( ?simOutputFormat "psfxl" )
save( 'i "/V0/MINUS" "/V1/MINUS" )
converge( 'ic "/R_AddrT<0>" "0" )
converge( 'ic "/R_AddrT<1>" "0" )
converge( 'ic "/R_AddrT<2>" "0" )
converge( 'ic "/R_AddrT<3>" "0" )
converge( 'ic "/R_AddrT<4>" "0" )
converge( 'ic "/R_AddrT<5>" "0" )
converge( 'ic "/R_AddrT<6>" "0" )
converge( 'ic "/GoRT" "0" )
converge( 'ic "/W_AddrT<0>" "0" )
converge( 'ic "/W_AddrT<1>" "0" )
converge( 'ic "/W_AddrT<2>" "0" )
converge( 'ic "/W_AddrT<3>" "0" )
converge( 'ic "/W_AddrT<4>" "0" )
converge( 'ic "/W_AddrT<5>" "0" )
converge( 'ic "/W_AddrT<6>" "0" )
converge( 'ic "/GoWT" "0" )
converge( 'ic "/W0T<0>" "0" )
converge( 'ic "/W0T<1>" "0" )
converge( 'ic "/W0T<2>" "0" )
converge( 'ic "/W0T<3>" "0" )
converge( 'ic "/W0T<4>" "0" )
converge( 'ic "/W0T<5>" "0" )
converge( 'ic "/W0T<6>" "0" )
converge( 'ic "/W0T<7>" "0" )
converge( 'ic "/W0T<8>" "0" )
converge( 'ic "/W0T<9>" "0" )
converge( 'ic "/W0T<10>" "0" )
converge( 'ic "/W0T<11>" "0" )
converge( 'ic "/W0T<12>" "0" )
converge( 'ic "/W0T<13>" "0" )
converge( 'ic "/W0T<14>" "0" )
converge( 'ic "/W0T<15>" "0" )
converge( 'ic "/W0T<16>" "0" )
converge( 'ic "/W0T<17>" "0" )
converge( 'ic "/W0T<18>" "0" )
converge( 'ic "/W0T<19>" "0" )
converge( 'ic "/W0T<20>" "0" )
converge( 'ic "/W0T<21>" "0" )
converge( 'ic "/W0T<22>" "0" )
converge( 'ic "/W0T<23>" "0" )
converge( 'ic "/W0T<24>" "0" )
converge( 'ic "/W0T<25>" "0" )
converge( 'ic "/W0T<26>" "0" )
converge( 'ic "/W0T<27>" "0" )
converge( 'ic "/W0T<28>" "0" )
converge( 'ic "/W0T<29>" "0" )
converge( 'ic "/W0T<30>" "0" )
converge( 'ic "/W0T<31>" "0" )
converge( 'ic "/W1T<0>" "0" )
converge( 'ic "/W1T<1>" "0" )
converge( 'ic "/W1T<2>" "0" )
converge( 'ic "/W1T<3>" "0" )
converge( 'ic "/W1T<4>" "0" )
converge( 'ic "/W1T<5>" "0" )
converge( 'ic "/W1T<6>" "0" )
converge( 'ic "/W1T<7>" "0" )
converge( 'ic "/W1T<8>" "0" )
converge( 'ic "/W1T<9>" "0" )
converge( 'ic "/W1T<10>" "0" )
converge( 'ic "/W1T<11>" "0" )
converge( 'ic "/W1T<12>" "0" )
converge( 'ic "/W1T<13>" "0" )
converge( 'ic "/W1T<14>" "0" )
converge( 'ic "/W1T<15>" "0" )
converge( 'ic "/W1T<16>" "0" )
converge( 'ic "/W1T<17>" "0" )
converge( 'ic "/W1T<18>" "0" )
converge( 'ic "/W1T<19>" "0" )
converge( 'ic "/W1T<20>" "0" )
converge( 'ic "/W1T<21>" "0" )
converge( 'ic "/W1T<22>" "0" )
converge( 'ic "/W1T<23>" "0" )
converge( 'ic "/W1T<24>" "0" )
converge( 'ic "/W1T<25>" "0" )
converge( 'ic "/W1T<26>" "0" )
converge( 'ic "/W1T<27>" "0" )
converge( 'ic "/W1T<28>" "0" )
converge( 'ic "/W1T<29>" "0" )
converge( 'ic "/W1T<30>" "0" )
converge( 'ic "/W1T<31>" "0" )
converge( 'ic "/ResetT" "0" )
converge( 'ic "/I36/I0/I1/I7/I3/Qb" "0" )
converge( 'ic "/I36/I2/I1/I7/I3/Qb" "0" )
converge( 'ic "/I36/I6/I1/I7/I3/Qb" "0" )
converge( 'ic "/I36/I6/I1/I7/I3/Q" "vdd" )
converge( 'ic "/I36/I2/I1/I7/I3/Q" "vdd" )
converge( 'ic "/I36/I0/I1/I7/I3/Q" "vdd" )
temp( 30.0 )

;;;;;;;;;;;;;;;;;;;;;;;;;;;;;;;;;;;;;;;;;;;;;;;;;;;;;;;;;;
;hList = 	list( "adder" "asp" "blind" "boa" "boom" "brown" \
;		      "cobra"  "copper" "coral" "corn" "crowned" \
;		      "deathadder" "fierce" "garter" "gopher" 	 \
;		      "hognose" "indigo" "krait" "mamba" "milk"  \
;		      "python" "queen" "racer" "rainbow" "rat" 	 \
;		      "rattle" "redbelly" "ribbon" "scarlet" 	 \
;		      "swamp" "timber" "viper" )

hList = list( "asp"  "boa" "boom" "brown" "cobra"  "copper" "coral" "corn" "crowned" "deathadder" "fierce" "garter" "gopher" "hognose" "indigo" "krait" "mamba" "milk" "python" "queen" "racer"  "rat" "rattle" "redbelly" "scarlet" "timber" "viper" )

vLoad = list( .35 .4 .45 .50 .55 .65 .85 1.0 1.25 )
tLoad = list( 30 60 90 )

jobList 	= nil
mVs   		= nil
temps   	= nil
j=1
foreach( degC  tLoad
    foreach( val  vLoad
	desVar( "vdd" val )
	temp(degC)

	volt    = round( evalstring( desVar( "vdd" )) * 1000 )
	mVs     = append1( mVs sprintf( nil "%d" volt ))
	temps   = append1( temps sprintf(nil "%d" degC ))

	;;jobName = strcat("/net/kafka/nfs/rstdenis/Cadence/simulation/10T_TagMem_Test/spectreVerilog/config/distributed/TagMem_" sprintf( nil "%d" volt ) "mV_" sprintf( nil "%d" degC) "C/psf" )
	;;jobList = append1( jobList jobName )

;;;;;;;;;;;;;;;;;;;;;;;;;;;;;;;;;;;;;;;;;;;;;;;;;;;;;;;;;;;;;;;;;;;;;;;;;;;;;;;;;;;;;;;;;;;;;;;;;;;;
jobName = strcat("TagMem_"  sprintf( nil "%d" volt ) "mV_" sprintf( nil "%d" degC) "C" )
jobList = append1( jobList run( ?jobName jobName ?queue "c2107" ?host nthelem(j hList) ) )
;;;;;;;;;;;;;;;;;;;;;;;;;;;;;;;;;;;;;;;;;;;;;;;;;;;;;;;;;;;;;;;;;;;;;;;;;;;;;;;;;;;;;;;;;;;;;;;;;;;;

	j = j + 1
    )
)

wait( ( append1 jobList nil  ) )

;;;;;;;;;;;;;;;;;;;;;;;;;;;;;;;;;;;;;;;;;;;;;;;;;;;;;;;;;;;;;;;;;;;;;;;;;;;;;;;;;;;;;
;file      =  strcat( "/root/Desktop/Cadence/simData/CacheData/TagData.csv"  )
;outF      =   outfile(file,    "w")
;fprintf( outF,   "Vdd [mv], Temp [C], Leakage [mA], peak Current [mA], rDelay, rEnergy, rNull, rnullEnergy, wDelay Wenergy Wnull WnullEnergy\n" )
;close( outF)
;;;;;;;;;;;;;;;;;;;;;;;;;;;;;;;;;;;;;;;;;;;;;;;;;;;;;;;;;;;;;;;;;;;;;;;;;;;;;;;;;;;;;

;j = 1
;foreach(job jobList
;    	printf("%s\n" job )
;    	unless( (openResults( job ) == nil) || (evalstring(nthelem(j mVs)) >= 1500)
;    	selectResult( 'tran )
;    	unless( i("/V1/MINUS")  == nil
;	Volts       = evalstring( nthelem(j mVs) )*0.001;
;        leakage     = average( clip( i( "/V1/MINUS" ) 500p 800p ) ) *1e3
;        leakagePwr  = leakage*Volts
;	peakCurrent = ymax( i( "/V1/MINUS" ))*1e3
;	peakPwr     = peakCurrent*Volts

;	cHost       = sprintf(nil "%s" nthelem(j hList))
;        nameR       = strcat( "/root/Desktop/Cadence/simData/CacheData/logs/tagRLog_" nthelem(j mVs) "mV_" nthelem(j temps) "C.log" )
;        nameW       = strcat( "/root/Desktop/Cadence/simData/CacheData/logs/tagWLog_" nthelem(j mVs) "mV_" nthelem(j temps) "C.log" )
;	shellCmd1   = strcat("scp " cHost ":/tmp2/tagRLog.csv " nameR  )
;	shellCmd2   = strcat("scp " cHost ":/tmp2/tagRLog.csv " nameW  )
;	shell( shellCmd1 )
;	shell( shellCmd2 )

;        printf("Reading %s\n" nameR)
;        fidR   = infile( nameR )
;	gets( s fidR )
;	gets( s fidR )
;	gets( s fidR )
;	gets( s fidR )
;        fscanf( fidR "%s %s %s %s %s" rAddr  rData1 rData0 rEnd     rDelay )
;        fscanf( fidR "%s %s %s %s %s" rAddr  rData1 rData0 rEndNull rNull )
;        close( fidR )

;        printf("Reading %s\n" nameW)
;        fidW   = infile( nameW )
;	gets( s fidW )
;	gets( s fidW )
;	gets( s fidW )
;        fscanf( fidW "%s %s %s %s %s" wAddr  wData1 wData0 wEnd     wDelay )
;        fscanf( fidW "%s %s %s %s %s" wAddr  wData1 wData0 wEndNull wNull  )
;        close(fidW)
;	unless( (rEnd == nil) || (rEndNull == nil) || (wEnd == nil) || (wEndNull == nil)
;	    rStart      = evalstring( strcat(rEnd "p")) - evalstring( strcat(rDelay "p"))
;            rEnd        = evalstring( strcat(rEnd "p"))
;            rEndNull    = evalstring( strcat(rEndNull "p"))
; 	    rEnergy     = integ( i("/V1/MINUS")  rStart rEnd    )*1e12*Volts
;	    rnullEnergy = integ( i("/V1/MINUS")  rEnd   rEndNull)*1e12*Volts

;            wStart      = evalstring( strcat(wEnd "p") ) - evalstring( strcat(wDelay "p"))
;            wEnd        = evalstring( strcat(wEnd "p") )
;            wEndNull    = evalstring( strcat(wEndNull "p") )
;	    wEnergy     = integ( i("/V1/MINUS") wStart wEnd    )*1e12*Volts
;	    wnullEnergy = integ( i("/V1/MINUS") wEnd   wEndNull)*1e12*Volts

;	    outF      =   outfile(file,    "a")
;            fprintf( outF "%s,\t%s,\t%g,\t%g,\t%s,\t%g,\t%s,\t%g,\t%s,\t%g,\t%s,\t%g\n" nthelem(j mVs) nthelem(j temps) leakage peakCurrent rDelay rEnergy rNull rnullEnergy wDelay wEnergy wNull wnullEnergy)
;            close( outF )
;        )
;      )
;    )
;;;;;;;;;;;;;;;;;;;;;;;;;;;;;;;;;;;;;;;;;;;;;;;;;;;;;;;;;;;;;;;;;;;;;;;;;;;;;;;;;;;;;;;;;;;;;;;;;;;;;;;;;;;;;;

;    j     = j + 1
;)
;;;;;;;;;;;;;;;;;;;;;;;;;;;;;;;;;;;;;;;;;;;;;;;;;;;;;;;;;;;;;;;;;;;;;;;;;;;;;;;;;;;;;;;;;;;;;;;;;;;;;;;;;;;;;;
printf("Completed.")

;foreach( job jobList deleteJob( job ) )

;;;;;;;;;;;;;;;;;;;;;;;;;;;;;;;;;;;;;;;;;;;;;;;;;;;;;;;;;;;;;;;;;;;;;;;;;;;;;;;;;;;;;;;;;;;;;;;;;;;;;;;;;;;;;;
;;;;;;;;;;;;;;;;;;;;;;;;;;;;;;;;;;;;;;;;;;;;;;;;;;;;;;;;;;;;;;;;;;;;;;;;;;;;;;;;;;;;;;;;;;;;;;;;;;;;;;;;;;;;;;
