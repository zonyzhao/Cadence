ADE simulation setup
Run mode: Monte Carlo Sampling
Tests:
  16nm_Tests:MC_6TWrite_Test:1: 16nm_Tests/MC_6TWrite_Test/ams_config, simulator ams
    Outputs: M1; M0; M2; M3; M4; M5; cross(VT("/ICHUNK/IARRAY0/B0P1") vdd 1 "either" nil nil); cross(v("/ICHUNK/IARRAY0/ISRAM0/I7/I3/Q1") (0.95 * vdd) 1 "rising" nil nil); passfail; BL0; Mcontrol
Global variables:
  time2 = 2n
  time3 = 2.22n
  time4 = 2.85n
  time5 = 3n
  vdd = .500
Monte Carlo Sampling options: mcmethod=all, mcnumpoints=1000
