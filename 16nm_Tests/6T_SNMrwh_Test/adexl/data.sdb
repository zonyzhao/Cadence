ADE simulation setup
Run mode: Monte Carlo Sampling
Tests:
  16nm_Tests:6T_SNMrwh_Test:1: 16nm_Tests/6T_SNMrwh_Test/schematic, simulator spectre
Global variables:
  timeB = 200n
  timeA = 100n
  vdd = 500m
Monte Carlo Sampling options: mcmethod=mismatch, mcnumpoints=200
