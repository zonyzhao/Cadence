ADE simulation setup
Run mode: Monte Carlo Sampling
Tests:
  16nm_Tests:6T_BANK_Test:1: 16nm_Tests/6T_BANK_Test/config, simulator spectreVerilog
Global variables:
  vcc = .850
  vdd = .850
Monte Carlo Sampling options: mcmethod=all, mcnumpoints=1000
