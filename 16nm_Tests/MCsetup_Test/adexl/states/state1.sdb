ADE simulation setup
Global variables:
  time2 = 5n
  vdd = .500
