ADE simulation setup
Global variables:
  time2 = 5n
  vdd = .500
Device parameters:
  16nm/inv_1x/schematic/M0.dvtshift = ndvtshift
  16nm/inv_1x/schematic/M1.dvtshift = pdvtshift
