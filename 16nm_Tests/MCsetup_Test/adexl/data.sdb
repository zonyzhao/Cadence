ADE simulation setup
Run mode: Monte Carlo Sampling
Tests:
  16nm_Tests:MCsetup_Test:1: 16nm_Tests/MCsetup_Test/schematic, simulator spectre
Global variables:
  time2 = 5n
  vdd = .500
  ndvtshift = 0
  pdvtshift = 0
Monte Carlo Sampling options: mcmethod=mismatch, mcnumpoints=200
