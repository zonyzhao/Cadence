ADE simulation setup
Run mode: Monte Carlo Sampling
Tests:
  16nm_Tests:MCsetup_Test:1 (off): 16nm_Tests/MCsetup_Test/schematic, simulator spectre
    Outputs: OPT("I0.M1.mpfet" "vth" ?result "tranOp")
Global variables:
  time2 = 5n
  vdd = .500
  ndvtshift = 0
  pdvtshift = 0
Monte Carlo Sampling options: mcmethod=global, mcnumpoints=10
