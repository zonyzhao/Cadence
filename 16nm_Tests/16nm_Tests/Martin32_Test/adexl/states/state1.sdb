ADE simulation setup
Run mode: Single Run, Sweeps and Corners
Tests:
  16nm_Tests:Martin32_Test:1: 16nm_Tests/Martin32_Test/config, simulator spectreVerilog
Global variables:
  vcc = 0.7
  vdd = 0.7
